* ring_core: magic R+C extraction of layout/ring_core.gds (layout/gen/pex.sh)
* rcfix.py: split-net C to VSS scaled by (S - K) / S on 19 nets (coupling double count removed)
* extracted 2026-11-12T17:48:51+01:00 with magic 8.3.642, mode rc, from ring_core_v3.gds
.subckt ring_core VDD VSS vbn vctrl bit0 bit1 bit2 bit3 bit4 bitb0 bitb1 bitb2 bitb3 bitb4 vg a0 a1 a2 a3 a4
X0 a_6356_6633# bitb0.t0 VSS.t29 VSS.t28 nfet_03v3 ad=0.45p pd=2.9u as=0.45p ps=2.9u w=1u l=0.28u
X1 vg.t20 a_6206_896# VSS.t15 VSS.t14 nfet_03v3 ad=0.336p pd=1.76u as=0.336p ps=1.76u w=1.2u l=5.335u
X2 vg.t35 a_6206_14# VSS.t48 VSS.t14 nfet_03v3 ad=0.336p pd=1.76u as=0.336p ps=1.76u w=1.2u l=5.335u
X3 VDD.t11 vg.t45 VDD.t11 VDD.t10 pfet_03v3 ad=8.3496p pd=30.38u as=0 ps=0 w=29.82u l=4.12u
X4 a3.t1 a2.t3 VDD.t20 VDD.t19 pfet_03v3 ad=2.25p pd=10.9u as=2.25p ps=10.9u w=5u l=0.28u
X5 vbn.t7 bit2.t0 a_6206_4704# VSS.t62 nfet_03v3 ad=0.9p pd=4.9u as=0.9p ps=4.9u w=2u l=0.28u
X6 VDD.t7 vg.t47 VDD.t7 VDD.t6 pfet_03v3 ad=8.3496p pd=30.38u as=0 ps=0 w=29.82u l=4.12u
X7 a4.t1 a3.t3 VDD.t3 VDD.t2 pfet_03v3 ad=2.25p pd=10.9u as=2.25p ps=10.9u w=5u l=0.28u
X8 a_6206_14# bitb4.t0 VSS.t40 VSS.t39 nfet_03v3 ad=0.45p pd=2.9u as=0.45p ps=2.9u w=1u l=0.28u
X9 VSS.t34 vbn.t12 vg.t10 VSS.t22 nfet_03v3 ad=0.336p pd=1.76u as=0.336p ps=1.76u w=1.2u l=5.335u
X10 vg.t25 a4.t2 a0.t1 VSS.t1 nfet_03v3 ad=0.9p pd=4.9u as=0.9p ps=4.9u w=2u l=0.28u
X11 vbn.t9 bit0.t0 a_6356_6633# VSS.t64 nfet_03v3 ad=0.9p pd=4.9u as=0.9p ps=4.9u w=2u l=0.28u
X12 VSS.t53 a_6206_14# vg.t27 VSS.t22 nfet_03v3 ad=0.336p pd=1.76u as=0.336p ps=1.76u w=1.2u l=5.335u
X13 vbn.t1 bitb3.t1 a_6206_896# VDD.t26 pfet_03v3 ad=2.25p pd=10.9u as=2.25p ps=10.9u w=5u l=0.28u
X14 VSS.t49 a_6206_14# vg.t32 VSS.t22 nfet_03v3 ad=0.336p pd=1.76u as=0.336p ps=1.76u w=1.2u l=5.335u
X15 VSS.t10 vctrl.t0 vg.t8 VSS.t4 nfet_03v3 ad=0.54p pd=3.3u as=0.336p ps=1.76u w=1.2u l=21.335u
X16 a2.t1 a1.t2 vg.t3 VSS.t59 nfet_03v3 ad=0.9p pd=4.9u as=0.9p ps=4.9u w=2u l=0.28u
X17 VSS.t32 vbn.t14 vg.t9 VSS.t22 nfet_03v3 ad=0.336p pd=1.76u as=0.336p ps=1.76u w=1.2u l=5.335u
X18 VSS.t43 a_6206_14# vg.t40 VSS.t22 nfet_03v3 ad=0.336p pd=1.76u as=0.336p ps=1.76u w=1.2u l=5.335u
X19 vbn.t3 bitb2.t1 a_6206_4704# VDD.t16 pfet_03v3 ad=2.25p pd=10.9u as=2.25p ps=10.9u w=5u l=0.28u
X20 vbn.t6 bit4.t0 a_6206_14# VSS.t41 nfet_03v3 ad=0.9p pd=4.9u as=0.9p ps=4.9u w=2u l=0.28u
X21 a_7096_6633# bitb1.t0 VSS.t27 VSS.t26 nfet_03v3 ad=0.45p pd=2.9u as=0.45p ps=2.9u w=1u l=0.28u
X22 VSS.t20 a_6206_896# vg.t16 VSS.t8 nfet_03v3 ad=0.54p pd=3.3u as=0.336p ps=1.76u w=1.2u l=5.335u
X23 vg.t33 a_6206_14# VSS.t58 VSS.t14 nfet_03v3 ad=0.336p pd=1.76u as=0.336p ps=1.76u w=1.2u l=5.335u
X24 vg.t4 a_6206_4704# VSS.t7 VSS.t6 nfet_03v3 ad=0.336p pd=1.76u as=0.336p ps=1.76u w=1.2u l=5.335u
X25 VDD.t1 a4.t3 a0.t0 VDD.t0 pfet_03v3 ad=2.25p pd=10.9u as=2.25p ps=10.9u w=5u l=0.28u
X26 vbn.t2 bitb0.t1 a_6356_6633# VDD.t18 pfet_03v3 ad=2.25p pd=10.9u as=2.25p ps=10.9u w=5u l=0.28u
X27 VDD.t5 vg.t48 VDD.t5 VDD.t4 pfet_03v3 ad=13.419p pd=60.54u as=0 ps=0 w=29.82u l=4.12u
X28 vg.t17 a_6206_896# VSS.t18 VSS.t6 nfet_03v3 ad=0.336p pd=1.76u as=0.336p ps=1.76u w=1.2u l=5.335u
X29 VSS.t50 a_6206_14# vg.t39 VSS.t8 nfet_03v3 ad=0.54p pd=3.3u as=0.336p ps=1.76u w=1.2u l=5.335u
X30 vg.t14 a_7096_6633# VSS.t13 VSS.t6 nfet_03v3 ad=0.336p pd=1.76u as=0.336p ps=1.76u w=1.2u l=5.335u
X31 VSS.t55 a_6206_14# vg.t30 VSS.t8 nfet_03v3 ad=0.54p pd=3.3u as=0.336p ps=1.76u w=1.2u l=5.335u
X32 VSS.t36 vbn.t10 vg.t12 VSS.t4 nfet_03v3 ad=0.336p pd=1.76u as=0.336p ps=1.76u w=1.2u l=5.335u
X33 a_6206_4704# bitb2.t0 VSS.t25 VSS.t24 nfet_03v3 ad=0.45p pd=2.9u as=0.45p ps=2.9u w=1u l=0.28u
X34 VSS.t9 a_6206_4704# vg.t5 VSS.t8 nfet_03v3 ad=0.54p pd=3.3u as=0.336p ps=1.76u w=1.2u l=5.335u
X35 VSS.t16 a_6206_896# vg.t21 VSS.t8 nfet_03v3 ad=0.54p pd=3.3u as=0.336p ps=1.76u w=1.2u l=5.335u
X36 a2.t0 a1.t3 VDD.t25 VDD.t24 pfet_03v3 ad=2.25p pd=10.9u as=2.25p ps=10.9u w=5u l=0.28u
X37 VDD.t13 vg.t44 VDD.t13 VDD.t12 pfet_03v3 ad=8.3496p pd=30.38u as=0 ps=0 w=29.82u l=4.12u
X38 VSS.t45 a_6206_14# vg.t29 VSS.t8 nfet_03v3 ad=0.54p pd=3.3u as=0.336p ps=1.76u w=1.2u l=5.335u
X39 vg.t28 a_6206_14# VSS.t47 VSS.t6 nfet_03v3 ad=0.336p pd=1.76u as=0.336p ps=1.76u w=1.2u l=5.335u
X40 vg.t26 a_6206_14# VSS.t57 VSS.t6 nfet_03v3 ad=0.336p pd=1.76u as=0.336p ps=1.76u w=1.2u l=5.335u
X41 vbn.t8 bit1.t0 a_7096_6633# VSS.t63 nfet_03v3 ad=0.9p pd=4.9u as=0.9p ps=4.9u w=2u l=0.28u
X42 vg.t1 vbn.t15 VSS.t31 VSS.t6 nfet_03v3 ad=0.336p pd=1.76u as=0.336p ps=1.76u w=1.2u l=5.335u
X43 vg.t23 a_6356_6633# VSS.t38 VSS.t37 nfet_03v3 ad=0.336p pd=1.76u as=0.54p ps=3.3u w=1.2u l=5.335u
X44 vg.t31 a_6206_14# VSS.t51 VSS.t2 nfet_03v3 ad=0.336p pd=1.76u as=0.54p ps=3.3u w=1.2u l=5.335u
X45 vbn.t4 bitb4.t1 a_6206_14# VDD.t21 pfet_03v3 ad=2.25p pd=10.9u as=2.25p ps=10.9u w=5u l=0.28u
X46 a1.t1 a0.t2 vg.t24 VSS.t42 nfet_03v3 ad=0.9p pd=4.9u as=0.9p ps=4.9u w=2u l=0.28u
X47 VDD.t9 vg.t46 VDD.t9 VDD.t8 pfet_03v3 ad=8.3496p pd=30.38u as=0 ps=0 w=29.82u l=4.12u
X48 a_6206_896# bitb3.t0 VSS.t61 VSS.t60 nfet_03v3 ad=0.45p pd=2.9u as=0.45p ps=2.9u w=1u l=0.28u
X49 vg.t19 a_6206_896# VSS.t17 VSS.t2 nfet_03v3 ad=0.336p pd=1.76u as=0.54p ps=3.3u w=1.2u l=5.335u
X50 vg.t15 a_6206_896# VSS.t21 VSS.t2 nfet_03v3 ad=0.336p pd=1.76u as=0.54p ps=3.3u w=1.2u l=5.335u
X51 VSS.t19 a_6206_896# vg.t22 VSS.t4 nfet_03v3 ad=0.336p pd=1.76u as=0.336p ps=1.76u w=1.2u l=5.335u
X52 VSS.t23 a_6206_896# vg.t18 VSS.t22 nfet_03v3 ad=0.336p pd=1.76u as=0.336p ps=1.76u w=1.2u l=5.335u
X53 VSS.t5 a_6206_4704# vg.t6 VSS.t4 nfet_03v3 ad=0.336p pd=1.76u as=0.336p ps=1.76u w=1.2u l=5.335u
X54 VSS.t54 a_6206_14# vg.t34 VSS.t4 nfet_03v3 ad=0.336p pd=1.76u as=0.336p ps=1.76u w=1.2u l=5.335u
X55 a3.t0 a2.t2 vg.t2 VSS.t30 nfet_03v3 ad=0.9p pd=4.9u as=0.9p ps=4.9u w=2u l=0.28u
X56 vg.t36 a_6206_14# VSS.t46 VSS.t2 nfet_03v3 ad=0.336p pd=1.76u as=0.54p ps=3.3u w=1.2u l=5.335u
X57 vg.t7 a_6206_4704# VSS.t3 VSS.t2 nfet_03v3 ad=0.336p pd=1.76u as=0.54p ps=3.3u w=1.2u l=5.335u
X58 vg.t38 a_6206_14# VSS.t52 VSS.t14 nfet_03v3 ad=0.336p pd=1.76u as=0.336p ps=1.76u w=1.2u l=5.335u
X59 vg.t37 a_6206_14# VSS.t56 VSS.t2 nfet_03v3 ad=0.336p pd=1.76u as=0.54p ps=3.3u w=1.2u l=5.335u
X60 a4.t0 a3.t2 vg.t11 VSS.t11 nfet_03v3 ad=0.9p pd=4.9u as=0.9p ps=4.9u w=2u l=0.28u
X61 vg.t42 vbn.t13 VSS.t33 VSS.t14 nfet_03v3 ad=0.336p pd=1.76u as=0.336p ps=1.76u w=1.2u l=5.335u
X62 vg.t0 vbn.t11 VSS.t35 VSS.t14 nfet_03v3 ad=0.336p pd=1.76u as=0.336p ps=1.76u w=1.2u l=5.335u
X63 VSS.t44 a_6206_14# vg.t41 VSS.t4 nfet_03v3 ad=0.336p pd=1.76u as=0.336p ps=1.76u w=1.2u l=5.335u
X64 VSS.t12 a_7096_6633# vg.t13 VSS.t4 nfet_03v3 ad=0.336p pd=1.76u as=0.336p ps=1.76u w=1.2u l=5.335u
X65 vbn.t5 bitb1.t1 a_7096_6633# VDD.t17 pfet_03v3 ad=2.25p pd=10.9u as=2.25p ps=10.9u w=5u l=0.28u
X66 VDD.t15 vg.t43 VDD.t15 VDD.t14 pfet_03v3 ad=8.3496p pd=30.38u as=0 ps=0 w=29.82u l=4.12u
X67 a1.t0 a0.t3 VDD.t23 VDD.t22 pfet_03v3 ad=2.25p pd=10.9u as=2.25p ps=10.9u w=5u l=0.28u
X68 vbn.t0 bit3.t0 a_6206_896# VSS.t0 nfet_03v3 ad=0.9p pd=4.9u as=0.9p ps=4.9u w=2u l=0.28u
R0 vctrl vctrl.t0 33.6536
R1 vg.n46 vg.t43 31.0276
R2 vg.n17 vg.t48 26.4187
R3 vg.n21 vg.t47 26.4187
R4 vg.n29 vg.t46 26.4187
R5 vg.n36 vg.t45 26.4187
R6 vg.n43 vg.t44 26.4187
R7 vg.n17 vg.n16 21.9053
R8 vg.n21 vg.n9 21.9053
R9 vg.n22 vg.n21 21.9053
R10 vg.n29 vg.n6 21.9053
R11 vg.n36 vg.n35 21.9053
R12 vg.n44 vg.n43 21.9053
R13 vg.n43 vg.n2 21.9053
R14 vg.n67 vg.n66 14.5769
R15 vg.n50 vg.n48 10.4429
R16 vg.n56 vg.n54 10.4429
R17 vg.n62 vg.n60 10.4429
R18 vg.n70 vg.n68 10.4429
R19 vg.n76 vg.n74 10.4429
R20 vg.n82 vg.n80 10.4429
R21 vg.n43 vg.n42 8.0005
R22 vg.n21 vg.n12 8.0005
R23 vg.n52 vg.n51 7.6505
R24 vg.n50 vg.n49 7.6505
R25 vg.n58 vg.n57 7.6505
R26 vg.n56 vg.n55 7.6505
R27 vg.n64 vg.n63 7.6505
R28 vg.n62 vg.n61 7.6505
R29 vg.n72 vg.n71 7.6505
R30 vg.n70 vg.n69 7.6505
R31 vg.n78 vg.n77 7.6505
R32 vg.n76 vg.n75 7.6505
R33 vg.n84 vg.n83 7.6505
R34 vg.n82 vg.n81 7.6505
R35 vg.n53 vg.n47 6.56698
R36 vg.n53 vg.n52 6.02932
R37 vg.n59 vg.n58 6.02932
R38 vg.n65 vg.n64 6.02932
R39 vg.n73 vg.n72 6.02932
R40 vg.n79 vg.n78 6.02932
R41 vg.n85 vg.n84 6.02932
R42 vg.n18 vg.n17 5.8468
R43 vg.n37 vg.n36 5.8468
R44 vg.n30 vg.n29 5.8468
R45 vg.n52 vg.n50 2.79287
R46 vg.n58 vg.n56 2.79287
R47 vg.n64 vg.n62 2.79287
R48 vg.n72 vg.n70 2.79287
R49 vg.n78 vg.n76 2.79287
R50 vg.n84 vg.n82 2.79287
R51 vg.n8 vg.t2 2.71814
R52 vg.n27 vg.t11 2.71814
R53 vg.n11 vg.t3 2.71814
R54 vg.n20 vg.t25 2.71814
R55 vg.n14 vg.t24 2.71814
R56 vg.n16 vg.n15 2.4251
R57 vg.n47 vg.n46 2.28972
R58 vg.n15 vg.n13 2.2505
R59 vg.n19 vg.n10 2.2505
R60 vg.n24 vg.n23 2.2505
R61 vg.n26 vg.n25 2.2505
R62 vg.n28 vg.n7 2.2505
R63 vg.n32 vg.n31 2.2505
R64 vg.n34 vg.n33 2.2505
R65 vg.n5 vg.n4 2.2505
R66 vg.n39 vg.n38 2.2505
R67 vg.n41 vg.n40 2.2505
R68 vg.n3 vg.n1 2.2505
R69 vg.n45 vg.n0 2.2505
R70 vg.n51 vg.t40 1.4705
R71 vg.n51 vg.t7 1.4705
R72 vg.n49 vg.t41 1.4705
R73 vg.n49 vg.t1 1.4705
R74 vg.n48 vg.t29 1.4705
R75 vg.n48 vg.t20 1.4705
R76 vg.n57 vg.t9 1.4705
R77 vg.n57 vg.t36 1.4705
R78 vg.n55 vg.t13 1.4705
R79 vg.n55 vg.t28 1.4705
R80 vg.n54 vg.t21 1.4705
R81 vg.n54 vg.t35 1.4705
R82 vg.n63 vg.t32 1.4705
R83 vg.n63 vg.t19 1.4705
R84 vg.n61 vg.t6 1.4705
R85 vg.n61 vg.t17 1.4705
R86 vg.n60 vg.t39 1.4705
R87 vg.n60 vg.t42 1.4705
R88 vg.n66 vg.t8 1.4705
R89 vg.n66 vg.t23 1.4705
R90 vg.n71 vg.t10 1.4705
R91 vg.n71 vg.t31 1.4705
R92 vg.n69 vg.t22 1.4705
R93 vg.n69 vg.t4 1.4705
R94 vg.n68 vg.t16 1.4705
R95 vg.n68 vg.t38 1.4705
R96 vg.n77 vg.t27 1.4705
R97 vg.n77 vg.t15 1.4705
R98 vg.n75 vg.t34 1.4705
R99 vg.n75 vg.t14 1.4705
R100 vg.n74 vg.t30 1.4705
R101 vg.n74 vg.t0 1.4705
R102 vg.n83 vg.t18 1.4705
R103 vg.n83 vg.t37 1.4705
R104 vg.n81 vg.t12 1.4705
R105 vg.n81 vg.t26 1.4705
R106 vg.n80 vg.t5 1.4705
R107 vg.n80 vg.t33 1.4705
R108 vg.n73 vg.n67 1.30076
R109 vg.n65 vg.n59 1.13971
R110 vg.n85 vg.n79 1.13971
R111 vg vg.n85 1.10182
R112 vg.n59 vg.n53 0.658921
R113 vg.n67 vg.n65 0.658921
R114 vg.n79 vg.n73 0.658921
R115 vg.n47 vg.n0 0.1205
R116 vg.n3 vg.n0 0.1205
R117 vg.n40 vg.n3 0.1205
R118 vg.n40 vg.n39 0.1205
R119 vg.n39 vg.n4 0.1205
R120 vg.n33 vg.n4 0.1205
R121 vg.n33 vg.n32 0.1205
R122 vg.n32 vg.n7 0.1205
R123 vg.n25 vg.n7 0.1205
R124 vg.n25 vg.n24 0.1205
R125 vg.n24 vg.n10 0.1205
R126 vg.n15 vg.n10 0.1205
R127 vg.n45 vg.n44 0.1187
R128 vg.n27 vg.n26 0.1094
R129 vg.n38 vg.n2 0.0983
R130 vg.n19 vg.n18 0.0950122
R131 vg.n38 vg.n37 0.0926122
R132 vg.n46 vg.n45 0.0830251
R133 vg.n34 vg.n6 0.0803
R134 vg.n42 vg.n1 0.0707
R135 vg.n30 vg.n28 0.0698122
R136 vg.n20 vg.n19 0.068
R137 vg.n35 vg.n5 0.0635
R138 vg.n35 vg.n34 0.0575
R139 vg.n31 vg.n30 0.0520149
R140 vg.n42 vg.n41 0.0503
R141 vg.n23 vg.n12 0.0479
R142 vg.n11 vg.n9 0.047
R143 vg.n14 vg.n13 0.0416
R144 vg.n37 vg.n5 0.0292149
R145 vg.n22 vg.n20 0.0284
R146 vg.n18 vg.n13 0.0268149
R147 vg.n12 vg.n11 0.026
R148 vg.n31 vg.n8 0.0254
R149 vg.n23 vg.n22 0.0251
R150 vg.n16 vg.n14 0.0248
R151 vg.n41 vg.n2 0.0227
R152 vg.n8 vg.n6 0.0158
R153 vg.n28 vg.n27 0.0116
R154 vg.n44 vg.n1 0.0023
R155 vg.n26 vg.n9 0.0011
R156 bit4 bit4.t0 74.3752
R157 bit3 bit3.t0 74.3752
R158 bit2 bit2.t0 74.3752
R159 bit1 bit1.t0 74.3752
R160 bit0 bit0.t0 74.3752
R161 vbn.n10 vbn.t12 38.1796
R162 vbn.n13 vbn.t15 36.9444
R163 vbn.n9 vbn.t11 33.1076
R164 vbn.n11 vbn.t14 32.969
R165 vbn.n11 vbn.t13 32.5581
R166 vbn.n9 vbn.t10 31.0482
R167 vbn.n14 vbn.n13 8.26866
R168 vbn.n10 vbn.n9 6.13708
R169 vbn.n2 vbn.n0 6.08497
R170 vbn.n2 vbn.n1 5.20866
R171 vbn.n4 vbn.n3 5.20866
R172 vbn.n6 vbn.n5 5.20866
R173 vbn.n8 vbn.n7 5.20866
R174 vbn.n12 vbn.n11 4.5005
R175 vbn vbn.n14 4.25418
R176 vbn.n0 vbn.t9 3.71525
R177 vbn.n1 vbn.t8 3.71525
R178 vbn.n3 vbn.t7 3.71525
R179 vbn.n5 vbn.t0 3.71525
R180 vbn.n7 vbn.t6 3.71525
R181 vbn.n12 vbn.n10 2.28129
R182 vbn.n13 vbn.n12 1.63708
R183 vbn.n0 vbn.t2 0.8915
R184 vbn.n1 vbn.t5 0.8915
R185 vbn.n3 vbn.t3 0.8915
R186 vbn.n5 vbn.t1 0.8915
R187 vbn.n7 vbn.t4 0.8915
R188 vbn.n8 vbn.n6 0.876816
R189 vbn.n6 vbn.n4 0.876816
R190 vbn.n4 vbn.n2 0.876816
R191 vbn.n14 vbn.n8 0.378263
R192 bitb4.n0 bitb4.t1 110.341
R193 bitb4.n0 bitb4.t0 57.8015
R194 bitb4 bitb4.n0 11.5572
R195 bitb3.n0 bitb3.t1 110.341
R196 bitb3.n0 bitb3.t0 57.8015
R197 bitb3 bitb3.n0 11.5572
R198 bitb2.n0 bitb2.t1 110.341
R199 bitb2.n0 bitb2.t0 57.8015
R200 bitb2 bitb2.n0 11.5572
R201 bitb1.n0 bitb1.t1 110.341
R202 bitb1.n0 bitb1.t0 57.8015
R203 bitb1 bitb1.n0 11.5572
R204 bitb0.n0 bitb0.t1 110.341
R205 bitb0.n0 bitb0.t0 57.8015
R206 bitb0 bitb0.n0 11.5572
R207 a2.n0 a2.t3 101.66
R208 a2.n0 a2.t2 62.8185
R209 a2 a2.n0 5.05471
R210 a2 a2.n1 4.92563
R211 a2.n1 a2.t1 3.12196
R212 a2.n1 a2.t0 1.48479
R213 a3.n1 a3.t3 101.925
R214 a3.n1 a3.t2 62.5532
R215 a3 a3.n1 5.07839
R216 a3 a3.n0 4.99905
R217 a3.n0 a3.t0 2.64828
R218 a3.n0 a3.t1 1.95847
R219 a1.n0 a1.t3 101.925
R220 a1.n0 a1.t2 62.5532
R221 a1 a1.n0 5.1376
R222 a1 a1.n1 5.00853
R223 a1.n1 a1.t1 2.64828
R224 a1.n1 a1.t0 1.95847
R225 a4.n1 a4.t3 101.793
R226 a4.n1 a4.t2 62.6858
R227 a4 a4.n0 5.08195
R228 a4 a4.n1 5.05708
R229 a4.n0 a4.t0 2.88512
R230 a4.n0 a4.t1 1.72163
R231 a0.n1 a0.t3 101.793
R232 a0.n1 a0.t2 62.6858
R233 a0.n2 a0.n0 5.37563
R234 a0.n2 a0.n1 4.5005
R235 a0.n0 a0.t1 2.88512
R236 a0.n0 a0.t0 1.72163
R237 a0 a0.n2 0.656553
R238 VDD.n19 VDD.t19 1326.26
R239 VDD.n17 VDD.n16 943.674
R240 VDD.n19 VDD.t18 903.912
R241 VDD.t21 VDD.t26 413.409
R242 VDD.t26 VDD.t16 413.409
R243 VDD.t16 VDD.t17 413.409
R244 VDD.t17 VDD.t18 413.409
R245 VDD.n20 VDD.n12 410.329
R246 VDD.n20 VDD.n13 410.329
R247 VDD.t0 VDD.t22 335.197
R248 VDD.t24 VDD.t0 324.022
R249 VDD.t19 VDD.t2 290.503
R250 VDD.t2 VDD.t24 290.503
R251 VDD.n15 VDD.t21 207.821
R252 VDD.t22 VDD.n18 198.883
R253 VDD.t12 VDD.t14 149.046
R254 VDD.t10 VDD.t12 149.046
R255 VDD.t8 VDD.t6 149.046
R256 VDD.t6 VDD.t4 149.046
R257 VDD.n29 VDD.t10 74.5228
R258 VDD.n29 VDD.t8 74.5228
R259 VDD.n34 VDD.n24 10.4634
R260 VDD.n35 VDD.n34 9.56345
R261 VDD.n15 VDD.n12 6.3005
R262 VDD.n18 VDD.n13 6.3005
R263 VDD.n14 VDD.n12 5.69302
R264 VDD.n13 VDD.n1 5.69302
R265 VDD.n33 VDD.n25 3.70672
R266 VDD.n28 VDD.n26 3.70672
R267 VDD.n32 VDD.n30 3.70672
R268 VDD.n28 VDD.n27 2.71269
R269 VDD.n32 VDD.n31 2.71269
R270 VDD.n53 VDD.t23 1.71571
R271 VDD.n47 VDD.t1 1.71571
R272 VDD.n46 VDD.t25 1.71571
R273 VDD.n44 VDD.t3 1.71571
R274 VDD.n4 VDD.t20 1.71571
R275 VDD VDD.n55 1.55338
R276 VDD.n54 VDD.n0 1.5005
R277 VDD.n52 VDD.n51 1.5005
R278 VDD.n50 VDD.n2 1.5005
R279 VDD.n49 VDD.n48 1.5005
R280 VDD.n45 VDD.n3 1.5005
R281 VDD.n43 VDD.n42 1.5005
R282 VDD.n41 VDD.n40 1.5005
R283 VDD.n39 VDD.n5 1.5005
R284 VDD.n38 VDD.n37 1.5005
R285 VDD.n36 VDD.n6 1.5005
R286 VDD.n10 VDD.n7 1.5005
R287 VDD.n11 VDD.n9 1.5005
R288 VDD.n23 VDD.n22 1.5005
R289 VDD.n34 VDD.n33 1.16382
R290 VDD.n17 VDD.n1 0.996766
R291 VDD.n16 VDD.n14 0.996766
R292 VDD.n33 VDD.n28 0.7025
R293 VDD.n33 VDD.n32 0.7025
R294 VDD.n14 VDD.n8 0.477902
R295 VDD.n18 VDD.n17 0.371088
R296 VDD.n16 VDD.n15 0.371088
R297 VDD.n22 VDD.n8 0.273174
R298 VDD.n24 VDD.n8 0.212451
R299 VDD.n33 VDD.n29 0.207057
R300 VDD.n27 VDD.t13 0.0962905
R301 VDD.n31 VDD.t7 0.0962905
R302 VDD.n55 VDD.n1 0.0915242
R303 VDD.n11 VDD.n10 0.0755
R304 VDD.n10 VDD.n6 0.0755
R305 VDD.n38 VDD.n6 0.0755
R306 VDD.n39 VDD.n38 0.0755
R307 VDD.n40 VDD.n39 0.0755
R308 VDD.n52 VDD.n2 0.0755
R309 VDD.n23 VDD.n9 0.0755
R310 VDD.n9 VDD.n7 0.0755
R311 VDD.n37 VDD.n36 0.0755
R312 VDD.n37 VDD.n5 0.0755
R313 VDD.n41 VDD.n5 0.0755
R314 VDD.n42 VDD.n41 0.0755
R315 VDD.n42 VDD.n3 0.0755
R316 VDD.n49 VDD.n3 0.0755
R317 VDD.n50 VDD.n49 0.0755
R318 VDD.n51 VDD.n50 0.0755
R319 VDD.n51 VDD.n0 0.0755
R320 VDD.n48 VDD.n47 0.0738125
R321 VDD.n24 VDD.n23 0.07325
R322 VDD.n36 VDD.n35 0.07325
R323 VDD.n46 VDD.n45 0.0704375
R324 VDD.n53 VDD.n52 0.0666875
R325 VDD.t11 VDD.n25 0.0662277
R326 VDD.t9 VDD.n25 0.0662277
R327 VDD.t13 VDD.n26 0.0662277
R328 VDD.n26 VDD.t11 0.0662277
R329 VDD.n30 VDD.t9 0.0662277
R330 VDD.t7 VDD.n30 0.0662277
R331 VDD.n21 VDD.n20 0.0610769
R332 VDD.n20 VDD.n19 0.0610769
R333 VDD.n21 VDD.n11 0.060875
R334 VDD VDD.n0 0.054875
R335 VDD.n43 VDD.n4 0.0505625
R336 VDD.n44 VDD.n43 0.0479375
R337 VDD.n55 VDD.n54 0.04325
R338 VDD.n27 VDD.t15 0.0366406
R339 VDD.n31 VDD.t5 0.0366406
R340 VDD.n45 VDD.n44 0.0280625
R341 VDD.n40 VDD.n4 0.0254375
R342 VDD.n22 VDD.n21 0.015125
R343 VDD.n54 VDD.n53 0.0093125
R344 VDD.n48 VDD.n46 0.0055625
R345 VDD.n35 VDD.n7 0.00275
R346 VDD.n47 VDD.n2 0.0021875
R347 VSS.n108 VSS.n107 73410.6
R348 VSS.n37 VSS.n5 50154.7
R349 VSS.n108 VSS.n5 20616.1
R350 VSS.n38 VSS.n37 19312
R351 VSS.n107 VSS.t30 12153.5
R352 VSS.t42 VSS.n5 2384.11
R353 VSS.t1 VSS.t42 2329.75
R354 VSS.t59 VSS.t1 2252.09
R355 VSS.t30 VSS.t11 2019.12
R356 VSS.t11 VSS.t59 2019.12
R357 VSS.n39 VSS.n3 1068.61
R358 VSS.n109 VSS.n3 1068.61
R359 VSS.n109 VSS.n4 1068.51
R360 VSS.n39 VSS.n4 1068.51
R361 VSS.t14 VSS.t4 482.043
R362 VSS.n39 VSS.t8 370.476
R363 VSS.t8 VSS.n38 325.86
R364 VSS.t4 VSS.t41 278.022
R365 VSS.n107 VSS.t28 226.506
R366 VSS.t62 VSS.t60 176.626
R367 VSS.n38 VSS.t14 156.184
R368 VSS.t2 VSS.t26 134.514
R369 VSS.t37 VSS.t24 127.154
R370 VSS.t60 VSS.t0 125.928
R371 VSS.t26 VSS.t63 125.928
R372 VSS.t28 VSS.n106 123.067
R373 VSS.t39 VSS.n105 110.8
R374 VSS.t0 VSS.t6 98.5349
R375 VSS.t22 VSS.t62 80.9541
R376 VSS.t6 VSS.t39 78.0921
R377 VSS.t63 VSS.t37 49.4721
R378 VSS.t24 VSS.t22 44.9747
R379 VSS.t64 VSS.t2 42.1127
R380 VSS.n105 VSS.t41 15.1282
R381 VSS.n40 VSS.n2 13.3863
R382 VSS.n110 VSS.n2 13.3863
R383 VSS.n104 VSS.t40 6.08947
R384 VSS.n103 VSS.t61 6.08947
R385 VSS.n102 VSS.t25 6.08947
R386 VSS.n101 VSS.t27 6.08947
R387 VSS.n100 VSS.t29 6.08947
R388 VSS.n17 VSS.t50 5.72359
R389 VSS.n41 VSS.n40 5.23877
R390 VSS.n111 VSS.n110 5.21234
R391 VSS.n13 VSS.t55 4.82596
R392 VSS.n13 VSS.t20 4.82596
R393 VSS.n96 VSS.t21 4.82596
R394 VSS.n96 VSS.t51 4.82596
R395 VSS.n8 VSS.t16 4.82596
R396 VSS.n8 VSS.t45 4.82596
R397 VSS.n23 VSS.t46 4.82596
R398 VSS.n23 VSS.t3 4.82596
R399 VSS.n27 VSS.t17 4.82596
R400 VSS.n26 VSS.t38 4.82596
R401 VSS.n17 VSS.t10 4.82596
R402 VSS.n41 VSS.t9 4.75491
R403 VSS.n28 VSS.t56 4.75491
R404 VSS.n14 VSS.n11 3.43471
R405 VSS.n14 VSS.n12 3.43471
R406 VSS.n95 VSS.n93 3.43471
R407 VSS.n95 VSS.n94 3.43471
R408 VSS.n9 VSS.n6 3.43471
R409 VSS.n9 VSS.n7 3.43471
R410 VSS.n22 VSS.n20 3.43471
R411 VSS.n22 VSS.n21 3.43471
R412 VSS.n18 VSS.n16 3.43471
R413 VSS.n25 VSS.n24 3.43471
R414 VSS.n43 VSS.n42 3.36366
R415 VSS.n54 VSS.n33 3.36366
R416 VSS.n106 VSS.t64 2.8625
R417 VSS.n9 VSS.n8 2.78932
R418 VSS.n23 VSS.n22 2.78932
R419 VSS.n14 VSS.n13 2.78932
R420 VSS.n96 VSS.n95 2.78932
R421 VSS.n18 VSS.n17 1.89168
R422 VSS.n26 VSS.n25 1.89168
R423 VSS.n98 VSS.n97 1.86918
R424 VSS.n99 VSS.n98 1.70813
R425 VSS.n97 VSS.n92 1.63708
R426 VSS.n10 VSS.n9 1.54826
R427 VSS.n19 VSS.n18 1.54826
R428 VSS.n15 VSS.n14 1.54826
R429 VSS.n100 VSS.n99 1.54471
R430 VSS VSS.n111 1.52112
R431 VSS.n45 VSS.n36 1.5005
R432 VSS.n47 VSS.n46 1.5005
R433 VSS.n48 VSS.n35 1.5005
R434 VSS.n50 VSS.n49 1.5005
R435 VSS.n51 VSS.n34 1.5005
R436 VSS.n53 VSS.n52 1.5005
R437 VSS.n55 VSS.n32 1.5005
R438 VSS.n57 VSS.n56 1.5005
R439 VSS.n58 VSS.n31 1.5005
R440 VSS.n60 VSS.n59 1.5005
R441 VSS.n61 VSS.n30 1.5005
R442 VSS.n64 VSS.n63 1.5005
R443 VSS.n91 VSS.n90 1.5005
R444 VSS.n89 VSS.n29 1.5005
R445 VSS.n88 VSS.n87 1.5005
R446 VSS.n86 VSS.n65 1.5005
R447 VSS.n85 VSS.n84 1.5005
R448 VSS.n83 VSS.n66 1.5005
R449 VSS.n82 VSS.n81 1.5005
R450 VSS.n80 VSS.n67 1.5005
R451 VSS.n79 VSS.n78 1.5005
R452 VSS.n77 VSS.n68 1.5005
R453 VSS.n76 VSS.n75 1.5005
R454 VSS.n74 VSS.n69 1.5005
R455 VSS.n73 VSS.n72 1.5005
R456 VSS.n71 VSS.n70 1.5005
R457 VSS.n1 VSS.n0 1.5005
R458 VSS.n42 VSS.t58 1.4705
R459 VSS.n42 VSS.t36 1.4705
R460 VSS.n33 VSS.t57 1.4705
R461 VSS.n33 VSS.t23 1.4705
R462 VSS.n12 VSS.t35 1.4705
R463 VSS.n12 VSS.t54 1.4705
R464 VSS.n11 VSS.t52 1.4705
R465 VSS.n11 VSS.t19 1.4705
R466 VSS.n94 VSS.t13 1.4705
R467 VSS.n94 VSS.t53 1.4705
R468 VSS.n93 VSS.t7 1.4705
R469 VSS.n93 VSS.t34 1.4705
R470 VSS.n7 VSS.t48 1.4705
R471 VSS.n7 VSS.t12 1.4705
R472 VSS.n6 VSS.t15 1.4705
R473 VSS.n6 VSS.t44 1.4705
R474 VSS.n21 VSS.t47 1.4705
R475 VSS.n21 VSS.t32 1.4705
R476 VSS.n20 VSS.t31 1.4705
R477 VSS.n20 VSS.t43 1.4705
R478 VSS.n16 VSS.t33 1.4705
R479 VSS.n16 VSS.t5 1.4705
R480 VSS.n24 VSS.t18 1.4705
R481 VSS.n24 VSS.t49 1.4705
R482 VSS.n22 VSS.n10 1.24511
R483 VSS.n25 VSS.n19 1.24511
R484 VSS.n95 VSS.n15 1.24511
R485 VSS.n27 VSS.n26 0.898132
R486 VSS.n104 VSS.n103 0.876816
R487 VSS.n103 VSS.n102 0.876816
R488 VSS.n102 VSS.n101 0.876816
R489 VSS.n101 VSS.n100 0.876816
R490 VSS.n105 VSS.n104 0.550675
R491 VSS.n45 VSS.n44 0.364386
R492 VSS.n99 VSS.n23 0.302474
R493 VSS.n98 VSS.n27 0.302474
R494 VSS.n97 VSS.n96 0.302474
R495 VSS.n44 VSS.n41 0.214812
R496 VSS.n44 VSS.n43 0.184345
R497 VSS.n105 VSS.n15 0.133833
R498 VSS.n105 VSS.n19 0.133833
R499 VSS.n105 VSS.n10 0.133833
R500 VSS.n47 VSS.n36 0.0755
R501 VSS.n48 VSS.n47 0.0755
R502 VSS.n49 VSS.n48 0.0755
R503 VSS.n49 VSS.n34 0.0755
R504 VSS.n53 VSS.n34 0.0755
R505 VSS.n56 VSS.n55 0.0755
R506 VSS.n56 VSS.n31 0.0755
R507 VSS.n60 VSS.n31 0.0755
R508 VSS.n61 VSS.n60 0.0755
R509 VSS.n91 VSS.n29 0.0755
R510 VSS.n87 VSS.n29 0.0755
R511 VSS.n87 VSS.n86 0.0755
R512 VSS.n86 VSS.n85 0.0755
R513 VSS.n85 VSS.n66 0.0755
R514 VSS.n81 VSS.n66 0.0755
R515 VSS.n81 VSS.n80 0.0755
R516 VSS.n80 VSS.n79 0.0755
R517 VSS.n79 VSS.n68 0.0755
R518 VSS.n75 VSS.n68 0.0755
R519 VSS.n75 VSS.n74 0.0755
R520 VSS.n74 VSS.n73 0.0755
R521 VSS.n73 VSS.n70 0.0755
R522 VSS.n70 VSS.n1 0.0755
R523 VSS.n111 VSS.n1 0.0755
R524 VSS.n46 VSS.n45 0.0755
R525 VSS.n46 VSS.n35 0.0755
R526 VSS.n50 VSS.n35 0.0755
R527 VSS.n51 VSS.n50 0.0755
R528 VSS.n52 VSS.n51 0.0755
R529 VSS.n52 VSS.n32 0.0755
R530 VSS.n57 VSS.n32 0.0755
R531 VSS.n58 VSS.n57 0.0755
R532 VSS.n59 VSS.n58 0.0755
R533 VSS.n59 VSS.n30 0.0755
R534 VSS.n64 VSS.n30 0.0755
R535 VSS.n90 VSS.n64 0.0755
R536 VSS.n90 VSS.n89 0.0755
R537 VSS.n89 VSS.n88 0.0755
R538 VSS.n88 VSS.n65 0.0755
R539 VSS.n84 VSS.n65 0.0755
R540 VSS.n84 VSS.n83 0.0755
R541 VSS.n83 VSS.n82 0.0755
R542 VSS.n82 VSS.n67 0.0755
R543 VSS.n78 VSS.n67 0.0755
R544 VSS.n78 VSS.n77 0.0755
R545 VSS.n77 VSS.n76 0.0755
R546 VSS.n76 VSS.n69 0.0755
R547 VSS.n72 VSS.n69 0.0755
R548 VSS.n72 VSS.n71 0.0755
R549 VSS.n71 VSS.n0 0.0755
R550 VSS.n63 VSS.n62 0.0629375
R551 VSS VSS.n0 0.054875
R552 VSS.n40 VSS.n39 0.0530253
R553 VSS.n110 VSS.n109 0.0530253
R554 VSS.n109 VSS.n108 0.0530253
R555 VSS.n92 VSS.n28 0.0483125
R556 VSS.n55 VSS.n54 0.04025
R557 VSS.n54 VSS.n53 0.03575
R558 VSS.n3 VSS.n2 0.0356351
R559 VSS.n37 VSS.n3 0.0356351
R560 VSS.n62 VSS.n4 0.0356351
R561 VSS.n106 VSS.n4 0.0356351
R562 VSS.n43 VSS.n36 0.032375
R563 VSS.n63 VSS.n28 0.0273125
R564 VSS.n62 VSS.n61 0.0130625
R565 VSS.n92 VSS.n91 0.000875
C0 a4 a1 0.39821f
C1 vctrl a_7096_6633# 0.04912f
C2 bit0 VDD 0.41867f
C3 a_6206_896# bit0 0.00331f
C4 bitb0 bitb1 0.01415f
C5 vbn bit2 0.19681f
C6 vg a2 0.4138f
C7 vg bit1 0
C8 bit1 a_6206_4704# 0.00886f
C9 bit1 bitb2 0.72283f
C10 bitb3 bit3 0.3148f
C11 bit0 a_6206_4704# 0
C12 bitb1 bit1 0.3148f
C13 vbn bitb4 0.17851f
C14 bit0 bitb1 0.72283f
C15 vbn vctrl 0.20136f
C16 a0 VDD 1.54092f
C17 a_6206_14# a_6356_6633# 0.21414f
C18 a_7096_6633# VDD 0.1987f
C19 a_6206_14# bitb3 0
C20 a_6206_896# a_7096_6633# 0.6087f
C21 a_6206_14# bitb0 0
C22 a0 vg 0.40126f
C23 vg a_7096_6633# 3.92648f
C24 a_7096_6633# a_6206_4704# 3.99805f
C25 a_7096_6633# bitb2 0.00121f
C26 a3 a1 0.02066f
C27 a1 VDD 1.2f
C28 a_6206_14# bit1 0
C29 bitb0 a_6356_6633# 0.21396f
C30 bitb1 a_7096_6633# 0.21396f
C31 bit2 VDD 0.39745f
C32 a_6206_14# bit0 0
C33 a_6206_896# bit2 0.01215f
C34 a4 a3 0.34397f
C35 vbn VDD 5.2352f
C36 a4 VDD 1.38472f
C37 vbn a_6206_896# 8.00858f
C38 vg a1 0.52714f
C39 bit2 a_6206_4704# 0.04998f
C40 vg vbn 1.36793f
C41 bitb4 VDD 0.69452f
C42 a4 vg 0.4584f
C43 bit2 bitb2 0.3148f
C44 a_6206_896# bitb4 0.00214f
C45 vbn a_6206_4704# 11.0326f
C46 bit0 a_6356_6633# 0.04998f
C47 vbn bitb2 0.1755f
C48 vctrl VDD 0.0024f
C49 bitb0 bit0 0.3148f
C50 vbn bitb1 0.1755f
C51 a_6206_896# vctrl 0.30122f
C52 bit4 vbn 0.71456f
C53 bitb4 a_6206_4704# 0
C54 vg vctrl 1.00629f
C55 vctrl a_6206_4704# 0.17004f
C56 bit2 bit3 0.02757f
C57 a_6206_14# a_7096_6633# 1.30715f
C58 vbn bit3 0.19848f
C59 bit4 bitb4 0.3148f
C60 bit0 bit1 0.02757f
C61 bit3 bitb4 0.72283f
C62 a_7096_6633# a_6356_6633# 0.51329f
C63 a3 VDD 1.30999f
C64 a_6206_14# bit2 0
C65 bitb0 a_7096_6633# 0
C66 a_6206_896# VDD 0.21312f
C67 a_6206_14# vbn 9.71087f
C68 a0 a2 0.00356f
C69 vg a3 0.52997f
C70 vg VDD 23.3372f
C71 a_6206_4704# VDD 0.20804f
C72 a_6206_14# bitb4 0.21399f
C73 vg a_6206_896# 3.03622f
C74 a_6206_896# a_6206_4704# 4.47742f
C75 a_7096_6633# bit1 0.04998f
C76 bitb2 VDD 0.69427f
C77 a_6206_896# bitb2 0.00104f
C78 vbn a_6356_6633# 1.13433f
C79 bit2 bitb3 0.72283f
C80 bit0 a_7096_6633# 0.00884f
C81 bitb1 VDD 0.69509f
C82 a_6206_14# vctrl 0.19159f
C83 vbn bitb3 0.17647f
C84 a_6206_896# bitb1 0
C85 bit4 VDD 0.46603f
C86 bit4 a_6206_896# 0.00331f
C87 vbn bitb0 0.0727f
C88 vg a_6206_4704# 2.53191f
C89 a1 a2 0.1528f
C90 bitb2 a_6206_4704# 0.21396f
C91 bitb1 a_6206_4704# 0
C92 bitb3 bitb4 0.01415f
C93 bit3 VDD 0.39755f
C94 a_6206_896# bit3 0.05328f
C95 vctrl a_6356_6633# 3.22782f
C96 bitb1 bitb2 0.01415f
C97 bit4 a_6206_4704# 0
C98 bit2 bit1 0.02757f
C99 a4 a2 0.37969f
C100 vbn bit1 0.19681f
C101 vbn bit0 0.19018f
C102 bit3 a_6206_4704# 0
C103 bit4 bit3 0.02757f
C104 a_6206_14# VDD 0.2224f
C105 a_6206_14# a_6206_896# 8.81578f
C106 a0 a1 0.58969f
C107 a4 a0 0.16016f
C108 vg a_6206_14# 5.82132f
C109 a_6206_14# a_6206_4704# 7.70065f
C110 a_6356_6633# VDD 0.2733f
C111 a_6206_14# bitb2 0
C112 a_6206_896# a_6356_6633# 3.25671f
C113 bitb3 VDD 0.69433f
C114 a_6206_14# bitb1 0
C115 vbn a_7096_6633# 4.66141f
C116 a_6206_896# bitb3 0.21489f
C117 bitb0 VDD 1.02531f
C118 a_6206_14# bit4 0.05001f
C119 bitb0 a_6206_896# 0
C120 vg a_6356_6633# 1.03554f
C121 a_6356_6633# a_6206_4704# 0.20544f
C122 a3 a2 0.37174f
C123 bitb3 a_6206_4704# 0.00123f
C124 a2 VDD 1.51639f
C125 a_6206_14# bit3 0.00887f
C126 bitb3 bitb2 0.01415f
C127 bitb1 a_6356_6633# 0.00121f
C128 bitb0 a_6206_4704# 0
C129 bit1 VDD 0.39742f
C130 a_6206_896# bit1 0.00331f
C131 vctrl VSS 3.51452f
C132 vg VSS 2.81904f
C133 bit4 VSS 0.387534f
C134 bit3 VSS 0.2697f
C135 bit2 VSS 0.270085f
C136 bit1 VSS 0.270163f
C137 bit0 VSS 0.277124f
C138 vbn VSS 2.97003f
C139 bitb4 VSS 0.210032f
C140 bitb3 VSS 0.199955f
C141 bitb2 VSS 0.199873f
C142 bitb1 VSS 0.200456f
C143 bitb0 VSS 0.275005f
C144 a2 VSS 0.0550165f
C145 a3 VSS 0.10975f
C146 a1 VSS 0.0871188f
C147 a4 VSS 0.0636097f
C148 a0 VSS 0.0994623f
C149 VDD VSS 145.446f
C150 a_6206_14# VSS 24.2576f
C151 a_6206_896# VSS 15.1648f
C152 a_6206_4704# VSS 7.88957f
C153 a_7096_6633# VSS 3.78694f
C154 a_6356_6633# VSS 2.52399f
C155 VDD.n0 VSS 0.0686429f
C156 VDD.t23 VSS 0.0444626f
C157 VDD.n2 VSS 0.0406859f
C158 VDD.n3 VSS 0.0795846f
C159 VDD.t25 VSS 0.0444626f
C160 VDD.t3 VSS 0.0444626f
C161 VDD.t20 VSS 0.0444626f
C162 VDD.n4 VSS 0.0703411f
C163 VDD.n5 VSS 0.0795846f
C164 VDD.n6 VSS 0.0795846f
C165 VDD.n7 VSS 0.0409852f
C166 VDD.n8 VSS 1.23991f
C167 VDD.n9 VSS 0.0795846f
C168 VDD.n10 VSS 0.0795846f
C169 VDD.n11 VSS 0.0718292f
C170 VDD.n12 VSS 0.0923379f
C171 VDD.n13 VSS 0.0923379f
C172 VDD.t18 VSS 0.874808f
C173 VDD.n14 VSS 1.48577f
C174 VDD.t17 VSS 0.54907f
C175 VDD.t16 VSS 0.54907f
C176 VDD.t26 VSS 0.54907f
C177 VDD.t21 VSS 0.412545f
C178 VDD.n15 VSS 0.188469f
C179 VDD.n16 VSS 0.218059f
C180 VDD.n17 VSS 0.218059f
C181 VDD.n18 VSS 0.182533f
C182 VDD.t22 VSS 0.354674f
C183 VDD.t0 VSS 0.437776f
C184 VDD.t24 VSS 0.408097f
C185 VDD.t2 VSS 0.385833f
C186 VDD.t19 VSS 1.07366f
C187 VDD.n19 VSS 1.48101f
C188 VDD.n20 VSS 0.155943f
C189 VDD.n21 VSS 0.0397964f
C190 VDD.n22 VSS 0.242045f
C191 VDD.n23 VSS 0.0783958f
C192 VDD.n24 VSS 0.880194f
C193 VDD.n25 VSS 0.27745f
C194 VDD.t11 VSS 0.138442f
C195 VDD.n26 VSS 0.27745f
C196 VDD.t13 VSS 0.225515f
C197 VDD.t15 VSS 0.439046f
C198 VDD.n27 VSS 0.234112f
C199 VDD.n28 VSS 0.223162f
C200 VDD.t14 VSS 2.75937f
C201 VDD.t12 VSS 2.43658f
C202 VDD.t10 VSS 1.82743f
C203 VDD.t4 VSS 2.75937f
C204 VDD.t6 VSS 2.43658f
C205 VDD.t8 VSS 1.82743f
C206 VDD.n29 VSS 1.12687f
C207 VDD.t9 VSS 0.138442f
C208 VDD.n30 VSS 0.27745f
C209 VDD.t5 VSS 0.439046f
C210 VDD.t7 VSS 0.225515f
C211 VDD.n31 VSS 0.234112f
C212 VDD.n32 VSS 0.223162f
C213 VDD.n33 VSS 0.17409f
C214 VDD.n34 VSS 0.576307f
C215 VDD.n35 VSS 0.550461f
C216 VDD.n36 VSS 0.0783958f
C217 VDD.n37 VSS 0.0795846f
C218 VDD.n38 VSS 0.0795846f
C219 VDD.n39 VSS 0.0795846f
C220 VDD.n40 VSS 0.0530268f
C221 VDD.n41 VSS 0.0795846f
C222 VDD.n42 VSS 0.0795846f
C223 VDD.n43 VSS 0.0517328f
C224 VDD.n44 VSS 0.0703411f
C225 VDD.n45 VSS 0.0517328f
C226 VDD.n46 VSS 0.0703411f
C227 VDD.t1 VSS 0.0444626f
C228 VDD.n47 VSS 0.0703411f
C229 VDD.n48 VSS 0.0415836f
C230 VDD.n49 VSS 0.0795846f
C231 VDD.n50 VSS 0.0795846f
C232 VDD.n51 VSS 0.0795846f
C233 VDD.n52 VSS 0.0749103f
C234 VDD.n53 VSS 0.0703411f
C235 VDD.n54 VSS 0.0273585f
C236 VDD.n55 VSS 0.0950956f
C237 a0.t0 VSS 0.0897256f
C238 a0.t1 VSS 0.0280987f
C239 a0.n0 VSS 0.105933f
C240 a0.t3 VSS 0.0411231f
C241 a0.t2 VSS 0.0211329f
C242 a0.n1 VSS 0.0579488f
C243 a0.n2 VSS 0.0626353f
C244 a4.t1 VSS 0.0577796f
C245 a4.t0 VSS 0.0180942f
C246 a4.n0 VSS 0.0668318f
C247 a4.t3 VSS 0.026482f
C248 a4.t2 VSS 0.0136087f
C249 a4.n1 VSS 0.038544f
C250 a1.t3 VSS 0.03297f
C251 a1.t2 VSS 0.0168867f
C252 a1.n0 VSS 0.0521749f
C253 a1.t0 VSS 0.0784346f
C254 a1.t1 VSS 0.0200827f
C255 a1.n1 VSS 0.0786023f
C256 a3.t1 VSS 0.0891203f
C257 a3.t0 VSS 0.0228188f
C258 a3.n0 VSS 0.0892624f
C259 a3.t3 VSS 0.0374622f
C260 a3.t2 VSS 0.0191878f
C261 a3.n1 VSS 0.0589883f
C262 a2.t2 VSS 0.0133142f
C263 a2.t3 VSS 0.0258111f
C264 a2.n0 VSS 0.0406397f
C265 a2.t0 VSS 0.0508295f
C266 a2.t1 VSS 0.0198672f
C267 a2.n1 VSS 0.0679818f
C268 bitb0.t1 VSS 0.0590671f
C269 bitb0.t0 VSS 0.0179972f
C270 bitb0.n0 VSS 0.10169f
C271 bitb1.t1 VSS 0.0503629f
C272 bitb1.t0 VSS 0.0153458f
C273 bitb1.n0 VSS 0.0867057f
C274 bitb2.t1 VSS 0.0502126f
C275 bitb2.t0 VSS 0.0152986f
C276 bitb2.n0 VSS 0.0864462f
C277 bitb3.t1 VSS 0.0502213f
C278 bitb3.t0 VSS 0.0153012f
C279 bitb3.n0 VSS 0.0864623f
C280 bitb4.t1 VSS 0.0520954f
C281 bitb4.t0 VSS 0.0158735f
C282 bitb4.n0 VSS 0.0896891f
C283 vbn.t9 VSS 0.0711258f
C284 vbn.t2 VSS 0.0897514f
C285 vbn.n0 VSS 0.22723f
C286 vbn.t8 VSS 0.0711258f
C287 vbn.t5 VSS 0.0897514f
C288 vbn.n1 VSS 0.220215f
C289 vbn.n2 VSS 0.12602f
C290 vbn.t7 VSS 0.0711258f
C291 vbn.t3 VSS 0.0897514f
C292 vbn.n3 VSS 0.220215f
C293 vbn.n4 VSS 0.084332f
C294 vbn.t0 VSS 0.0711258f
C295 vbn.t1 VSS 0.0897514f
C296 vbn.n5 VSS 0.220215f
C297 vbn.n6 VSS 0.084332f
C298 vbn.t6 VSS 0.0711258f
C299 vbn.t4 VSS 0.0897514f
C300 vbn.n7 VSS 0.220215f
C301 vbn.n8 VSS 0.061743f
C302 vbn.t11 VSS 0.463015f
C303 vbn.t10 VSS 0.442531f
C304 vbn.n9 VSS 0.920748f
C305 vbn.t12 VSS 0.563818f
C306 vbn.n10 VSS 0.942403f
C307 vbn.t13 VSS 0.460583f
C308 vbn.t14 VSS 0.464253f
C309 vbn.n11 VSS 0.880593f
C310 vbn.n12 VSS 0.177502f
C311 vbn.t15 VSS 0.561437f
C312 vbn.n13 VSS 1.06455f
C313 vbn.n14 VSS 0.289531f
C314 bit0.t0 VSS 0.0360661f
C315 bit1.t0 VSS 0.0353469f
C316 bit2.t0 VSS 0.0353448f
C317 bit3.t0 VSS 0.0352999f
C318 bit4.t0 VSS 0.0462258f
C319 vg.n0 VSS 0.0310155f
C320 vg.n1 VSS 0.00930376f
C321 vg.t44 VSS 0.942815f
C322 vg.n2 VSS 0.0215431f
C323 vg.n3 VSS 0.0310155f
C324 vg.n4 VSS 0.0310155f
C325 vg.n5 VSS 0.0164907f
C326 vg.t45 VSS 0.942815f
C327 vg.n6 VSS 0.0183257f
C328 vg.n7 VSS 0.0310155f
C329 vg.t2 VSS 0.00802569f
C330 vg.n8 VSS 0.0155299f
C331 vg.t11 VSS 0.00802569f
C332 vg.n9 VSS 0.012124f
C333 vg.n10 VSS 0.0310155f
C334 vg.t3 VSS 0.00802569f
C335 vg.n11 VSS 0.0196393f
C336 vg.n12 VSS 0.00942136f
C337 vg.t25 VSS 0.00802569f
C338 vg.n13 VSS 0.0137748f
C339 vg.t48 VSS 0.942815f
C340 vg.t24 VSS 0.00802569f
C341 vg.n14 VSS 0.0187873f
C342 vg.n15 VSS 0.0519484f
C343 vg.n16 VSS 0.0302677f
C344 vg.n17 VSS 0.332299f
C345 vg.n18 VSS 0.0116114f
C346 vg.n19 VSS 0.0257013f
C347 vg.n20 VSS 0.0226636f
C348 vg.t47 VSS 0.942815f
C349 vg.n21 VSS 0.332299f
C350 vg.n22 VSS 0.0128207f
C351 vg.n23 VSS 0.00930376f
C352 vg.n24 VSS 0.0310155f
C353 vg.n25 VSS 0.0310155f
C354 vg.n26 VSS 0.0141498f
C355 vg.n27 VSS 0.0258433f
C356 vg.n28 VSS 0.0168879f
C357 vg.t46 VSS 0.942815f
C358 vg.n29 VSS 0.332299f
C359 vg.n30 VSS 0.0123547f
C360 vg.n31 VSS 0.0124612f
C361 vg.n32 VSS 0.0310155f
C362 vg.n33 VSS 0.0310155f
C363 vg.n34 VSS 0.0176778f
C364 vg.n35 VSS 0.0215431f
C365 vg.n36 VSS 0.332299f
C366 vg.n37 VSS 0.0119109f
C367 vg.n38 VSS 0.029429f
C368 vg.n39 VSS 0.0310155f
C369 vg.n40 VSS 0.0310155f
C370 vg.n41 VSS 0.00930376f
C371 vg.n42 VSS 0.0155078f
C372 vg.n43 VSS 0.332299f
C373 vg.n44 VSS 0.0215431f
C374 vg.n45 VSS 0.0324511f
C375 vg.t43 VSS 0.992186f
C376 vg.n46 VSS 0.339371f
C377 vg.n47 VSS 0.0813819f
C378 vg.t29 VSS 0.00173738f
C379 vg.t20 VSS 0.00173738f
C380 vg.n48 VSS 0.0131868f
C381 vg.t41 VSS 0.00173738f
C382 vg.t1 VSS 0.00173738f
C383 vg.n49 VSS 0.00627056f
C384 vg.n50 VSS 0.067221f
C385 vg.t40 VSS 0.00173738f
C386 vg.t7 VSS 0.00173738f
C387 vg.n51 VSS 0.00627056f
C388 vg.n52 VSS 0.0478169f
C389 vg.n53 VSS 0.0367557f
C390 vg.t21 VSS 0.00173738f
C391 vg.t35 VSS 0.00173738f
C392 vg.n54 VSS 0.0131868f
C393 vg.t13 VSS 0.00173738f
C394 vg.t28 VSS 0.00173738f
C395 vg.n55 VSS 0.00627056f
C396 vg.n56 VSS 0.067221f
C397 vg.t9 VSS 0.00173738f
C398 vg.t36 VSS 0.00173738f
C399 vg.n57 VSS 0.00627056f
C400 vg.n58 VSS 0.0478169f
C401 vg.n59 VSS 0.0183124f
C402 vg.t39 VSS 0.00173738f
C403 vg.t42 VSS 0.00173738f
C404 vg.n60 VSS 0.0131868f
C405 vg.t6 VSS 0.00173738f
C406 vg.t17 VSS 0.00173738f
C407 vg.n61 VSS 0.00627056f
C408 vg.n62 VSS 0.067221f
C409 vg.t32 VSS 0.00173738f
C410 vg.t19 VSS 0.00173738f
C411 vg.n63 VSS 0.00627056f
C412 vg.n64 VSS 0.0478169f
C413 vg.n65 VSS 0.0183124f
C414 vg.t8 VSS 0.00173738f
C415 vg.t23 VSS 0.00173738f
C416 vg.n66 VSS 0.0235601f
C417 vg.n67 VSS 0.0426535f
C418 vg.t16 VSS 0.00173738f
C419 vg.t38 VSS 0.00173738f
C420 vg.n68 VSS 0.0131868f
C421 vg.t22 VSS 0.00173738f
C422 vg.t4 VSS 0.00173738f
C423 vg.n69 VSS 0.00627056f
C424 vg.n70 VSS 0.067221f
C425 vg.t10 VSS 0.00173738f
C426 vg.t31 VSS 0.00173738f
C427 vg.n71 VSS 0.00627056f
C428 vg.n72 VSS 0.0478169f
C429 vg.n73 VSS 0.0196482f
C430 vg.t30 VSS 0.00173738f
C431 vg.t0 VSS 0.00173738f
C432 vg.n74 VSS 0.0131868f
C433 vg.t34 VSS 0.00173738f
C434 vg.t14 VSS 0.00173738f
C435 vg.n75 VSS 0.00627056f
C436 vg.n76 VSS 0.067221f
C437 vg.t27 VSS 0.00173738f
C438 vg.t15 VSS 0.00173738f
C439 vg.n77 VSS 0.00627056f
C440 vg.n78 VSS 0.0478169f
C441 vg.n79 VSS 0.0183124f
C442 vg.t5 VSS 0.00173738f
C443 vg.t33 VSS 0.00173738f
C444 vg.n80 VSS 0.0131868f
C445 vg.t12 VSS 0.00173738f
C446 vg.t26 VSS 0.00173738f
C447 vg.n81 VSS 0.00627056f
C448 vg.n82 VSS 0.067221f
C449 vg.t18 VSS 0.00173738f
C450 vg.t37 VSS 0.00173738f
C451 vg.n83 VSS 0.00627056f
C452 vg.n84 VSS 0.0478169f
C453 vg.n85 VSS 0.0219869f
C454 vctrl.t0 VSS 1.70981f
.ends
