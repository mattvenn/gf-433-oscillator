* ring_core: magic R+C extraction of layout/ring_core.gds (layout/gen/pex.sh)
* extracted 2026-11-08T13:01:36+01:00 with magic 8.3.642, mode rc, from ring_core_v3_w30.gds
.subckt ring_core VDD VSS vbn vctrl bit0 bit1 bit2 bit3 bit4 bitb0 bitb1 bitb2 bitb3 bitb4 vg a0 a1 a2 a3 a4
X0 vbn.t2 bitb0.t1 a_6156_6633# VDD.t2 pfet_03v3 ad=2.25p pd=10.9u as=2.25p ps=10.9u w=5u l=0.28u
X1 VSS.t12 vg.t48 VSS.t12 VSS.t11 nfet_03v3 ad=13.8195p pd=62.32u as=0 ps=0 w=30.71u l=4u
X2 vg.t37 a_6006_896# VSS.t57 VSS.t5 nfet_03v3 ad=0.336p pd=1.76u as=0.336p ps=1.76u w=1.2u l=5.335u
X3 vg.t16 a_6896_6633# VSS.t37 VSS.t5 nfet_03v3 ad=0.336p pd=1.76u as=0.336p ps=1.76u w=1.2u l=5.335u
X4 VSS.t33 vbn.t10 vg.t14 VSS.t3 nfet_03v3 ad=0.336p pd=1.76u as=0.336p ps=1.76u w=1.2u l=5.335u
X5 a_6006_4704# bitb2.t0 VSS.t35 VSS.t34 nfet_03v3 ad=0.45p pd=2.9u as=0.45p ps=2.9u w=1u l=0.28u
X6 a3.t1 a2.t3 VDD.t9 VDD.t8 pfet_03v3 ad=2.25p pd=10.9u as=2.25p ps=10.9u w=5u l=0.28u
X7 vg.t42 vbn.t15 VSS.t26 VSS.t5 nfet_03v3 ad=0.336p pd=1.76u as=0.336p ps=1.76u w=1.2u l=5.335u
X8 vg.t32 a_6006_14# VSS.t42 VSS.t5 nfet_03v3 ad=0.336p pd=1.76u as=0.336p ps=1.76u w=1.2u l=5.335u
X9 vg.t22 a_6006_14# VSS.t52 VSS.t5 nfet_03v3 ad=0.336p pd=1.76u as=0.336p ps=1.76u w=1.2u l=5.335u
X10 a4.t0 a3.t3 VDD.t4 VDD.t3 pfet_03v3 ad=2.25p pd=10.9u as=2.25p ps=10.9u w=5u l=0.28u
X11 vbn.t8 bit1.t0 a_6896_6633# VSS.t75 nfet_03v3 ad=0.9p pd=4.9u as=0.9p ps=4.9u w=2u l=0.28u
X12 vg.t5 a_6156_6633# VSS.t10 VSS.t9 nfet_03v3 ad=0.336p pd=1.76u as=0.54p ps=3.3u w=1.2u l=5.335u
X13 vg.t28 a_6006_14# VSS.t46 VSS.t1 nfet_03v3 ad=0.336p pd=1.76u as=0.54p ps=3.3u w=1.2u l=5.335u
X14 vbn.t6 bitb4.t1 a_6006_14# VDD.t6 pfet_03v3 ad=2.25p pd=10.9u as=2.25p ps=10.9u w=5u l=0.28u
X15 VSS.t16 vg.t46 VSS.t16 VSS.t15 nfet_03v3 ad=8.5988p pd=31.27u as=0 ps=0 w=30.71u l=4u
X16 vg.t39 a_6006_896# VSS.t56 VSS.t1 nfet_03v3 ad=0.336p pd=1.76u as=0.54p ps=3.3u w=1.2u l=5.335u
X17 vg.t40 a_6006_896# VSS.t60 VSS.t1 nfet_03v3 ad=0.336p pd=1.76u as=0.54p ps=3.3u w=1.2u l=5.335u
X18 vg.t10 a4.t2 a0.t0 VSS.t0 nfet_03v3 ad=0.9p pd=4.9u as=0.9p ps=4.9u w=2u l=0.28u
X19 a_6006_896# bitb3.t0 VSS.t73 VSS.t72 nfet_03v3 ad=0.45p pd=2.9u as=0.45p ps=2.9u w=1u l=0.28u
X20 VSS.t58 a_6006_896# vg.t35 VSS.t3 nfet_03v3 ad=0.336p pd=1.76u as=0.336p ps=1.76u w=1.2u l=5.335u
X21 vbn.t7 bit2.t0 a_6006_4704# VSS.t74 nfet_03v3 ad=0.9p pd=4.9u as=0.9p ps=4.9u w=2u l=0.28u
X22 VSS.t18 vg.t45 VSS.t18 VSS.t17 nfet_03v3 ad=8.5988p pd=31.27u as=0 ps=0 w=30.71u l=4u
X23 VSS.t4 a_6006_4704# vg.t1 VSS.t3 nfet_03v3 ad=0.336p pd=1.76u as=0.336p ps=1.76u w=1.2u l=5.335u
X24 VSS.t49 a_6006_14# vg.t24 VSS.t3 nfet_03v3 ad=0.336p pd=1.76u as=0.336p ps=1.76u w=1.2u l=5.335u
X25 VSS.t61 a_6006_896# vg.t33 VSS.t27 nfet_03v3 ad=0.336p pd=1.76u as=0.336p ps=1.76u w=1.2u l=5.335u
X26 VSS.t20 vg.t44 VSS.t20 VSS.t19 nfet_03v3 ad=8.5988p pd=31.27u as=0 ps=0 w=30.71u l=4u
X27 vg.t0 a_6006_4704# VSS.t2 VSS.t1 nfet_03v3 ad=0.336p pd=1.76u as=0.54p ps=3.3u w=1.2u l=5.335u
X28 vg.t18 a_6006_14# VSS.t41 VSS.t1 nfet_03v3 ad=0.336p pd=1.76u as=0.54p ps=3.3u w=1.2u l=5.335u
X29 vg.t27 a_6006_14# VSS.t47 VSS.t29 nfet_03v3 ad=0.336p pd=1.76u as=0.336p ps=1.76u w=1.2u l=5.335u
X30 a2.t0 a1.t2 vg.t12 VSS.t71 nfet_03v3 ad=0.9p pd=4.9u as=0.9p ps=4.9u w=2u l=0.28u
X31 VSS.t14 vg.t47 VSS.t14 VSS.t13 nfet_03v3 ad=8.5988p pd=31.27u as=0 ps=0 w=30.71u l=4u
X32 VSS.t36 a_6896_6633# vg.t15 VSS.t3 nfet_03v3 ad=0.336p pd=1.76u as=0.336p ps=1.76u w=1.2u l=5.335u
X33 vg.t6 vbn.t13 VSS.t30 VSS.t29 nfet_03v3 ad=0.336p pd=1.76u as=0.336p ps=1.76u w=1.2u l=5.335u
X34 vg.t8 vbn.t11 VSS.t32 VSS.t29 nfet_03v3 ad=0.336p pd=1.76u as=0.336p ps=1.76u w=1.2u l=5.335u
X35 vg.t23 a_6006_14# VSS.t51 VSS.t1 nfet_03v3 ad=0.336p pd=1.76u as=0.54p ps=3.3u w=1.2u l=5.335u
X36 VSS.t39 a_6006_14# vg.t19 VSS.t3 nfet_03v3 ad=0.336p pd=1.76u as=0.336p ps=1.76u w=1.2u l=5.335u
X37 VSS.t69 vctrl.t0 vg.t41 VSS.t3 nfet_03v3 ad=0.54p pd=3.3u as=0.336p ps=1.76u w=1.2u l=21.335u
X38 vbn.t1 bitb1.t1 a_6896_6633# VDD.t7 pfet_03v3 ad=2.25p pd=10.9u as=2.25p ps=10.9u w=5u l=0.28u
X39 vbn.t5 bit3.t0 a_6006_896# VSS.t68 nfet_03v3 ad=0.9p pd=4.9u as=0.9p ps=4.9u w=2u l=0.28u
X40 vg.t17 a_6006_14# VSS.t43 VSS.t29 nfet_03v3 ad=0.336p pd=1.76u as=0.336p ps=1.76u w=1.2u l=5.335u
X41 VDD.t1 a4.t3 a0.t1 VDD.t0 pfet_03v3 ad=2.25p pd=10.9u as=2.25p ps=10.9u w=5u l=0.28u
X42 a_6156_6633# bitb0.t0 VSS.t24 VSS.t23 nfet_03v3 ad=0.45p pd=2.9u as=0.45p ps=2.9u w=1u l=0.28u
X43 vg.t34 a_6006_896# VSS.t54 VSS.t29 nfet_03v3 ad=0.336p pd=1.76u as=0.336p ps=1.76u w=1.2u l=5.335u
X44 vbn.t0 bitb2.t1 a_6006_4704# VDD.t5 pfet_03v3 ad=2.25p pd=10.9u as=2.25p ps=10.9u w=5u l=0.28u
X45 a_6896_6633# bitb1.t0 VSS.t65 VSS.t64 nfet_03v3 ad=0.45p pd=2.9u as=0.45p ps=2.9u w=1u l=0.28u
X46 VSS.t59 a_6006_896# vg.t36 VSS.t7 nfet_03v3 ad=0.54p pd=3.3u as=0.336p ps=1.76u w=1.2u l=5.335u
X47 a2.t1 a1.t3 VDD.t13 VDD.t12 pfet_03v3 ad=2.25p pd=10.9u as=2.25p ps=10.9u w=5u l=0.28u
X48 VSS.t50 a_6006_14# vg.t25 VSS.t7 nfet_03v3 ad=0.54p pd=3.3u as=0.336p ps=1.76u w=1.2u l=5.335u
X49 a_6006_14# bitb4.t0 VSS.t63 VSS.t62 nfet_03v3 ad=0.45p pd=2.9u as=0.45p ps=2.9u w=1u l=0.28u
X50 VSS.t45 a_6006_14# vg.t20 VSS.t7 nfet_03v3 ad=0.54p pd=3.3u as=0.336p ps=1.76u w=1.2u l=5.335u
X51 a1.t0 a0.t2 vg.t9 VSS.t70 nfet_03v3 ad=0.9p pd=4.9u as=0.9p ps=4.9u w=2u l=0.28u
X52 VSS.t31 vbn.t12 vg.t4 VSS.t27 nfet_03v3 ad=0.336p pd=1.76u as=0.336p ps=1.76u w=1.2u l=5.335u
X53 vbn.t3 bitb3.t1 a_6006_896# VDD.t14 pfet_03v3 ad=2.25p pd=10.9u as=2.25p ps=10.9u w=5u l=0.28u
X54 vbn.t9 bit0.t0 a_6156_6633# VSS.t76 nfet_03v3 ad=0.9p pd=4.9u as=0.9p ps=4.9u w=2u l=0.28u
X55 VSS.t44 a_6006_14# vg.t30 VSS.t27 nfet_03v3 ad=0.336p pd=1.76u as=0.336p ps=1.76u w=1.2u l=5.335u
X56 VSS.t48 a_6006_14# vg.t26 VSS.t27 nfet_03v3 ad=0.336p pd=1.76u as=0.336p ps=1.76u w=1.2u l=5.335u
X57 VSS.t55 a_6006_896# vg.t38 VSS.t7 nfet_03v3 ad=0.54p pd=3.3u as=0.336p ps=1.76u w=1.2u l=5.335u
X58 VSS.t40 a_6006_14# vg.t31 VSS.t7 nfet_03v3 ad=0.54p pd=3.3u as=0.336p ps=1.76u w=1.2u l=5.335u
X59 a3.t0 a2.t2 vg.t7 VSS.t66 nfet_03v3 ad=0.9p pd=4.9u as=0.9p ps=4.9u w=2u l=0.28u
X60 VSS.t8 a_6006_4704# vg.t3 VSS.t7 nfet_03v3 ad=0.54p pd=3.3u as=0.336p ps=1.76u w=1.2u l=5.335u
X61 VSS.t38 a_6006_14# vg.t21 VSS.t27 nfet_03v3 ad=0.336p pd=1.76u as=0.336p ps=1.76u w=1.2u l=5.335u
X62 VSS.t28 vbn.t14 vg.t13 VSS.t27 nfet_03v3 ad=0.336p pd=1.76u as=0.336p ps=1.76u w=1.2u l=5.335u
X63 a4.t1 a3.t2 vg.t11 VSS.t25 nfet_03v3 ad=0.9p pd=4.9u as=0.9p ps=4.9u w=2u l=0.28u
X64 vbn.t4 bit4.t0 a_6006_14# VSS.t67 nfet_03v3 ad=0.9p pd=4.9u as=0.9p ps=4.9u w=2u l=0.28u
X65 VSS.t22 vg.t43 VSS.t22 VSS.t21 nfet_03v3 ad=8.5988p pd=31.27u as=0 ps=0 w=30.71u l=4u
X66 a1.t1 a0.t3 VDD.t11 VDD.t10 pfet_03v3 ad=2.25p pd=10.9u as=2.25p ps=10.9u w=5u l=0.28u
X67 vg.t2 a_6006_4704# VSS.t6 VSS.t5 nfet_03v3 ad=0.336p pd=1.76u as=0.336p ps=1.76u w=1.2u l=5.335u
X68 vg.t29 a_6006_14# VSS.t53 VSS.t29 nfet_03v3 ad=0.336p pd=1.76u as=0.336p ps=1.76u w=1.2u l=5.335u
R0 vctrl vctrl.t0 33.6536
R1 vg.n18 vg.t48 28.0234
R2 vg.n22 vg.t47 28.0234
R3 vg.n30 vg.t46 28.0234
R4 vg.n37 vg.t45 28.0234
R5 vg.n40 vg.t44 28.0234
R6 vg.n47 vg.t43 28.0234
R7 vg.n18 vg.n17 21.9053
R8 vg.n22 vg.n10 21.9053
R9 vg.n23 vg.n22 21.9053
R10 vg.n30 vg.n8 21.9053
R11 vg.n30 vg.n29 21.9053
R12 vg.n38 vg.n37 21.9053
R13 vg.n41 vg.n40 21.9053
R14 vg.n47 vg.n46 21.9053
R15 vg.n69 vg.n68 14.5769
R16 vg.n52 vg.n50 10.4429
R17 vg.n58 vg.n56 10.4429
R18 vg.n64 vg.n62 10.4429
R19 vg.n72 vg.n70 10.4429
R20 vg.n78 vg.n76 10.4429
R21 vg.n84 vg.n82 10.4429
R22 vg.n31 vg.n30 8.0005
R23 vg.n22 vg.n13 8.0005
R24 vg.n54 vg.n53 7.6505
R25 vg.n52 vg.n51 7.6505
R26 vg.n60 vg.n59 7.6505
R27 vg.n58 vg.n57 7.6505
R28 vg.n66 vg.n65 7.6505
R29 vg.n64 vg.n63 7.6505
R30 vg.n74 vg.n73 7.6505
R31 vg.n72 vg.n71 7.6505
R32 vg.n80 vg.n79 7.6505
R33 vg.n78 vg.n77 7.6505
R34 vg.n86 vg.n85 7.6505
R35 vg.n84 vg.n83 7.6505
R36 vg.n55 vg.n49 6.50698
R37 vg.n55 vg.n54 6.02932
R38 vg.n61 vg.n60 6.02932
R39 vg.n67 vg.n66 6.02932
R40 vg.n75 vg.n74 6.02932
R41 vg.n81 vg.n80 6.02932
R42 vg.n87 vg.n86 6.02932
R43 vg.n48 vg.n47 5.8476
R44 vg.n19 vg.n18 5.8468
R45 vg.n40 vg.n2 5.8468
R46 vg.n37 vg.n36 5.8468
R47 vg.n54 vg.n52 2.79287
R48 vg.n60 vg.n58 2.79287
R49 vg.n66 vg.n64 2.79287
R50 vg.n74 vg.n72 2.79287
R51 vg.n80 vg.n78 2.79287
R52 vg.n86 vg.n84 2.79287
R53 vg.n5 vg.t7 2.71814
R54 vg.n28 vg.t11 2.71814
R55 vg.n12 vg.t12 2.71814
R56 vg.n21 vg.t10 2.71814
R57 vg.n15 vg.t9 2.71814
R58 vg.n17 vg.n16 2.4215
R59 vg.n49 vg.n48 2.30143
R60 vg.n16 vg.n14 2.2505
R61 vg.n20 vg.n11 2.2505
R62 vg.n25 vg.n24 2.2505
R63 vg.n27 vg.n26 2.2505
R64 vg.n9 vg.n7 2.2505
R65 vg.n33 vg.n32 2.2505
R66 vg.n35 vg.n34 2.2505
R67 vg.n6 vg.n4 2.2505
R68 vg.n39 vg.n3 2.2505
R69 vg.n43 vg.n42 2.2505
R70 vg.n45 vg.n44 2.2505
R71 vg.n1 vg.n0 2.2505
R72 vg.n53 vg.t21 1.4705
R73 vg.n53 vg.t0 1.4705
R74 vg.n51 vg.t19 1.4705
R75 vg.n51 vg.t42 1.4705
R76 vg.n50 vg.t31 1.4705
R77 vg.n50 vg.t34 1.4705
R78 vg.n59 vg.t13 1.4705
R79 vg.n59 vg.t18 1.4705
R80 vg.n57 vg.t15 1.4705
R81 vg.n57 vg.t32 1.4705
R82 vg.n56 vg.t38 1.4705
R83 vg.n56 vg.t17 1.4705
R84 vg.n65 vg.t30 1.4705
R85 vg.n65 vg.t39 1.4705
R86 vg.n63 vg.t1 1.4705
R87 vg.n63 vg.t37 1.4705
R88 vg.n62 vg.t20 1.4705
R89 vg.n62 vg.t6 1.4705
R90 vg.n68 vg.t41 1.4705
R91 vg.n68 vg.t5 1.4705
R92 vg.n73 vg.t4 1.4705
R93 vg.n73 vg.t28 1.4705
R94 vg.n71 vg.t35 1.4705
R95 vg.n71 vg.t2 1.4705
R96 vg.n70 vg.t36 1.4705
R97 vg.n70 vg.t27 1.4705
R98 vg.n79 vg.t26 1.4705
R99 vg.n79 vg.t40 1.4705
R100 vg.n77 vg.t24 1.4705
R101 vg.n77 vg.t16 1.4705
R102 vg.n76 vg.t25 1.4705
R103 vg.n76 vg.t8 1.4705
R104 vg.n85 vg.t33 1.4705
R105 vg.n85 vg.t23 1.4705
R106 vg.n83 vg.t14 1.4705
R107 vg.n83 vg.t22 1.4705
R108 vg.n82 vg.t3 1.4705
R109 vg.n82 vg.t29 1.4705
R110 vg.n75 vg.n69 1.30076
R111 vg.n67 vg.n61 1.13971
R112 vg.n87 vg.n81 1.13971
R113 vg vg.n87 1.10182
R114 vg.n61 vg.n55 0.658921
R115 vg.n69 vg.n67 0.658921
R116 vg.n81 vg.n75 0.658921
R117 vg.n49 vg.n0 0.1205
R118 vg.n44 vg.n0 0.1205
R119 vg.n44 vg.n43 0.1205
R120 vg.n43 vg.n3 0.1205
R121 vg.n6 vg.n3 0.1205
R122 vg.n34 vg.n6 0.1205
R123 vg.n34 vg.n33 0.1205
R124 vg.n33 vg.n7 0.1205
R125 vg.n26 vg.n7 0.1205
R126 vg.n26 vg.n25 0.1205
R127 vg.n25 vg.n11 0.1205
R128 vg.n16 vg.n11 0.1205
R129 vg.n28 vg.n27 0.1094
R130 vg.n46 vg.n45 0.0995
R131 vg.n20 vg.n19 0.0986122
R132 vg.n35 vg.n5 0.0956
R133 vg.n36 vg.n35 0.0854122
R134 vg.n45 vg.n2 0.0842122
R135 vg.n31 vg.n9 0.0707
R136 vg.n48 vg.n1 0.0704143
R137 vg.n21 vg.n20 0.068
R138 vg.n41 vg.n39 0.0659
R139 vg.n39 vg.n38 0.0647
R140 vg.n38 vg.n4 0.0563
R141 vg.n42 vg.n41 0.0551
R142 vg.n32 vg.n31 0.0503
R143 vg.n15 vg.n14 0.0416
R144 vg.n42 vg.n2 0.0376149
R145 vg.n24 vg.n13 0.0371
R146 vg.n13 vg.n12 0.0368
R147 vg.n36 vg.n4 0.0364149
R148 vg.n12 vg.n10 0.0362
R149 vg.n24 vg.n23 0.0359
R150 vg.n17 vg.n15 0.0284
R151 vg.n19 vg.n14 0.0232149
R152 vg.n32 vg.n8 0.0227
R153 vg.n46 vg.n1 0.0215
R154 vg.n23 vg.n21 0.0176
R155 vg.n27 vg.n10 0.0119
R156 vg.n29 vg.n28 0.0098
R157 vg.n8 vg.n5 0.0032
R158 vg.n29 vg.n9 0.0023
R159 bit4 bit4.t0 74.3752
R160 bit3 bit3.t0 74.3752
R161 bit2 bit2.t0 74.3752
R162 bit1 bit1.t0 74.3752
R163 bit0 bit0.t0 74.3752
R164 vbn.n10 vbn.t12 38.1796
R165 vbn.n13 vbn.t15 36.9444
R166 vbn.n9 vbn.t11 33.1076
R167 vbn.n11 vbn.t14 32.969
R168 vbn.n11 vbn.t13 32.5581
R169 vbn.n9 vbn.t10 31.0482
R170 vbn.n14 vbn.n13 8.26866
R171 vbn.n10 vbn.n9 6.13708
R172 vbn.n2 vbn.n0 6.08497
R173 vbn.n2 vbn.n1 5.20866
R174 vbn.n4 vbn.n3 5.20866
R175 vbn.n6 vbn.n5 5.20866
R176 vbn.n8 vbn.n7 5.20866
R177 vbn.n12 vbn.n11 4.5005
R178 vbn vbn.n14 4.25418
R179 vbn.n0 vbn.t9 3.71525
R180 vbn.n1 vbn.t8 3.71525
R181 vbn.n3 vbn.t7 3.71525
R182 vbn.n5 vbn.t5 3.71525
R183 vbn.n7 vbn.t4 3.71525
R184 vbn.n12 vbn.n10 2.28129
R185 vbn.n13 vbn.n12 1.63708
R186 vbn.n0 vbn.t2 0.8915
R187 vbn.n1 vbn.t1 0.8915
R188 vbn.n3 vbn.t0 0.8915
R189 vbn.n5 vbn.t3 0.8915
R190 vbn.n7 vbn.t6 0.8915
R191 vbn.n8 vbn.n6 0.876816
R192 vbn.n6 vbn.n4 0.876816
R193 vbn.n4 vbn.n2 0.876816
R194 vbn.n14 vbn.n8 0.378263
R195 bitb4.n0 bitb4.t1 110.341
R196 bitb4.n0 bitb4.t0 57.8015
R197 bitb4 bitb4.n0 11.5572
R198 bitb3.n0 bitb3.t1 110.341
R199 bitb3.n0 bitb3.t0 57.8015
R200 bitb3 bitb3.n0 11.5572
R201 bitb2.n0 bitb2.t1 110.341
R202 bitb2.n0 bitb2.t0 57.8015
R203 bitb2 bitb2.n0 11.5572
R204 bitb1.n0 bitb1.t1 110.341
R205 bitb1.n0 bitb1.t0 57.8015
R206 bitb1 bitb1.n0 11.5572
R207 bitb0.n0 bitb0.t1 110.341
R208 bitb0.n0 bitb0.t0 57.8015
R209 bitb0 bitb0.n0 11.5572
R210 a2.n0 a2.t3 101.66
R211 a2.n0 a2.t2 62.8185
R212 a2 a2.n0 5.05471
R213 a2 a2.n1 4.92563
R214 a2.n1 a2.t0 3.12196
R215 a2.n1 a2.t1 1.48479
R216 a3.n1 a3.t3 101.925
R217 a3.n1 a3.t2 62.5532
R218 a3 a3.n1 5.07839
R219 a3 a3.n0 4.99905
R220 a3.n0 a3.t0 2.64828
R221 a3.n0 a3.t1 1.95847
R222 a1.n0 a1.t3 101.925
R223 a1.n0 a1.t2 62.5532
R224 a1 a1.n0 5.1376
R225 a1 a1.n1 5.00853
R226 a1.n1 a1.t0 2.64828
R227 a1.n1 a1.t1 1.95847
R228 a4.n1 a4.t3 101.793
R229 a4.n1 a4.t2 62.6858
R230 a4 a4.n0 5.08195
R231 a4 a4.n1 5.05708
R232 a4.n0 a4.t1 2.88512
R233 a4.n0 a4.t0 1.72163
R234 a0.n1 a0.t3 101.793
R235 a0.n1 a0.t2 62.6858
R236 a0.n2 a0.n0 5.37563
R237 a0.n2 a0.n1 4.5005
R238 a0.n0 a0.t0 2.88512
R239 a0.n0 a0.t1 1.72163
R240 a0 a0.n2 0.656553
R241 VDD.n16 VDD.t8 1270.39
R242 VDD.n14 VDD.n13 927.096
R243 VDD.n16 VDD.t2 848.045
R244 VDD.t6 VDD.t14 413.409
R245 VDD.t14 VDD.t5 413.409
R246 VDD.t5 VDD.t7 413.409
R247 VDD.t7 VDD.t2 413.409
R248 VDD.n17 VDD.n9 402.039
R249 VDD.n17 VDD.n10 402.039
R250 VDD.t0 VDD.t10 335.197
R251 VDD.t12 VDD.t0 324.022
R252 VDD.t8 VDD.t3 290.503
R253 VDD.t3 VDD.t12 290.503
R254 VDD.n12 VDD.t6 207.821
R255 VDD.t10 VDD.n15 198.883
R256 VDD.n12 VDD.n9 6.3005
R257 VDD.n15 VDD.n10 6.3005
R258 VDD.n11 VDD.n9 5.69302
R259 VDD.n10 VDD.n1 5.69302
R260 VDD.n39 VDD.t11 1.71571
R261 VDD.n33 VDD.t1 1.71571
R262 VDD.n32 VDD.t13 1.71571
R263 VDD.n30 VDD.t4 1.71571
R264 VDD.n4 VDD.t9 1.71571
R265 VDD VDD.n41 1.55338
R266 VDD.n40 VDD.n0 1.5005
R267 VDD.n38 VDD.n37 1.5005
R268 VDD.n36 VDD.n2 1.5005
R269 VDD.n35 VDD.n34 1.5005
R270 VDD.n31 VDD.n3 1.5005
R271 VDD.n29 VDD.n28 1.5005
R272 VDD.n27 VDD.n26 1.5005
R273 VDD.n25 VDD.n5 1.5005
R274 VDD.n24 VDD.n23 1.5005
R275 VDD.n22 VDD.n6 1.5005
R276 VDD.n21 VDD.n20 1.5005
R277 VDD.n19 VDD.n7 1.5005
R278 VDD.n14 VDD.n1 0.996766
R279 VDD.n13 VDD.n11 0.996766
R280 VDD.n11 VDD.n8 0.496987
R281 VDD.n15 VDD.n14 0.371088
R282 VDD.n13 VDD.n12 0.371088
R283 VDD.n8 VDD.n7 0.284343
R284 VDD.n18 VDD.n8 0.232406
R285 VDD.n41 VDD.n1 0.0915242
R286 VDD.n20 VDD.n19 0.0755
R287 VDD.n20 VDD.n6 0.0755
R288 VDD.n24 VDD.n6 0.0755
R289 VDD.n25 VDD.n24 0.0755
R290 VDD.n26 VDD.n25 0.0755
R291 VDD.n38 VDD.n2 0.0755
R292 VDD.n21 VDD.n7 0.0755
R293 VDD.n22 VDD.n21 0.0755
R294 VDD.n23 VDD.n22 0.0755
R295 VDD.n23 VDD.n5 0.0755
R296 VDD.n27 VDD.n5 0.0755
R297 VDD.n28 VDD.n27 0.0755
R298 VDD.n28 VDD.n3 0.0755
R299 VDD.n35 VDD.n3 0.0755
R300 VDD.n36 VDD.n35 0.0755
R301 VDD.n37 VDD.n36 0.0755
R302 VDD.n37 VDD.n0 0.0755
R303 VDD.n34 VDD.n33 0.0738125
R304 VDD.n32 VDD.n31 0.0704375
R305 VDD.n39 VDD.n38 0.0666875
R306 VDD.n18 VDD.n17 0.0622647
R307 VDD.n17 VDD.n16 0.0622647
R308 VDD VDD.n0 0.054875
R309 VDD.n29 VDD.n4 0.0505625
R310 VDD.n30 VDD.n29 0.0479375
R311 VDD.n41 VDD.n40 0.04325
R312 VDD.n19 VDD.n18 0.042125
R313 VDD.n31 VDD.n30 0.0280625
R314 VDD.n26 VDD.n4 0.0254375
R315 VDD.n40 VDD.n39 0.0093125
R316 VDD.n34 VDD.n32 0.0055625
R317 VDD.n33 VDD.n2 0.0021875
R318 VSS.n136 VSS.n135 34334.5
R319 VSS.n135 VSS.n134 19311.7
R320 VSS.n136 VSS.n4 15309.2
R321 VSS.n134 VSS.n7 2286.63
R322 VSS.n57 VSS.n3 627.33
R323 VSS.n140 VSS.n3 627.33
R324 VSS.n7 VSS.n5 627.33
R325 VSS.n137 VSS.n5 627.33
R326 VSS.t29 VSS.t3 482.043
R327 VSS.n137 VSS.n136 475.327
R328 VSS.t23 VSS.t21 440.748
R329 VSS.n138 VSS.n137 432.067
R330 VSS.n55 VSS.n7 432.067
R331 VSS.t21 VSS.t19 372.877
R332 VSS.t19 VSS.t17 372.877
R333 VSS.n56 VSS.t7 370.425
R334 VSS.n134 VSS.t7 325.86
R335 VSS.t3 VSS.t67 278.022
R336 VSS.t70 VSS.n4 251.038
R337 VSS.t17 VSS.t66 237.954
R338 VSS.t0 VSS.t11 218.329
R339 VSS.t25 VSS.t71 212.606
R340 VSS.t72 VSS.t74 176.626
R341 VSS.n134 VSS.t29 156.184
R342 VSS.t13 VSS.t0 154.548
R343 VSS.t66 VSS.t15 134.923
R344 VSS.t64 VSS.t1 134.514
R345 VSS.t34 VSS.t9 127.154
R346 VSS.t68 VSS.t72 125.928
R347 VSS.t75 VSS.t64 125.928
R348 VSS.t76 VSS.t23 125.928
R349 VSS.n133 VSS.t62 110.8
R350 VSS.t5 VSS.t68 98.5349
R351 VSS.t71 VSS.t13 82.5895
R352 VSS.t74 VSS.t27 80.9541
R353 VSS.t62 VSS.t5 78.0921
R354 VSS.t15 VSS.t25 77.6832
R355 VSS.t9 VSS.t75 49.4721
R356 VSS.t27 VSS.t34 44.9747
R357 VSS.n18 VSS.t76 38.0241
R358 VSS.n139 VSS.n4 37.6164
R359 VSS.t11 VSS.t70 26.985
R360 VSS.t67 VSS.n133 15.1282
R361 VSS.n53 VSS.n52 7.85935
R362 VSS.n52 VSS.n6 7.85935
R363 VSS.n8 VSS.t63 6.08947
R364 VSS.n25 VSS.t73 6.08947
R365 VSS.n26 VSS.t35 6.08947
R366 VSS.n27 VSS.t65 6.08947
R367 VSS.n28 VSS.t24 6.08947
R368 VSS.n15 VSS.t45 5.72359
R369 VSS.n6 VSS.n2 5.41204
R370 VSS.n54 VSS.n53 5.41204
R371 VSS.n53 VSS.n7 5.2005
R372 VSS.n137 VSS.n6 5.2005
R373 VSS.n141 VSS.n140 5.2005
R374 VSS.n58 VSS.n57 5.2005
R375 VSS.n141 VSS.n2 5.17896
R376 VSS.n58 VSS.n54 5.17896
R377 VSS.n140 VSS.n139 5.13853
R378 VSS.n57 VSS.n56 5.13853
R379 VSS.n37 VSS.t56 4.82596
R380 VSS.n11 VSS.t55 4.82596
R381 VSS.n11 VSS.t40 4.82596
R382 VSS.n32 VSS.t41 4.82596
R383 VSS.n32 VSS.t2 4.82596
R384 VSS.n36 VSS.t10 4.82596
R385 VSS.n15 VSS.t69 4.82596
R386 VSS.n21 VSS.t50 4.82596
R387 VSS.n21 VSS.t59 4.82596
R388 VSS.n130 VSS.t60 4.82596
R389 VSS.n130 VSS.t46 4.82596
R390 VSS.n60 VSS.t8 4.75491
R391 VSS.n87 VSS.t51 4.75491
R392 VSS.t1 VSS.n18 4.08906
R393 VSS.n127 VSS.t22 3.88323
R394 VSS.t12 VSS.n1 3.88323
R395 VSS.n121 VSS.n92 3.82887
R396 VSS.n95 VSS.n93 3.82887
R397 VSS.n114 VSS.n96 3.82887
R398 VSS.n108 VSS.n99 3.82887
R399 VSS.n101 VSS.n100 3.82887
R400 VSS.n16 VSS.n14 3.43471
R401 VSS.n35 VSS.n34 3.43471
R402 VSS.n12 VSS.n9 3.43471
R403 VSS.n12 VSS.n10 3.43471
R404 VSS.n31 VSS.n29 3.43471
R405 VSS.n31 VSS.n30 3.43471
R406 VSS.n22 VSS.n19 3.43471
R407 VSS.n22 VSS.n20 3.43471
R408 VSS.n131 VSS.n23 3.43471
R409 VSS.n131 VSS.n24 3.43471
R410 VSS.n48 VSS.n47 3.36366
R411 VSS.n78 VSS.n44 3.36366
R412 VSS.n12 VSS.n11 2.78932
R413 VSS.n32 VSS.n31 2.78932
R414 VSS.n22 VSS.n21 2.78932
R415 VSS.n131 VSS.n130 2.78932
R416 VSS.n16 VSS.n15 1.89168
R417 VSS.n36 VSS.n35 1.89168
R418 VSS.n129 VSS.n38 1.86918
R419 VSS.n38 VSS.n33 1.70813
R420 VSS.n129 VSS.n128 1.63708
R421 VSS.n59 VSS.n51 1.5755
R422 VSS.n13 VSS.n12 1.54826
R423 VSS.n17 VSS.n16 1.54826
R424 VSS.n132 VSS.n22 1.54826
R425 VSS.n33 VSS.n28 1.54471
R426 VSS VSS.n142 1.52112
R427 VSS.n61 VSS.n51 1.5005
R428 VSS.n63 VSS.n62 1.5005
R429 VSS.n64 VSS.n50 1.5005
R430 VSS.n66 VSS.n65 1.5005
R431 VSS.n67 VSS.n49 1.5005
R432 VSS.n69 VSS.n68 1.5005
R433 VSS.n71 VSS.n70 1.5005
R434 VSS.n72 VSS.n46 1.5005
R435 VSS.n74 VSS.n73 1.5005
R436 VSS.n75 VSS.n45 1.5005
R437 VSS.n77 VSS.n76 1.5005
R438 VSS.n79 VSS.n43 1.5005
R439 VSS.n81 VSS.n80 1.5005
R440 VSS.n82 VSS.n42 1.5005
R441 VSS.n84 VSS.n83 1.5005
R442 VSS.n85 VSS.n41 1.5005
R443 VSS.n89 VSS.n88 1.5005
R444 VSS.n90 VSS.n39 1.5005
R445 VSS.n126 VSS.n125 1.5005
R446 VSS.n124 VSS.n40 1.5005
R447 VSS.n123 VSS.n122 1.5005
R448 VSS.n120 VSS.n91 1.5005
R449 VSS.n119 VSS.n118 1.5005
R450 VSS.n117 VSS.n116 1.5005
R451 VSS.n115 VSS.n94 1.5005
R452 VSS.n113 VSS.n112 1.5005
R453 VSS.n111 VSS.n97 1.5005
R454 VSS.n110 VSS.n109 1.5005
R455 VSS.n107 VSS.n98 1.5005
R456 VSS.n106 VSS.n105 1.5005
R457 VSS.n104 VSS.n103 1.5005
R458 VSS.n102 VSS.n0 1.5005
R459 VSS.n47 VSS.t53 1.4705
R460 VSS.n47 VSS.t33 1.4705
R461 VSS.n44 VSS.t52 1.4705
R462 VSS.n44 VSS.t61 1.4705
R463 VSS.n14 VSS.t30 1.4705
R464 VSS.n14 VSS.t4 1.4705
R465 VSS.n34 VSS.t57 1.4705
R466 VSS.n34 VSS.t44 1.4705
R467 VSS.n10 VSS.t43 1.4705
R468 VSS.n10 VSS.t36 1.4705
R469 VSS.n9 VSS.t54 1.4705
R470 VSS.n9 VSS.t39 1.4705
R471 VSS.n30 VSS.t42 1.4705
R472 VSS.n30 VSS.t28 1.4705
R473 VSS.n29 VSS.t26 1.4705
R474 VSS.n29 VSS.t38 1.4705
R475 VSS.n20 VSS.t32 1.4705
R476 VSS.n20 VSS.t49 1.4705
R477 VSS.n19 VSS.t47 1.4705
R478 VSS.n19 VSS.t58 1.4705
R479 VSS.n24 VSS.t37 1.4705
R480 VSS.n24 VSS.t48 1.4705
R481 VSS.n23 VSS.t6 1.4705
R482 VSS.n23 VSS.t31 1.4705
R483 VSS.n31 VSS.n13 1.24511
R484 VSS.n35 VSS.n17 1.24511
R485 VSS.n132 VSS.n131 1.24511
R486 VSS.n37 VSS.n36 0.898132
R487 VSS.n25 VSS.n8 0.876816
R488 VSS.n26 VSS.n25 0.876816
R489 VSS.n27 VSS.n26 0.876816
R490 VSS.n28 VSS.n27 0.876816
R491 VSS.n133 VSS.n8 0.550675
R492 VSS.n33 VSS.n32 0.302474
R493 VSS.n38 VSS.n37 0.302474
R494 VSS.n130 VSS.n129 0.302474
R495 VSS.n133 VSS.n17 0.133833
R496 VSS.n133 VSS.n13 0.133833
R497 VSS.n133 VSS.n132 0.133833
R498 VSS.n62 VSS.n61 0.0755
R499 VSS.n62 VSS.n50 0.0755
R500 VSS.n66 VSS.n50 0.0755
R501 VSS.n67 VSS.n66 0.0755
R502 VSS.n68 VSS.n67 0.0755
R503 VSS.n72 VSS.n71 0.0755
R504 VSS.n73 VSS.n72 0.0755
R505 VSS.n73 VSS.n45 0.0755
R506 VSS.n77 VSS.n45 0.0755
R507 VSS.n80 VSS.n79 0.0755
R508 VSS.n80 VSS.n42 0.0755
R509 VSS.n84 VSS.n42 0.0755
R510 VSS.n85 VSS.n84 0.0755
R511 VSS.n126 VSS.n40 0.0755
R512 VSS.n122 VSS.n40 0.0755
R513 VSS.n120 VSS.n119 0.0755
R514 VSS.n116 VSS.n115 0.0755
R515 VSS.n113 VSS.n97 0.0755
R516 VSS.n109 VSS.n97 0.0755
R517 VSS.n107 VSS.n106 0.0755
R518 VSS.n103 VSS.n102 0.0755
R519 VSS.n63 VSS.n51 0.0755
R520 VSS.n64 VSS.n63 0.0755
R521 VSS.n65 VSS.n64 0.0755
R522 VSS.n65 VSS.n49 0.0755
R523 VSS.n69 VSS.n49 0.0755
R524 VSS.n70 VSS.n69 0.0755
R525 VSS.n70 VSS.n46 0.0755
R526 VSS.n74 VSS.n46 0.0755
R527 VSS.n75 VSS.n74 0.0755
R528 VSS.n76 VSS.n75 0.0755
R529 VSS.n76 VSS.n43 0.0755
R530 VSS.n81 VSS.n43 0.0755
R531 VSS.n82 VSS.n81 0.0755
R532 VSS.n83 VSS.n82 0.0755
R533 VSS.n83 VSS.n41 0.0755
R534 VSS.n89 VSS.n41 0.0755
R535 VSS.n90 VSS.n89 0.0755
R536 VSS.n125 VSS.n90 0.0755
R537 VSS.n125 VSS.n124 0.0755
R538 VSS.n124 VSS.n123 0.0755
R539 VSS.n123 VSS.n91 0.0755
R540 VSS.n118 VSS.n91 0.0755
R541 VSS.n118 VSS.n117 0.0755
R542 VSS.n117 VSS.n94 0.0755
R543 VSS.n112 VSS.n94 0.0755
R544 VSS.n112 VSS.n111 0.0755
R545 VSS.n111 VSS.n110 0.0755
R546 VSS.n110 VSS.n98 0.0755
R547 VSS.n105 VSS.n98 0.0755
R548 VSS.n105 VSS.n104 0.0755
R549 VSS.n104 VSS.n0 0.0755
R550 VSS.n78 VSS.n77 0.07325
R551 VSS.n71 VSS.n48 0.069875
R552 VSS.n108 VSS.n107 0.068375
R553 VSS.n88 VSS.n87 0.0648125
R554 VSS.n115 VSS.n114 0.061625
R555 VSS.n61 VSS.n60 0.0614375
R556 VSS.n92 VSS.t22 0.0579406
R557 VSS.t20 VSS.n92 0.0579406
R558 VSS.n95 VSS.t20 0.0579406
R559 VSS.t18 VSS.n95 0.0579406
R560 VSS.n96 VSS.t18 0.0579406
R561 VSS.t16 VSS.n96 0.0579406
R562 VSS.n99 VSS.t16 0.0579406
R563 VSS.t14 VSS.n99 0.0579406
R564 VSS.n100 VSS.t14 0.0579406
R565 VSS.n100 VSS.t12 0.0579406
R566 VSS.n121 VSS.n120 0.056375
R567 VSS VSS.n0 0.054875
R568 VSS.n55 VSS.n54 0.0530253
R569 VSS.n138 VSS.n2 0.0530253
R570 VSS.n139 VSS.n138 0.0528943
R571 VSS.n56 VSS.n55 0.0528943
R572 VSS.n102 VSS.n1 0.0490625
R573 VSS.n103 VSS.n101 0.047375
R574 VSS.n59 VSS.n58 0.04625
R575 VSS.n88 VSS.n86 0.0441875
R576 VSS.n119 VSS.n93 0.040625
R577 VSS.n128 VSS.n39 0.037625
R578 VSS.n128 VSS.n127 0.0370625
R579 VSS.n52 VSS.n5 0.0368636
R580 VSS.n135 VSS.n5 0.0368636
R581 VSS.n86 VSS.n3 0.0368636
R582 VSS.n18 VSS.n3 0.0368636
R583 VSS.n116 VSS.n93 0.035375
R584 VSS.n142 VSS.n141 0.033875
R585 VSS.n86 VSS.n85 0.0318125
R586 VSS.n106 VSS.n101 0.028625
R587 VSS.n142 VSS.n1 0.0269375
R588 VSS.n122 VSS.n121 0.019625
R589 VSS.n60 VSS.n59 0.0145625
R590 VSS.n114 VSS.n113 0.014375
R591 VSS.n87 VSS.n39 0.0111875
R592 VSS.n109 VSS.n108 0.007625
R593 VSS.n68 VSS.n48 0.006125
R594 VSS.n79 VSS.n78 0.00275
R595 VSS.n127 VSS.n126 0.0018125
C0 bit1 bitb2 0.72283f
C1 a_6156_6633# a_6006_14# 0.21414f
C2 a_6156_6633# a_6896_6633# 0.51329f
C3 bit3 a_6006_4704# 0
C4 a2 a3 0.37174f
C5 bitb4 VDD 0.69452f
C6 bit0 a_6006_4704# 0
C7 VDD bit4 0.46603f
C8 a_6006_896# a_6006_4704# 4.47742f
C9 a0 vg 0.401f
C10 a_6156_6633# bitb0 0.21396f
C11 bitb1 bit1 0.3148f
C12 a1 VDD 1.2f
C13 bit2 a_6006_4704# 0.04998f
C14 bitb4 vbn 0.17851f
C15 a_6156_6633# VDD 0.25281f
C16 bitb2 a_6006_896# 0.00104f
C17 vctrl vg 1.00676f
C18 vbn bit4 0.71456f
C19 a_6006_14# a_6006_4704# 7.70065f
C20 bit1 vg 0
C21 bit3 bitb3 0.3148f
C22 a_6006_4704# a_6896_6633# 3.99805f
C23 bit2 bitb2 0.3148f
C24 a4 a1 0.39821f
C25 bit0 bitb1 0.72283f
C26 a_6156_6633# vbn 1.13433f
C27 bitb3 a_6006_896# 0.21489f
C28 a2 VDD 1.51352f
C29 bitb2 a_6006_14# 0
C30 bitb1 a_6006_896# 0
C31 bitb2 a_6896_6633# 0.00121f
C32 bitb0 a_6006_4704# 0
C33 bit0 bit1 0.02757f
C34 vctrl a_6006_896# 0.30122f
C35 bit2 bitb3 0.72283f
C36 bit1 a_6006_896# 0.00331f
C37 VDD a_6006_4704# 0.19338f
C38 bitb4 bit4 0.3148f
C39 bitb3 a_6006_14# 0
C40 a_6006_896# vg 3.0381f
C41 bit2 bit1 0.02757f
C42 bitb1 a_6006_14# 0
C43 bitb1 a_6896_6633# 0.21396f
C44 a4 a2 0.37969f
C45 vctrl a_6006_14# 0.19159f
C46 a3 vg 0.52938f
C47 bit1 a_6006_14# 0
C48 bitb2 VDD 0.69427f
C49 vctrl a_6896_6633# 0.04912f
C50 bit1 a_6896_6633# 0.04998f
C51 vbn a_6006_4704# 11.0326f
C52 bit3 a_6006_896# 0.05328f
C53 a_6006_14# vg 5.82374f
C54 bit0 a_6006_896# 0.00331f
C55 bitb1 bitb0 0.01415f
C56 a0 VDD 1.53853f
C57 a_6896_6633# vg 3.92746f
C58 bit2 bit3 0.02757f
C59 bitb3 VDD 0.69433f
C60 vbn bitb2 0.1755f
C61 bitb1 VDD 0.69427f
C62 bit3 a_6006_14# 0.00887f
C63 bit2 a_6006_896# 0.01215f
C64 bit0 a_6006_14# 0
C65 a2 a1 0.1528f
C66 bit1 VDD 0.39742f
C67 bit0 a_6896_6633# 0.00884f
C68 a_6006_14# a_6006_896# 8.81578f
C69 bitb4 a_6006_4704# 0
C70 bitb3 vbn 0.17647f
C71 a4 a0 0.16016f
C72 a_6006_896# a_6896_6633# 0.6087f
C73 VDD vg 0.42199f
C74 bitb1 vbn 0.1755f
C75 a_6006_4704# bit4 0
C76 bit2 a_6006_14# 0
C77 vctrl vbn 0.20136f
C78 bit0 bitb0 0.3148f
C79 bit1 vbn 0.19681f
C80 bitb0 a_6006_896# 0
C81 bit3 VDD 0.39755f
C82 a_6156_6633# a_6006_4704# 0.20544f
C83 a_6006_14# a_6896_6633# 1.30715f
C84 vbn vg 1.36982f
C85 bit0 VDD 0.40675f
C86 VDD a_6006_896# 0.19338f
C87 a4 vg 0.45933f
C88 bitb4 bitb3 0.01415f
C89 bitb0 a_6006_14# 0
C90 a3 VDD 1.30092f
C91 a1 a0 0.58969f
C92 bit3 vbn 0.19848f
C93 bit2 VDD 0.39745f
C94 bitb0 a_6896_6633# 0
C95 bit0 vbn 0.19018f
C96 vbn a_6006_896# 8.00858f
C97 VDD a_6006_14# 0.19338f
C98 VDD a_6896_6633# 0.19338f
C99 bitb1 a_6156_6633# 0.00121f
C100 bit2 vbn 0.19681f
C101 vctrl a_6156_6633# 3.22782f
C102 a4 a3 0.34397f
C103 a1 vg 0.52711f
C104 a2 a0 0.00356f
C105 bitb0 VDD 0.92049f
C106 vbn a_6006_14# 9.71087f
C107 bitb4 bit3 0.72283f
C108 vbn a_6896_6633# 4.66141f
C109 bitb2 a_6006_4704# 0.21396f
C110 a_6156_6633# vg 1.03727f
C111 bit3 bit4 0.02757f
C112 bitb4 a_6006_896# 0.00214f
C113 vbn bitb0 0.0727f
C114 a_6006_896# bit4 0.00331f
C115 bitb3 a_6006_4704# 0.00123f
C116 bitb1 a_6006_4704# 0
C117 bit0 a_6156_6633# 0.04998f
C118 a2 vg 0.41376f
C119 a3 a1 0.02066f
C120 vbn VDD 5.22274f
C121 bitb4 a_6006_14# 0.21399f
C122 vctrl a_6006_4704# 0.17004f
C123 a_6156_6633# a_6006_896# 3.25671f
C124 bit1 a_6006_4704# 0.00886f
C125 bitb3 bitb2 0.01415f
C126 a_6006_14# bit4 0.05001f
C127 a4 VDD 1.3832f
C128 bitb1 bitb2 0.01415f
C129 a_6006_4704# vg 2.53379f
C130 vctrl VSS 6.97962f
C131 vg VSS 32.16264f
C132 bit4 VSS 1.79583f
C133 bit3 VSS 1.818f
C134 bit2 VSS 1.81683f
C135 bit1 VSS 1.81694f
C136 bit0 VSS 1.81571f
C137 vbn VSS 13.3663f
C138 bitb4 VSS 1.43298f
C139 bitb3 VSS 1.4231f
C140 bitb2 VSS 1.42236f
C141 bitb1 VSS 1.42236f
C142 bitb0 VSS 1.31287f
C143 a2 VSS 0.62562f
C144 a3 VSS 0.77142f
C145 a1 VSS 0.77416f
C146 a4 VSS 0.76101f
C147 a0 VSS 0.63153f
C148 VDD VSS 70.36195f
C149 a_6006_14# VSS 24.2762f
C150 a_6006_896# VSS 15.1797f
C151 a_6006_4704# VSS 7.89975f
C152 a_6896_6633# VSS 3.78967f
C153 a_6156_6633# VSS 2.53075f
C154 VDD.n0 VSS 0.09618f
C155 VDD.t11 VSS 0.0623f
C156 VDD.n2 VSS 0.05701f
C157 VDD.n3 VSS 0.11151f
C158 VDD.t13 VSS 0.0623f
C159 VDD.t4 VSS 0.0623f
C160 VDD.t9 VSS 0.0623f
C161 VDD.n4 VSS 0.09856f
C162 VDD.n5 VSS 0.11151f
C163 VDD.n6 VSS 0.11151f
C164 VDD.n7 VSS 0.46321f
C165 VDD.n8 VSS 1.85297f
C166 VDD.n9 VSS 0.12716f
C167 VDD.n10 VSS 0.12716f
C168 VDD.t2 VSS 1.17368f
C169 VDD.n11 VSS 2.15041f
C170 VDD.t7 VSS 0.76929f
C171 VDD.t5 VSS 0.76929f
C172 VDD.t14 VSS 0.76929f
C173 VDD.t6 VSS 0.57801f
C174 VDD.n12 VSS 0.26405f
C175 VDD.n13 VSS 0.30111f
C176 VDD.n14 VSS 0.30111f
C177 VDD.n15 VSS 0.25574f
C178 VDD.t10 VSS 0.49692f
C179 VDD.t0 VSS 0.61335f
C180 VDD.t12 VSS 0.57177f
C181 VDD.t3 VSS 0.54058f
C182 VDD.t8 VSS 1.45229f
C183 VDD.n16 VSS 1.97104f
C184 VDD.n17 VSS 0.21407f
C185 VDD.n18 VSS 0.35462f
C186 VDD.n19 VSS 0.0867f
C187 VDD.n20 VSS 0.11151f
C188 VDD.n21 VSS 0.11151f
C189 VDD.n22 VSS 0.11151f
C190 VDD.n23 VSS 0.11151f
C191 VDD.n24 VSS 0.11151f
C192 VDD.n25 VSS 0.11151f
C193 VDD.n26 VSS 0.07429f
C194 VDD.n27 VSS 0.11151f
C195 VDD.n28 VSS 0.11151f
C196 VDD.n29 VSS 0.07248f
C197 VDD.n30 VSS 0.09856f
C198 VDD.n31 VSS 0.07248f
C199 VDD.n32 VSS 0.09856f
C200 VDD.t1 VSS 0.0623f
C201 VDD.n33 VSS 0.09856f
C202 VDD.n34 VSS 0.05826f
C203 VDD.n35 VSS 0.11151f
C204 VDD.n36 VSS 0.11151f
C205 VDD.n37 VSS 0.11151f
C206 VDD.n38 VSS 0.10496f
C207 VDD.n39 VSS 0.09856f
C208 VDD.n40 VSS 0.03833f
C209 VDD.n41 VSS 0.13323f
C210 a0.t1 VSS 0.5671f
C211 a0.t0 VSS 0.1776f
C212 a0.n0 VSS 0.66954f
C213 a0.t3 VSS 0.25992f
C214 a0.t2 VSS 0.13357f
C215 a0.n1 VSS 0.36626f
C216 a0.n2 VSS 0.39589f
C217 a4.t0 VSS 0.69134f
C218 a4.t1 VSS 0.2165f
C219 a4.n0 VSS 0.79966f
C220 a4.t3 VSS 0.31686f
C221 a4.t2 VSS 0.16283f
C222 a4.n1 VSS 0.46118f
C223 a1.t3 VSS 0.29298f
C224 a1.t2 VSS 0.15006f
C225 a1.n0 VSS 0.46364f
C226 a1.t1 VSS 0.69699f
C227 a1.t0 VSS 0.17846f
C228 a1.n1 VSS 0.69847f
C229 a3.t1 VSS 0.625f
C230 a3.t0 VSS 0.16002f
C231 a3.n0 VSS 0.626f
C232 a3.t3 VSS 0.26272f
C233 a3.t2 VSS 0.13456f
C234 a3.n1 VSS 0.41369f
C235 a2.t2 VSS 0.15134f
C236 a2.t3 VSS 0.29338f
C237 a2.n0 VSS 0.46193f
C238 a2.t1 VSS 0.57774f
C239 a2.t0 VSS 0.22582f
C240 a2.n1 VSS 0.77271f
C241 bitb0.t1 VSS 0.25527f
C242 bitb0.t0 VSS 0.07778f
C243 bitb0.n0 VSS 0.43947f
C244 bitb1.t1 VSS 0.35733f
C245 bitb1.t0 VSS 0.10887f
C246 bitb1.n0 VSS 0.61518f
C247 bitb2.t1 VSS 0.35733f
C248 bitb2.t0 VSS 0.10887f
C249 bitb2.n0 VSS 0.61518f
C250 bitb3.t1 VSS 0.35743f
C251 bitb3.t0 VSS 0.1089f
C252 bitb3.n0 VSS 0.61536f
C253 bitb4.t1 VSS 0.35543f
C254 bitb4.t0 VSS 0.1083f
C255 bitb4.n0 VSS 0.61192f
C256 vbn.t9 VSS 0.31989f
C257 vbn.t2 VSS 0.40366f
C258 vbn.n0 VSS 1.02198f
C259 vbn.t8 VSS 0.31989f
C260 vbn.t1 VSS 0.40366f
C261 vbn.n1 VSS 0.99043f
C262 vbn.n2 VSS 0.56679f
C263 vbn.t7 VSS 0.31989f
C264 vbn.t0 VSS 0.40366f
C265 vbn.n3 VSS 0.99043f
C266 vbn.n4 VSS 0.37929f
C267 vbn.t5 VSS 0.31989f
C268 vbn.t3 VSS 0.40366f
C269 vbn.n5 VSS 0.99043f
C270 vbn.n6 VSS 0.37929f
C271 vbn.t4 VSS 0.31989f
C272 vbn.t6 VSS 0.40366f
C273 vbn.n7 VSS 0.99043f
C274 vbn.n8 VSS 0.27769f
C275 vbn.t11 VSS 2.08243f
C276 vbn.t10 VSS 1.99031f
C277 vbn.n9 VSS 4.14112f
C278 vbn.t12 VSS 2.53581f
C279 vbn.n10 VSS 4.23852f
C280 vbn.t13 VSS 2.0715f
C281 vbn.t14 VSS 2.08801f
C282 vbn.n11 VSS 3.96052f
C283 vbn.n12 VSS 0.79833f
C284 vbn.t15 VSS 2.52509f
C285 vbn.n13 VSS 4.78789f
C286 vbn.n14 VSS 1.30219f
C287 bit0.t0 VSS 0.23438f
C288 bit1.t0 VSS 0.23772f
C289 bit2.t0 VSS 0.23776f
C290 bit3.t0 VSS 0.23795f
C291 bit4.t0 VSS 0.21421f
C292 vg.n0 VSS 0.06787f
C293 vg.n1 VSS 0.02954f
C294 vg.t43 VSS 2.0636f
C295 vg.n2 VSS 0.02709f
C296 vg.n3 VSS 0.06787f
C297 vg.n4 VSS 0.03405f
C298 vg.t45 VSS 2.0636f
C299 vg.t7 VSS 0.01756f
C300 vg.n5 VSS 0.05028f
C301 vg.n6 VSS 0.06787f
C302 vg.n7 VSS 0.06787f
C303 vg.n8 VSS 0.01971f
C304 vg.n9 VSS 0.02036f
C305 vg.t46 VSS 2.0636f
C306 vg.t11 VSS 0.01756f
C307 vg.n10 VSS 0.02599f
C308 vg.n11 VSS 0.06787f
C309 vg.t12 VSS 0.01756f
C310 vg.n12 VSS 0.04298f
C311 vg.n13 VSS 0.02062f
C312 vg.t10 VSS 0.01756f
C313 vg.n14 VSS 0.03088f
C314 vg.t48 VSS 2.0636f
C315 vg.t9 VSS 0.01756f
C316 vg.n15 VSS 0.04213f
C317 vg.n16 VSS 0.11362f
C318 vg.n17 VSS 0.06474f
C319 vg.n18 VSS 0.72649f
C320 vg.n19 VSS 0.02379f
C321 vg.n20 VSS 0.05659f
C322 vg.n21 VSS 0.04654f
C323 vg.t47 VSS 2.0636f
C324 vg.n22 VSS 0.72649f
C325 vg.n23 VSS 0.02751f
C326 vg.n24 VSS 0.02036f
C327 vg.n25 VSS 0.06787f
C328 vg.n26 VSS 0.06787f
C329 vg.n27 VSS 0.03402f
C330 vg.n28 VSS 0.05605f
C331 vg.n29 VSS 0.01581f
C332 vg.n30 VSS 0.72649f
C333 vg.n31 VSS 0.03394f
C334 vg.n32 VSS 0.02036f
C335 vg.n33 VSS 0.06787f
C336 vg.n34 VSS 0.06787f
C337 vg.n35 VSS 0.06217f
C338 vg.n36 VSS 0.02699f
C339 vg.n37 VSS 0.72649f
C340 vg.n38 VSS 0.0466f
C341 vg.n39 VSS 0.03665f
C342 vg.t44 VSS 2.0636f
C343 vg.n40 VSS 0.72649f
C344 vg.n41 VSS 0.0466f
C345 vg.n42 VSS 0.03379f
C346 vg.n43 VSS 0.06787f
C347 vg.n44 VSS 0.06787f
C348 vg.n45 VSS 0.0631f
C349 vg.n46 VSS 0.0466f
C350 vg.n47 VSS 0.72649f
C351 vg.n48 VSS 0.09936f
C352 vg.n49 VSS 0.14527f
C353 vg.t31 VSS 0.0038f
C354 vg.t34 VSS 0.0038f
C355 vg.n50 VSS 0.02886f
C356 vg.t19 VSS 0.0038f
C357 vg.t42 VSS 0.0038f
C358 vg.n51 VSS 0.01372f
C359 vg.n52 VSS 0.14711f
C360 vg.t21 VSS 0.0038f
C361 vg.t0 VSS 0.0038f
C362 vg.n53 VSS 0.01372f
C363 vg.n54 VSS 0.10464f
C364 vg.n55 VSS 0.07928f
C365 vg.t38 VSS 0.0038f
C366 vg.t17 VSS 0.0038f
C367 vg.n56 VSS 0.02886f
C368 vg.t15 VSS 0.0038f
C369 vg.t32 VSS 0.0038f
C370 vg.n57 VSS 0.01372f
C371 vg.n58 VSS 0.14711f
C372 vg.t13 VSS 0.0038f
C373 vg.t18 VSS 0.0038f
C374 vg.n59 VSS 0.01372f
C375 vg.n60 VSS 0.10464f
C376 vg.n61 VSS 0.04008f
C377 vg.t20 VSS 0.0038f
C378 vg.t6 VSS 0.0038f
C379 vg.n62 VSS 0.02886f
C380 vg.t1 VSS 0.0038f
C381 vg.t37 VSS 0.0038f
C382 vg.n63 VSS 0.01372f
C383 vg.n64 VSS 0.14711f
C384 vg.t30 VSS 0.0038f
C385 vg.t39 VSS 0.0038f
C386 vg.n65 VSS 0.01372f
C387 vg.n66 VSS 0.10464f
C388 vg.n67 VSS 0.04008f
C389 vg.t41 VSS 0.0038f
C390 vg.t5 VSS 0.0038f
C391 vg.n68 VSS 0.05156f
C392 vg.n69 VSS 0.09334f
C393 vg.t36 VSS 0.0038f
C394 vg.t27 VSS 0.0038f
C395 vg.n70 VSS 0.02886f
C396 vg.t35 VSS 0.0038f
C397 vg.t2 VSS 0.0038f
C398 vg.n71 VSS 0.01372f
C399 vg.n72 VSS 0.14711f
C400 vg.t4 VSS 0.0038f
C401 vg.t28 VSS 0.0038f
C402 vg.n73 VSS 0.01372f
C403 vg.n74 VSS 0.10464f
C404 vg.n75 VSS 0.043f
C405 vg.t25 VSS 0.0038f
C406 vg.t8 VSS 0.0038f
C407 vg.n76 VSS 0.02886f
C408 vg.t24 VSS 0.0038f
C409 vg.t16 VSS 0.0038f
C410 vg.n77 VSS 0.01372f
C411 vg.n78 VSS 0.14711f
C412 vg.t26 VSS 0.0038f
C413 vg.t40 VSS 0.0038f
C414 vg.n79 VSS 0.01372f
C415 vg.n80 VSS 0.10464f
C416 vg.n81 VSS 0.04008f
C417 vg.t3 VSS 0.0038f
C418 vg.t29 VSS 0.0038f
C419 vg.n82 VSS 0.02886f
C420 vg.t14 VSS 0.0038f
C421 vg.t22 VSS 0.0038f
C422 vg.n83 VSS 0.01372f
C423 vg.n84 VSS 0.14711f
C424 vg.t33 VSS 0.0038f
C425 vg.t23 VSS 0.0038f
C426 vg.n85 VSS 0.01372f
C427 vg.n86 VSS 0.10464f
C428 vg.n87 VSS 0.04812f
C429 vctrl.t0 VSS 3.39398f
.ends
