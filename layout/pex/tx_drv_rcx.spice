* tx_drv: magic R+C extraction of layout/tx_drv.gds (layout/gen/pex.sh)
* rcfix.py: split-net C to VSS scaled by (S - K) / S on 6 nets (coupling double count removed)
* extracted 2026-11-09T21:25:48+01:00 with magic 8.3.642, mode rc, from tx_drv.gds
.subckt tx_drv VDD VSS ls en_p en_n out_p out_n
X0 out_p.t9 py4 VSS.t47 VSS.t46 nfet_03v3 ad=4.8p pd=9.2u as=9.6p ps=18.4u w=8u l=0.28u
X1 out_p.t2 py4 VDD.t54 VDD.t53 pfet_03v3 ad=12p pd=21.2u as=12p ps=21.2u w=20u l=0.28u
X2 VSS.t60 VDD.t84 VSS.t60 VSS.t59 nfet_03v3 ad=12p pd=22.4u as=0 ps=0 w=10u l=10u
X3 VSS.t82 VDD.t66 VSS.t82 VSS.t65 nfet_03v3 ad=6p pd=11.2u as=0 ps=0 w=10u l=10u
X4 b a VDD.t40 VDD.t39 pfet_03v3 ad=1.05p pd=4.1u as=0.4725p ps=3u w=1.05u l=0.28u
X5 py0 a VDD.t38 VDD.t37 pfet_03v3 ad=0.625p pd=2.25u as=0.5625p ps=3.4u w=1.25u l=0.28u
X6 out_p.t3 py4 VSS.t55 VSS.t54 nfet_03v3 ad=9.6p pd=18.4u as=4.8p ps=9.2u w=8u l=0.28u
X7 out_n.t3 ny4 VSS.t29 VSS.t28 nfet_03v3 ad=4.8p pd=9.2u as=4.8p ps=9.2u w=8u l=0.28u
X8 b a VSS.t37 VSS.t36 nfet_03v3 ad=0.42p pd=2.84u as=0.189p ps=1.74u w=0.42u l=0.28u
X9 VSS.t83 VDD.t65 VSS.t83 VSS.t67 nfet_03v3 ad=6p pd=11.2u as=0 ps=0 w=10u l=10u
X10 VDD.t28 ny4 out_n.t0 VDD.t27 pfet_03v3 ad=12p pd=21.2u as=12p ps=21.2u w=20u l=0.28u
X11 ta t VDD.t5 VDD.t4 pfet_03v3 ad=1.25p pd=4.5u as=0.5625p ps=3.4u w=1.25u l=0.28u
X12 VSS.t72 VDD.t76 VSS.t72 VSS.t65 nfet_03v3 ad=6p pd=11.2u as=0 ps=0 w=10u l=10u
X13 out_n.t9 ny4 VDD.t30 VDD.t29 pfet_03v3 ad=12p pd=21.2u as=12p ps=21.2u w=20u l=0.28u
X14 tb t VSS.t3 VSS.t2 nfet_03v3 ad=1.5p pd=5u as=0.675p ps=3.9u w=1.5u l=0.28u
X15 VSS.t45 en_p.t0 a_9448_1520# VSS.t44 nfet_03v3 ad=0.45p pd=2.9u as=0.28p ps=1.56u w=1u l=0.28u
X16 VSS.t81 VDD.t67 VSS.t81 VSS.t63 nfet_03v3 ad=6p pd=11.2u as=0 ps=0 w=10u l=10u
X17 b VSS.t88 tb VDD.t10 pfet_03v3 ad=2.5p pd=7u as=2.5p ps=7u w=2.5u l=0.28u
X18 VSS.t9 py3 py4 VSS.t8 nfet_03v3 ad=2.25p pd=10.9u as=2.5p ps=6u w=5u l=0.28u
X19 tb t VDD.t3 VDD.t2 pfet_03v3 ad=3.75p pd=9.5u as=1.6875p ps=8.4u w=3.75u l=0.28u
X20 a_9448_1520# a py0 VSS.t38 nfet_03v3 ad=0.28p pd=1.56u as=1p ps=4u w=1u l=0.28u
X21 VDD.t22 ny2 ny3 VDD.t21 pfet_03v3 ad=2.8125p pd=13.4u as=6.25p ps=14.5u w=6.25u l=0.28u
X22 py2 py1 VDD.t36 VDD.t35 pfet_03v3 ad=1.56p pd=5.12u as=0.702p ps=4.02u w=1.56u l=0.28u
X23 VDD.t56 py4 out_p.t0 VDD.t55 pfet_03v3 ad=12p pd=21.2u as=12p ps=21.2u w=20u l=0.28u
X24 a b VDD.t42 VDD.t41 pfet_03v3 ad=1.05p pd=4.1u as=0.4725p ps=3u w=1.05u l=0.28u
X25 out_p.t4 py4 VDD.t50 VDD.t49 pfet_03v3 ad=12p pd=21.2u as=24p ps=42.4u w=20u l=0.28u
X26 out_n.t7 ny4 VSS.t25 VSS.t24 nfet_03v3 ad=4.8p pd=9.2u as=4.8p ps=9.2u w=8u l=0.28u
X27 a ta VSS.t19 VSS.t18 nfet_03v3 ad=1p pd=4u as=0.45p ps=2.9u w=1u l=0.28u
X28 VSS.t73 VDD.t75 VSS.t73 VSS.t67 nfet_03v3 ad=6p pd=11.2u as=0 ps=0 w=10u l=10u
X29 VSS.t49 py4 out_p.t8 VSS.t48 nfet_03v3 ad=4.8p pd=9.2u as=4.8p ps=9.2u w=8u l=0.28u
X30 VDD.t46 ny0 ny1 VDD.t45 pfet_03v3 ad=0.4725p pd=3u as=1.05p ps=4.1u w=1.05u l=0.28u
X31 py4 py3 VDD.t7 VDD.t6 pfet_03v3 ad=6.25p pd=13.5u as=5.625p ps=25.9u w=12.5u l=0.28u
X32 a b VSS.t41 VSS.t40 nfet_03v3 ad=0.42p pd=2.84u as=0.189p ps=1.74u w=0.42u l=0.28u
X33 VSS.t71 VDD.t77 VSS.t71 VSS.t63 nfet_03v3 ad=6p pd=11.2u as=0 ps=0 w=10u l=10u
X34 VSS.t77 VDD.t71 VSS.t77 VSS.t65 nfet_03v3 ad=6p pd=11.2u as=0 ps=0 w=10u l=10u
X35 VSS.t80 VDD.t68 VSS.t80 VSS.t61 nfet_03v3 ad=6p pd=11.2u as=0 ps=0 w=10u l=10u
X36 VDD.t18 ny3 ny4 VDD.t17 pfet_03v3 ad=5.625p pd=25.9u as=6.25p ps=13.5u w=12.5u l=0.28u
X37 VSS.t43 ny0 ny1 VSS.t42 nfet_03v3 ad=0.189p pd=1.74u as=0.42p ps=2.84u w=0.42u l=0.28u
X38 py3 py2 VSS.t33 VSS.t32 nfet_03v3 ad=2.5p pd=7u as=1.125p ps=5.9u w=2.5u l=0.28u
X39 VSS.t79 VDD.t69 VSS.t79 VSS.t59 nfet_03v3 ad=12p pd=22.4u as=0 ps=0 w=10u l=10u
X40 py2 py1 VSS.t35 VSS.t34 nfet_03v3 ad=0.625p pd=3.25u as=0.28125p ps=2.15u w=0.625u l=0.28u
X41 VDD.t32 ny4 out_n.t8 VDD.t31 pfet_03v3 ad=24p pd=42.4u as=12p ps=21.2u w=20u l=0.28u
X42 VSS.t31 ny4 out_n.t1 VSS.t30 nfet_03v3 ad=9.6p pd=18.4u as=4.8p ps=9.2u w=8u l=0.28u
X43 ta t VSS.t5 VSS.t4 nfet_03v3 ad=0.5p pd=3u as=0.225p ps=1.9u w=0.5u l=0.28u
X44 VSS.t78 VDD.t70 VSS.t78 VSS.t67 nfet_03v3 ad=6p pd=11.2u as=0 ps=0 w=10u l=10u
X45 VDD.t12 ny1 ny2 VDD.t11 pfet_03v3 ad=0.702p pd=4.02u as=1.56p ps=5.12u w=1.56u l=0.28u
X46 VDD.t44 b ny0 VDD.t43 pfet_03v3 ad=0.5625p pd=3.4u as=0.625p ps=2.25u w=1.25u l=0.28u
X47 ny4 ny3 VSS.t15 VSS.t14 nfet_03v3 ad=2.5p pd=6u as=2.25p ps=10.9u w=5u l=0.28u
X48 out_p.t6 py4 VSS.t51 VSS.t50 nfet_03v3 ad=4.8p pd=9.2u as=4.8p ps=9.2u w=8u l=0.28u
X49 t ls.t1 VDD.t60 VDD.t59 pfet_03v3 ad=1.05p pd=4.1u as=0.4725p ps=3u w=1.05u l=0.28u
X50 VDD.t48 en_p.t1 py0 VDD.t47 pfet_03v3 ad=0.5625p pd=3.4u as=0.625p ps=2.25u w=1.25u l=0.28u
X51 out_p.t1 py4 VDD.t58 VDD.t57 pfet_03v3 ad=24p pd=42.4u as=12p ps=21.2u w=20u l=0.28u
X52 VSS.t66 VDD.t81 VSS.t66 VSS.t65 nfet_03v3 ad=6p pd=11.2u as=0 ps=0 w=10u l=10u
X53 VSS.t70 VDD.t78 VSS.t70 VSS.t61 nfet_03v3 ad=6p pd=11.2u as=0 ps=0 w=10u l=10u
X54 VSS.t76 VDD.t72 VSS.t76 VSS.t63 nfet_03v3 ad=6p pd=11.2u as=0 ps=0 w=10u l=10u
X55 VDD.t9 py3 py4 VDD.t8 pfet_03v3 ad=5.625p pd=25.9u as=6.25p ps=13.5u w=12.5u l=0.28u
X56 VDD.t52 py4 out_p.t7 VDD.t51 pfet_03v3 ad=12p pd=21.2u as=12p ps=21.2u w=20u l=0.28u
X57 t ls.t0 VSS.t57 VSS.t56 nfet_03v3 ad=0.42p pd=2.84u as=0.189p ps=1.74u w=0.42u l=0.28u
X58 VSS.t69 VDD.t79 VSS.t69 VSS.t59 nfet_03v3 ad=12p pd=22.4u as=0 ps=0 w=10u l=10u
X59 VSS.t84 VDD.t64 VSS.t84 VSS.t59 nfet_03v3 ad=12p pd=22.4u as=0 ps=0 w=10u l=10u
X60 ny4 ny3 VDD.t16 VDD.t15 pfet_03v3 ad=6.25p pd=13.5u as=5.625p ps=25.9u w=12.5u l=0.28u
X61 ny0 en_n.t1 VDD.t1 VDD.t0 pfet_03v3 ad=0.625p pd=2.25u as=0.5625p ps=3.4u w=1.25u l=0.28u
X62 a ta VDD.t20 VDD.t19 pfet_03v3 ad=2.5p pd=7u as=1.125p ps=5.9u w=2.5u l=0.28u
X63 VSS.t27 ny4 out_n.t2 VSS.t26 nfet_03v3 ad=4.8p pd=9.2u as=4.8p ps=9.2u w=8u l=0.28u
X64 VSS.t17 ny3 ny4 VSS.t16 nfet_03v3 ad=2.25p pd=10.9u as=2.5p ps=6u w=5u l=0.28u
X65 VSS.t68 VDD.t80 VSS.t68 VSS.t67 nfet_03v3 ad=6p pd=11.2u as=0 ps=0 w=10u l=10u
X66 VSS.t11 ny1 ny2 VSS.t10 nfet_03v3 ad=0.28125p pd=2.15u as=0.625p ps=3.25u w=0.625u l=0.28u
X67 ny0 b a_4834_1520# VSS.t39 nfet_03v3 ad=1p pd=4u as=0.28p ps=1.56u w=1u l=0.28u
X68 py4 py3 VSS.t7 VSS.t6 nfet_03v3 ad=2.5p pd=6u as=2.25p ps=10.9u w=5u l=0.28u
X69 VSS.t64 VDD.t82 VSS.t64 VSS.t63 nfet_03v3 ad=6p pd=11.2u as=0 ps=0 w=10u l=10u
X70 VSS.t85 VDD.t63 VSS.t85 VSS.t61 nfet_03v3 ad=6p pd=11.2u as=0 ps=0 w=10u l=10u
X71 VSS.t86 VDD.t62 VSS.t86 VSS.t63 nfet_03v3 ad=6p pd=11.2u as=0 ps=0 w=10u l=10u
X72 VSS.t87 VDD.t61 VSS.t87 VSS.t65 nfet_03v3 ad=6p pd=11.2u as=0 ps=0 w=10u l=10u
X73 py1 py0 VDD.t14 VDD.t13 pfet_03v3 ad=1.05p pd=4.1u as=0.4725p ps=3u w=1.05u l=0.28u
X74 VSS.t23 ny4 out_n.t6 VSS.t22 nfet_03v3 ad=4.8p pd=9.2u as=9.6p ps=18.4u w=8u l=0.28u
X75 VSS.t75 VDD.t73 VSS.t75 VSS.t61 nfet_03v3 ad=6p pd=11.2u as=0 ps=0 w=10u l=10u
X76 a_4834_1520# en_n.t0 VSS.t1 VSS.t0 nfet_03v3 ad=0.28p pd=1.56u as=0.45p ps=2.9u w=1u l=0.28u
X77 py1 py0 VSS.t13 VSS.t12 nfet_03v3 ad=0.42p pd=2.84u as=0.189p ps=1.74u w=0.42u l=0.28u
X78 VSS.t74 VDD.t74 VSS.t74 VSS.t59 nfet_03v3 ad=12p pd=22.4u as=0 ps=0 w=10u l=10u
X79 VDD.t24 ny4 out_n.t4 VDD.t23 pfet_03v3 ad=12p pd=21.2u as=24p ps=42.4u w=20u l=0.28u
X80 VSS.t21 ny2 ny3 VSS.t20 nfet_03v3 ad=1.125p pd=5.9u as=2.5p ps=7u w=2.5u l=0.28u
X81 out_n.t5 ny4 VDD.t26 VDD.t25 pfet_03v3 ad=12p pd=21.2u as=12p ps=21.2u w=20u l=0.28u
X82 py3 py2 VDD.t34 VDD.t33 pfet_03v3 ad=6.25p pd=14.5u as=2.8125p ps=13.4u w=6.25u l=0.28u
X83 b VDD.t85 tb VSS.t58 nfet_03v3 ad=1p pd=4u as=1p ps=4u w=1u l=0.28u
X84 VSS.t53 py4 out_p.t5 VSS.t52 nfet_03v3 ad=4.8p pd=9.2u as=4.8p ps=9.2u w=8u l=0.28u
X85 VSS.t62 VDD.t83 VSS.t62 VSS.t61 nfet_03v3 ad=6p pd=11.2u as=0 ps=0 w=10u l=10u
R0 out_p.n39 out_p.n38 4.5005
R1 out_p.n42 out_p.n41 4.5005
R2 out_p.n27 out_p.n26 4.5005
R3 out_p.n31 out_p.n30 4.5005
R4 out_p.n14 out_p.n13 4.5005
R5 out_p.n18 out_p.n17 4.5005
R6 out_p.n42 out_p.n1 2.23758
R7 out_p.n40 out_p.n39 2.23758
R8 out_p.n31 out_p.n5 2.23758
R9 out_p.n28 out_p.n27 2.23758
R10 out_p.n18 out_p.n10 2.23758
R11 out_p.n15 out_p.n14 2.23758
R12 out_p.n41 out_p.t3 1.63289
R13 out_p.n11 out_p.n9 1.5275
R14 out_p.n19 out_p.n9 1.5005
R15 out_p.n21 out_p.n20 1.5005
R16 out_p.n22 out_p.n7 1.5005
R17 out_p.n24 out_p.n23 1.5005
R18 out_p.n8 out_p.n6 1.5005
R19 out_p.n32 out_p.n4 1.5005
R20 out_p.n34 out_p.n33 1.5005
R21 out_p.n35 out_p.n3 1.5005
R22 out_p.n37 out_p.n36 1.5005
R23 out_p.n2 out_p.n0 1.5005
R24 out_p.n38 out_p.t1 1.35536
R25 out_p.n17 out_p.n16 1.16039
R26 out_p.n30 out_p.n29 1.16039
R27 out_p.n13 out_p.n12 1.14536
R28 out_p.n26 out_p.n25 1.14536
R29 out_p.n16 out_p.t8 0.473
R30 out_p.n16 out_p.t9 0.473
R31 out_p.n29 out_p.t5 0.473
R32 out_p.n29 out_p.t6 0.473
R33 out_p.n43 out_p.n42 0.396757
R34 out_p.n12 out_p.t7 0.2105
R35 out_p.n12 out_p.t4 0.2105
R36 out_p.n25 out_p.t0 0.2105
R37 out_p.n25 out_p.t2 0.2105
R38 out_p.n43 out_p.n0 0.0667686
R39 out_p.n15 out_p.n10 0.0551779
R40 out_p.n28 out_p.n5 0.0551779
R41 out_p.n40 out_p.n1 0.0551779
R42 out_p out_p.n43 0.0550336
R43 out_p.n17 out_p.n15 0.027839
R44 out_p.n30 out_p.n28 0.027839
R45 out_p.n41 out_p.n40 0.027839
R46 out_p.n38 out_p.n1 0.027839
R47 out_p.n26 out_p.n5 0.027839
R48 out_p.n13 out_p.n10 0.027839
R49 out_p.n37 out_p.n3 0.0275
R50 out_p.n33 out_p.n3 0.0275
R51 out_p.n33 out_p.n32 0.0275
R52 out_p.n24 out_p.n7 0.0275
R53 out_p.n20 out_p.n7 0.0275
R54 out_p.n20 out_p.n19 0.0275
R55 out_p.n36 out_p.n0 0.0275
R56 out_p.n36 out_p.n35 0.0275
R57 out_p.n35 out_p.n34 0.0275
R58 out_p.n34 out_p.n4 0.0275
R59 out_p.n8 out_p.n4 0.0275
R60 out_p.n23 out_p.n8 0.0275
R61 out_p.n23 out_p.n22 0.0275
R62 out_p.n22 out_p.n21 0.0275
R63 out_p.n21 out_p.n9 0.0275
R64 out_p.n27 out_p.n24 0.01805
R65 out_p.n18 out_p.n11 0.01715
R66 out_p.n39 out_p.n37 0.01625
R67 out_p.n31 out_p.n6 0.01535
R68 out_p.n42 out_p.n2 0.01355
R69 out_p.n32 out_p.n31 0.01265
R70 out_p.n39 out_p.n2 0.01175
R71 out_p.n19 out_p.n18 0.01085
R72 out_p.n27 out_p.n6 0.00995
R73 out_p.n14 out_p.n11 0.00815
R74 en_p.n0 en_p.t1 36.0548
R75 en_p.n0 en_p.t0 31.6815
R76 en_p en_p.n0 16.5735
R77 ls.n0 ls.t1 33.4926
R78 ls.n0 ls.t0 24.0497
R79 ls ls.n0 16.1283
R80 en_n.n0 en_n.t1 40.5145
R81 en_n.n0 en_n.t0 36.4326
R82 en_n en_n.n0 11.3062
R83 out_n.n13 out_n.n7 4.5005
R84 out_n.n10 out_n.n9 4.5005
R85 out_n.n27 out_n.n22 4.5005
R86 out_n.n24 out_n.n20 4.5005
R87 out_n.n34 out_n.n0 4.5005
R88 out_n.n38 out_n.n37 4.5005
R89 out_n.n11 out_n.n10 2.23758
R90 out_n.n13 out_n.n12 2.23758
R91 out_n.n25 out_n.n20 2.23758
R92 out_n.n27 out_n.n26 2.23758
R93 out_n.n38 out_n.n35 2.23758
R94 out_n.n36 out_n.n0 2.23758
R95 out_n.n37 out_n.t6 1.63289
R96 out_n.n15 out_n.n5 1.5275
R97 out_n.n15 out_n.n14 1.5005
R98 out_n.n16 out_n.n4 1.5005
R99 out_n.n18 out_n.n17 1.5005
R100 out_n.n19 out_n.n3 1.5005
R101 out_n.n29 out_n.n28 1.5005
R102 out_n.n30 out_n.n2 1.5005
R103 out_n.n32 out_n.n31 1.5005
R104 out_n.n33 out_n.n1 1.5005
R105 out_n.n40 out_n.n39 1.5005
R106 out_n.n34 out_n.t4 1.35536
R107 out_n.n24 out_n.n23 1.16039
R108 out_n.n9 out_n.n8 1.16039
R109 out_n.n22 out_n.n21 1.14536
R110 out_n.n7 out_n.n6 1.14536
R111 out_n.n23 out_n.t2 0.473
R112 out_n.n23 out_n.t7 0.473
R113 out_n.n8 out_n.t1 0.473
R114 out_n.n8 out_n.t3 0.473
R115 out_n.n41 out_n.n0 0.313126
R116 out_n.n21 out_n.t0 0.2105
R117 out_n.n21 out_n.t5 0.2105
R118 out_n.n6 out_n.t8 0.2105
R119 out_n.n6 out_n.t9 0.2105
R120 out_n.n41 out_n.n40 0.0783159
R121 out_n out_n.n41 0.0593633
R122 out_n.n36 out_n.n35 0.0551779
R123 out_n.n26 out_n.n25 0.0551779
R124 out_n.n12 out_n.n11 0.0551779
R125 out_n.n37 out_n.n36 0.027839
R126 out_n.n26 out_n.n24 0.027839
R127 out_n.n12 out_n.n9 0.027839
R128 out_n.n11 out_n.n7 0.027839
R129 out_n.n25 out_n.n22 0.027839
R130 out_n.n35 out_n.n34 0.027839
R131 out_n.n14 out_n.n4 0.0275
R132 out_n.n18 out_n.n4 0.0275
R133 out_n.n19 out_n.n18 0.0275
R134 out_n.n32 out_n.n2 0.0275
R135 out_n.n33 out_n.n32 0.0275
R136 out_n.n39 out_n.n33 0.0275
R137 out_n.n16 out_n.n15 0.0275
R138 out_n.n17 out_n.n16 0.0275
R139 out_n.n17 out_n.n3 0.0275
R140 out_n.n29 out_n.n3 0.0275
R141 out_n.n30 out_n.n29 0.0275
R142 out_n.n31 out_n.n30 0.0275
R143 out_n.n31 out_n.n1 0.0275
R144 out_n.n40 out_n.n1 0.0275
R145 out_n.n27 out_n.n2 0.02705
R146 out_n.n14 out_n.n13 0.02525
R147 out_n.n38 out_n.n0 0.0248
R148 out_n.n28 out_n.n20 0.02435
R149 out_n.n10 out_n.n5 0.02255
R150 out_n.n20 out_n.n19 0.00365
R151 out_n.n13 out_n.n5 0.00275
R152 out_n.n39 out_n.n38 0.00185
R153 out_n.n28 out_n.n27 0.00095
R154 VDD.t8 VDD.t49 173.357
R155 VDD.t15 VDD.t31 150.861
R156 VDD.t41 VDD.t37 138.069
R157 VDD.t0 VDD.t45 131.452
R158 VDD.t33 VDD.t6 111.602
R159 VDD.t35 VDD.t33 111.602
R160 VDD.t13 VDD.t35 111.602
R161 VDD.t39 VDD.t41 111.602
R162 VDD.t10 VDD.t39 111.602
R163 VDD.t2 VDD.t19 111.602
R164 VDD.t19 VDD.t4 111.602
R165 VDD.t4 VDD.t59 111.602
R166 VDD.t45 VDD.t11 111.602
R167 VDD.t11 VDD.t21 111.602
R168 VDD.t21 VDD.t17 111.602
R169 VDD.n187 VDD.t10 102.779
R170 VDD.n129 VDD.t64 91.2505
R171 VDD.n128 VDD.t61 91.2505
R172 VDD.t47 VDD.t13 87.3406
R173 VDD.t59 VDD.t43 87.3406
R174 VDD.n143 VDD.n142 66.7434
R175 VDD.n144 VDD.n143 66.7434
R176 VDD.n141 VDD.n140 66.7434
R177 VDD.n144 VDD.n141 66.7434
R178 VDD.n135 VDD.n134 66.7434
R179 VDD.n136 VDD.n135 66.7434
R180 VDD.n133 VDD.n132 66.7434
R181 VDD.n136 VDD.n133 66.7434
R182 VDD.t55 VDD.t57 65.285
R183 VDD.t53 VDD.t55 65.285
R184 VDD.t51 VDD.t53 65.285
R185 VDD.t49 VDD.t51 65.285
R186 VDD.t31 VDD.t29 65.285
R187 VDD.t29 VDD.t27 65.285
R188 VDD.t27 VDD.t25 65.285
R189 VDD.t25 VDD.t23 65.285
R190 VDD.t6 VDD.t8 56.4628
R191 VDD.t37 VDD.t47 56.4628
R192 VDD.t43 VDD.t0 56.4628
R193 VDD.t17 VDD.t15 56.4628
R194 VDD.n130 VDD.n129 43.8005
R195 VDD.n130 VDD.n128 43.8005
R196 VDD VDD.t85 36.6268
R197 VDD.n188 VDD.t2 26.6878
R198 VDD.n138 VDD.n131 18.026
R199 VDD VDD.n193 15.5172
R200 VDD.n131 VDD.n59 14.747
R201 VDD.n145 VDD.n139 13.436
R202 VDD.n138 VDD.n137 13.436
R203 VDD.n146 VDD.n145 11.837
R204 VDD.n137 VDD.n59 11.837
R205 VDD.n147 VDD.n146 7.53275
R206 VDD.n139 VDD.n127 7.53275
R207 VDD.n94 VDD.t14 7.39282
R208 VDD.n97 VDD.t42 7.39282
R209 VDD.n4 VDD.t40 7.39282
R210 VDD.n182 VDD.t60 7.39282
R211 VDD.n179 VDD.t46 7.39282
R212 VDD.n95 VDD.t48 7.08647
R213 VDD.n96 VDD.t38 7.08647
R214 VDD.n183 VDD.t5 7.08647
R215 VDD.n181 VDD.t44 7.08647
R216 VDD.n180 VDD.t1 7.08647
R217 VDD.n188 VDD.n187 6.39662
R218 VDD.n88 VDD.t36 5.8882
R219 VDD.n178 VDD.t12 5.8882
R220 VDD.n184 VDD.t20 4.63645
R221 VDD.n185 VDD.t3 3.85109
R222 VDD.n146 VDD.n59 3.7505
R223 VDD.n139 VDD.n138 3.7505
R224 VDD.n129 VDD.t63 3.6505
R225 VDD.n128 VDD.t62 3.6505
R226 VDD.n144 VDD.t77 3.6505
R227 VDD.n144 VDD.t82 3.6505
R228 VDD.n142 VDD.t84 3.6505
R229 VDD.n142 VDD.t79 3.6505
R230 VDD.n143 VDD.t83 3.6505
R231 VDD.n143 VDD.t78 3.6505
R232 VDD.n140 VDD.t80 3.6505
R233 VDD.n140 VDD.t75 3.6505
R234 VDD.n141 VDD.t81 3.6505
R235 VDD.n141 VDD.t76 3.6505
R236 VDD.n136 VDD.t67 3.6505
R237 VDD.n136 VDD.t72 3.6505
R238 VDD.n134 VDD.t74 3.6505
R239 VDD.n134 VDD.t69 3.6505
R240 VDD.n135 VDD.t73 3.6505
R241 VDD.n135 VDD.t68 3.6505
R242 VDD.n132 VDD.t70 3.6505
R243 VDD.n132 VDD.t65 3.6505
R244 VDD.n133 VDD.t71 3.6505
R245 VDD.n133 VDD.t66 3.6505
R246 VDD.n87 VDD.t34 3.10717
R247 VDD.n177 VDD.t22 3.10717
R248 VDD.n175 VDD.t16 2.04714
R249 VDD.n79 VDD.t9 2.01864
R250 VDD.n86 VDD.t7 2.01864
R251 VDD.n176 VDD.t18 2.01864
R252 VDD.n122 VDD.n79 1.63945
R253 VDD.n86 VDD.n80 1.63945
R254 VDD.n87 VDD.n85 1.63945
R255 VDD.n113 VDD.n88 1.63945
R256 VDD.n94 VDD.n93 1.63945
R257 VDD.n95 VDD.n92 1.63945
R258 VDD.n104 VDD.n96 1.63945
R259 VDD.n99 VDD.n97 1.63945
R260 VDD.n4 VDD.n2 1.63945
R261 VDD.n185 VDD.n5 1.63945
R262 VDD.n184 VDD.n6 1.63945
R263 VDD.n183 VDD.n7 1.63945
R264 VDD.n182 VDD.n8 1.63945
R265 VDD.n181 VDD.n9 1.63945
R266 VDD.n180 VDD.n10 1.63945
R267 VDD.n179 VDD.n11 1.63945
R268 VDD.n178 VDD.n12 1.63945
R269 VDD.n177 VDD.n13 1.63945
R270 VDD.n176 VDD.n14 1.63945
R271 VDD.n157 VDD.n155 1.57925
R272 VDD.n29 VDD.n26 1.5755
R273 VDD.n40 VDD.n39 1.5755
R274 VDD.n48 VDD.n47 1.5755
R275 VDD.n160 VDD.n155 1.5755
R276 VDD.n108 VDD.n91 1.5755
R277 VDD.n98 VDD.n0 1.50141
R278 VDD.n43 VDD.n21 1.50127
R279 VDD.n68 VDD.n66 1.5005
R280 VDD.n75 VDD.n74 1.5005
R281 VDD.n77 VDD.n62 1.5005
R282 VDD.n124 VDD.n123 1.5005
R283 VDD.n121 VDD.n120 1.5005
R284 VDD.n84 VDD.n81 1.5005
R285 VDD.n115 VDD.n114 1.5005
R286 VDD.n112 VDD.n111 1.5005
R287 VDD.n90 VDD.n89 1.5005
R288 VDD.n106 VDD.n105 1.5005
R289 VDD.n103 VDD.n102 1.5005
R290 VDD.n101 VDD.n100 1.5005
R291 VDD.n192 VDD.n191 1.5005
R292 VDD.n190 VDD.n1 1.5005
R293 VDD.n27 VDD.n3 1.5005
R294 VDD.n25 VDD.n24 1.5005
R295 VDD.n33 VDD.n32 1.5005
R296 VDD.n37 VDD.n36 1.5005
R297 VDD.n72 VDD.n71 1.5005
R298 VDD.n160 VDD.n159 1.5005
R299 VDD.n162 VDD.n161 1.5005
R300 VDD.n149 VDD.n148 1.5005
R301 VDD.n169 VDD.n168 1.5005
R302 VDD.n171 VDD.n170 1.5005
R303 VDD.n49 VDD.n48 1.5005
R304 VDD.n52 VDD.n19 1.5005
R305 VDD.n57 VDD.n56 1.5005
R306 VDD.n58 VDD.n17 1.5005
R307 VDD.n73 VDD.n60 1.5005
R308 VDD.n126 VDD.n125 1.5005
R309 VDD.n63 VDD.n61 1.5005
R310 VDD.n119 VDD.n118 1.5005
R311 VDD.n117 VDD.n116 1.5005
R312 VDD.n83 VDD.n82 1.5005
R313 VDD.n110 VDD.n109 1.5005
R314 VDD.n108 VDD.n107 1.5005
R315 VDD.n29 VDD.n28 1.5005
R316 VDD.n31 VDD.n30 1.5005
R317 VDD.n34 VDD.n23 1.5005
R318 VDD.n39 VDD.n38 1.5005
R319 VDD.n35 VDD.n22 1.5005
R320 VDD.n42 VDD.n41 1.5005
R321 VDD.n46 VDD.n45 1.5005
R322 VDD.n44 VDD.n20 1.5005
R323 VDD.n51 VDD.n50 1.5005
R324 VDD.n54 VDD.n53 1.5005
R325 VDD.n55 VDD.n15 1.5005
R326 VDD.n173 VDD.n172 1.5005
R327 VDD.n150 VDD.n18 1.5005
R328 VDD.n167 VDD.n166 1.5005
R329 VDD.n164 VDD.n163 1.5005
R330 VDD.n156 VDD.n154 1.5005
R331 VDD.n158 VDD.n157 1.5005
R332 VDD.n16 VDD.t32 1.28831
R333 VDD.n76 VDD.t50 1.28831
R334 VDD.n79 VDD.n78 1.20555
R335 VDD.n153 VDD.n152 1.07831
R336 VDD.n165 VDD.n151 1.07831
R337 VDD.n65 VDD.n64 1.07831
R338 VDD.n69 VDD.n67 1.07831
R339 VDD.n175 VDD.n174 1.067
R340 VDD.n186 VDD.n4 1.05563
R341 VDD.n97 VDD.n96 0.741816
R342 VDD.n87 VDD.n86 0.599711
R343 VDD.n88 VDD.n87 0.599711
R344 VDD.n94 VDD.n88 0.599711
R345 VDD.n97 VDD.n4 0.599711
R346 VDD.n185 VDD.n184 0.599711
R347 VDD.n184 VDD.n183 0.599711
R348 VDD.n183 VDD.n182 0.599711
R349 VDD.n179 VDD.n178 0.599711
R350 VDD.n178 VDD.n177 0.599711
R351 VDD.n177 VDD.n176 0.599711
R352 VDD.n71 VDD.n70 0.594418
R353 VDD.n70 VDD.n69 0.586011
R354 VDD.n180 VDD.n179 0.514447
R355 VDD.n86 VDD.n79 0.4955
R356 VDD.n96 VDD.n95 0.4955
R357 VDD.n181 VDD.n180 0.4955
R358 VDD.n176 VDD.n175 0.444579
R359 VDD.n95 VDD.n94 0.277605
R360 VDD.n182 VDD.n181 0.277605
R361 VDD.n186 VDD.n185 0.274053
R362 VDD.n152 VDD.t26 0.2105
R363 VDD.n152 VDD.t24 0.2105
R364 VDD.n151 VDD.t30 0.2105
R365 VDD.n151 VDD.t28 0.2105
R366 VDD.n64 VDD.t54 0.2105
R367 VDD.n64 VDD.t52 0.2105
R368 VDD.n67 VDD.t58 0.2105
R369 VDD.n67 VDD.t56 0.2105
R370 VDD.n187 VDD.n186 0.12283
R371 VDD.n131 VDD.n130 0.0874565
R372 VDD.n189 VDD.n188 0.0868014
R373 VDD.n46 VDD.n43 0.0756696
R374 VDD.n30 VDD.n29 0.0755
R375 VDD.n30 VDD.n23 0.0755
R376 VDD.n39 VDD.n23 0.0755
R377 VDD.n48 VDD.n19 0.0755
R378 VDD.n57 VDD.n19 0.0755
R379 VDD.n58 VDD.n57 0.0755
R380 VDD.n170 VDD.n169 0.0755
R381 VDD.n169 VDD.n148 0.0755
R382 VDD.n161 VDD.n148 0.0755
R383 VDD.n161 VDD.n160 0.0755
R384 VDD.n71 VDD.n60 0.0755
R385 VDD.n126 VDD.n61 0.0755
R386 VDD.n118 VDD.n61 0.0755
R387 VDD.n118 VDD.n117 0.0755
R388 VDD.n117 VDD.n82 0.0755
R389 VDD.n109 VDD.n82 0.0755
R390 VDD.n109 VDD.n108 0.0755
R391 VDD.n112 VDD.n89 0.0755
R392 VDD.n103 VDD.n100 0.0755
R393 VDD.n191 VDD.n190 0.0755
R394 VDD.n36 VDD.n35 0.0755
R395 VDD.n45 VDD.n44 0.0755
R396 VDD.n166 VDD.n150 0.0755
R397 VDD.n157 VDD.n156 0.0755
R398 VDD.n102 VDD.n101 0.0755
R399 VDD.n192 VDD.n1 0.0755
R400 VDD.n69 VDD.n68 0.075125
R401 VDD.n32 VDD.n7 0.0749375
R402 VDD.n101 VDD.n0 0.0748482
R403 VDD.n43 VDD.n42 0.0745446
R404 VDD.n21 VDD.n11 0.0734375
R405 VDD.n76 VDD.n75 0.072875
R406 VDD.n190 VDD.n189 0.0723125
R407 VDD.n173 VDD.n16 0.07175
R408 VDD.n47 VDD.n46 0.07175
R409 VDD.n49 VDD.n20 0.07175
R410 VDD.n52 VDD.n51 0.07175
R411 VDD.n56 VDD.n54 0.07175
R412 VDD.n55 VDD.n17 0.07175
R413 VDD.n172 VDD.n171 0.07175
R414 VDD.n168 VDD.n18 0.07175
R415 VDD.n167 VDD.n149 0.07175
R416 VDD.n163 VDD.n162 0.07175
R417 VDD.n159 VDD.n154 0.07175
R418 VDD.n27 VDD.n26 0.071375
R419 VDD.n28 VDD.n25 0.071375
R420 VDD.n33 VDD.n31 0.071375
R421 VDD.n37 VDD.n34 0.071375
R422 VDD.n38 VDD.n22 0.071375
R423 VDD.n42 VDD.n40 0.071375
R424 VDD.n114 VDD.n113 0.0704375
R425 VDD.n72 VDD.n66 0.069875
R426 VDD.n74 VDD.n73 0.069875
R427 VDD.n125 VDD.n62 0.069875
R428 VDD.n124 VDD.n63 0.069875
R429 VDD.n120 VDD.n119 0.069875
R430 VDD.n116 VDD.n81 0.069875
R431 VDD.n115 VDD.n83 0.069875
R432 VDD.n111 VDD.n110 0.069875
R433 VDD.n107 VDD.n90 0.069875
R434 VDD.n106 VDD.n91 0.069875
R435 VDD.n145 VDD.n144 0.0694655
R436 VDD.n137 VDD.n136 0.0694655
R437 VDD.n78 VDD.n77 0.069125
R438 VDD.n164 VDD.n153 0.06875
R439 VDD.n193 VDD.n0 0.0678661
R440 VDD.n170 VDD.n147 0.067625
R441 VDD.n127 VDD.n60 0.06725
R442 VDD.n41 VDD.n10 0.0670625
R443 VDD.n70 VDD.n66 0.0650391
R444 VDD.n174 VDD.n15 0.064625
R445 VDD.n105 VDD.n104 0.0625625
R446 VDD.n53 VDD.n14 0.0580625
R447 VDD.n50 VDD.n12 0.0576875
R448 VDD.n24 VDD.n6 0.0550625
R449 VDD.n158 VDD 0.054875
R450 VDD.n85 VDD.n84 0.0505625
R451 VDD.n98 VDD.n2 0.0498125
R452 VDD.n122 VDD.n121 0.0486875
R453 VDD.n99 VDD.n98 0.0460625
R454 VDD.n84 VDD.n80 0.0453125
R455 VDD.n93 VDD.n92 0.044375
R456 VDD.n9 VDD.n8 0.044375
R457 VDD.n165 VDD.n164 0.04325
R458 VDD.n24 VDD.n5 0.0408125
R459 VDD.n75 VDD.n65 0.039125
R460 VDD.n50 VDD.n13 0.0381875
R461 VDD.n53 VDD.n13 0.0378125
R462 VDD.n68 VDD.n65 0.036875
R463 VDD.n5 VDD.n3 0.0351875
R464 VDD.n166 VDD.n165 0.03275
R465 VDD.n121 VDD.n80 0.0306875
R466 VDD.n100 VDD.n99 0.0299375
R467 VDD.n123 VDD.n122 0.0273125
R468 VDD.n191 VDD.n2 0.0261875
R469 VDD.n114 VDD.n85 0.0254375
R470 VDD.n32 VDD.n6 0.0209375
R471 VDD.n35 VDD.n8 0.0198125
R472 VDD.n44 VDD.n12 0.0183125
R473 VDD.n15 VDD.n14 0.0179375
R474 VDD VDD.n155 0.017375
R475 VDD.n105 VDD.n92 0.0168125
R476 VDD.n93 VDD.n89 0.0153125
R477 VDD.n104 VDD.n103 0.0134375
R478 VDD.n41 VDD.n9 0.0123125
R479 VDD.n174 VDD.n173 0.011375
R480 VDD.n21 VDD.n10 0.0089375
R481 VDD.n127 VDD.n126 0.00875
R482 VDD.n147 VDD.n58 0.008375
R483 VDD.n193 VDD.n192 0.008
R484 VDD.n156 VDD.n153 0.00725
R485 VDD.n123 VDD.n78 0.006875
R486 VDD.n74 VDD.n72 0.006125
R487 VDD.n73 VDD.n62 0.006125
R488 VDD.n125 VDD.n124 0.006125
R489 VDD.n120 VDD.n63 0.006125
R490 VDD.n119 VDD.n81 0.006125
R491 VDD.n116 VDD.n115 0.006125
R492 VDD.n111 VDD.n83 0.006125
R493 VDD.n110 VDD.n90 0.006125
R494 VDD.n107 VDD.n106 0.006125
R495 VDD.n102 VDD.n91 0.006125
R496 VDD.n113 VDD.n112 0.0055625
R497 VDD.n26 VDD.n1 0.004625
R498 VDD.n28 VDD.n27 0.004625
R499 VDD.n31 VDD.n25 0.004625
R500 VDD.n34 VDD.n33 0.004625
R501 VDD.n38 VDD.n37 0.004625
R502 VDD.n40 VDD.n22 0.004625
R503 VDD.n150 VDD.n16 0.00425
R504 VDD.n47 VDD.n20 0.00425
R505 VDD.n51 VDD.n49 0.00425
R506 VDD.n54 VDD.n52 0.00425
R507 VDD.n56 VDD.n55 0.00425
R508 VDD.n172 VDD.n17 0.00425
R509 VDD.n171 VDD.n18 0.00425
R510 VDD.n168 VDD.n167 0.00425
R511 VDD.n163 VDD.n149 0.00425
R512 VDD.n162 VDD.n154 0.00425
R513 VDD.n159 VDD.n158 0.00425
R514 VDD.n189 VDD.n3 0.0036875
R515 VDD.n77 VDD.n76 0.003125
R516 VDD.n45 VDD.n11 0.0025625
R517 VDD.n36 VDD.n7 0.0010625
R518 VSS.t22 VSS.t54 340653
R519 VSS.t46 VSS.t8 155.035
R520 VSS.t56 VSS.t39 134.916
R521 VSS.t14 VSS.t30 134.916
R522 VSS.t38 VSS.t40 121.504
R523 VSS.t6 VSS.t32 99.8063
R524 VSS.t34 VSS.t12 99.8063
R525 VSS.t36 VSS.t58 99.8063
R526 VSS.t2 VSS.t18 99.8063
R527 VSS.t4 VSS.t56 99.8063
R528 VSS.t10 VSS.t20 99.8063
R529 VSS.t20 VSS.t16 99.8063
R530 VSS.n254 VSS.t58 97.6366
R531 VSS.t12 VSS.t44 97.4394
R532 VSS.t18 VSS.t63 84.8157
R533 VSS.t42 VSS.t61 80.8708
R534 VSS.t0 VSS.t42 78.1094
R535 VSS.t32 VSS.t67 73.77
R536 VSS.t40 VSS.t65 63.9078
R537 VSS.t54 VSS.t52 58.3849
R538 VSS.t52 VSS.t50 58.3849
R539 VSS.t50 VSS.t48 58.3849
R540 VSS.t48 VSS.t46 58.3849
R541 VSS.t28 VSS.t26 58.3849
R542 VSS.t26 VSS.t24 58.3849
R543 VSS.t24 VSS.t22 58.3849
R544 VSS VSS.t88 56.3378
R545 VSS.t8 VSS.t6 50.4951
R546 VSS.t16 VSS.t14 50.4951
R547 VSS.t30 VSS.t59 37.8715
R548 VSS.t65 VSS.t36 35.899
R549 VSS.t44 VSS.t38 33.1376
R550 VSS.t39 VSS.t0 33.1376
R551 VSS.t67 VSS.t34 26.0368
R552 VSS.n254 VSS.t2 23.8671
R553 VSS.t59 VSS.t28 20.5139
R554 VSS.t61 VSS.t10 18.936
R555 VSS.t63 VSS.t4 14.9911
R556 VSS VSS.n259 12.3044
R557 VSS.n50 VSS.t13 12.2626
R558 VSS.n57 VSS.t41 12.2626
R559 VSS.n58 VSS.t37 12.2626
R560 VSS.n80 VSS.t57 12.2626
R561 VSS.n86 VSS.t43 12.2626
R562 VSS.n149 VSS.t5 11.6171
R563 VSS.n9 VSS.t35 10.9339
R564 VSS.n131 VSS.t11 10.9339
R565 VSS.n3 VSS.t45 6.73842
R566 VSS.n75 VSS.t19 6.73842
R567 VSS.n82 VSS.t1 6.73842
R568 VSS.n70 VSS.t3 5.07271
R569 VSS.n39 VSS.t33 3.66909
R570 VSS.n88 VSS.t21 3.66909
R571 VSS.n31 VSS.t9 2.40914
R572 VSS.n37 VSS.t7 2.40914
R573 VSS.n93 VSS.t17 2.40914
R574 VSS.n122 VSS.t15 2.40914
R575 VSS.n219 VSS.t83 1.68581
R576 VSS.n106 VSS.n103 1.57925
R577 VSS.n27 VSS.n14 1.5755
R578 VSS.n34 VSS.n11 1.5755
R579 VSS.n62 VSS.n56 1.5755
R580 VSS.n154 VSS.n1 1.5755
R581 VSS.n126 VSS.n90 1.5755
R582 VSS.n119 VSS.n118 1.5755
R583 VSS.n109 VSS.n103 1.5755
R584 VSS.n171 VSS.t78 1.5185
R585 VSS.n171 VSS.t73 1.5185
R586 VSS.n186 VSS.t74 1.5185
R587 VSS.t69 VSS.n186 1.5185
R588 VSS.n229 VSS.t87 1.5185
R589 VSS.n233 VSS.t84 1.5185
R590 VSS.t79 VSS.n233 1.5185
R591 VSS.n105 VSS.t60 1.5185
R592 VSS.n13 VSS.t68 1.5185
R593 VSS.n181 VSS.n180 1.5005
R594 VSS.n179 VSS.n173 1.5005
R595 VSS.n178 VSS.n177 1.5005
R596 VSS.n176 VSS.n174 1.5005
R597 VSS.n175 VSS.n160 1.5005
R598 VSS.n205 VSS.n204 1.5005
R599 VSS.n203 VSS.n159 1.5005
R600 VSS.n202 VSS.n201 1.5005
R601 VSS.n200 VSS.n161 1.5005
R602 VSS.n199 VSS.n198 1.5005
R603 VSS.n197 VSS.n162 1.5005
R604 VSS.n196 VSS.n195 1.5005
R605 VSS.n194 VSS.n163 1.5005
R606 VSS.n193 VSS.n192 1.5005
R607 VSS.n191 VSS.n165 1.5005
R608 VSS.n190 VSS.n189 1.5005
R609 VSS.n228 VSS.n227 1.5005
R610 VSS.n226 VSS.n220 1.5005
R611 VSS.n225 VSS.n224 1.5005
R612 VSS.n223 VSS.n221 1.5005
R613 VSS.n222 VSS.n209 1.5005
R614 VSS.n252 VSS.n251 1.5005
R615 VSS.n250 VSS.n208 1.5005
R616 VSS.n249 VSS.n248 1.5005
R617 VSS.n247 VSS.n210 1.5005
R618 VSS.n246 VSS.n245 1.5005
R619 VSS.n244 VSS.n211 1.5005
R620 VSS.n243 VSS.n242 1.5005
R621 VSS.n241 VSS.n212 1.5005
R622 VSS.n240 VSS.n239 1.5005
R623 VSS.n238 VSS.n214 1.5005
R624 VSS.n237 VSS.n236 1.5005
R625 VSS.n109 VSS.n108 1.5005
R626 VSS.n111 VSS.n110 1.5005
R627 VSS.n97 VSS.n96 1.5005
R628 VSS.n118 VSS.n117 1.5005
R629 VSS.n126 VSS.n125 1.5005
R630 VSS.n128 VSS.n127 1.5005
R631 VSS.n85 VSS.n84 1.5005
R632 VSS.n135 VSS.n134 1.5005
R633 VSS.n137 VSS.n136 1.5005
R634 VSS.n79 VSS.n78 1.5005
R635 VSS.n144 VSS.n143 1.5005
R636 VSS.n146 VSS.n145 1.5005
R637 VSS.n73 VSS.n72 1.5005
R638 VSS.n153 VSS.n152 1.5005
R639 VSS.n155 VSS.n154 1.5005
R640 VSS.n62 VSS.n61 1.5005
R641 VSS.n64 VSS.n63 1.5005
R642 VSS.n55 VSS.n5 1.5005
R643 VSS.n54 VSS.n53 1.5005
R644 VSS.n46 VSS.n7 1.5005
R645 VSS.n45 VSS.n44 1.5005
R646 VSS.n43 VSS.n42 1.5005
R647 VSS.n12 VSS.n11 1.5005
R648 VSS.n28 VSS.n27 1.5005
R649 VSS.n26 VSS.n25 1.5005
R650 VSS.n24 VSS.n23 1.5005
R651 VSS.n21 VSS.n16 1.5005
R652 VSS.n30 VSS.n29 1.5005
R653 VSS.n33 VSS.n32 1.5005
R654 VSS.n36 VSS.n35 1.5005
R655 VSS.n41 VSS.n40 1.5005
R656 VSS.n38 VSS.n10 1.5005
R657 VSS.n48 VSS.n47 1.5005
R658 VSS.n49 VSS.n8 1.5005
R659 VSS.n52 VSS.n51 1.5005
R660 VSS.n66 VSS.n65 1.5005
R661 VSS.n6 VSS.n4 1.5005
R662 VSS.n60 VSS.n59 1.5005
R663 VSS.n2 VSS.n0 1.5005
R664 VSS.n258 VSS.n257 1.5005
R665 VSS.n157 VSS.n156 1.5005
R666 VSS.n74 VSS.n71 1.5005
R667 VSS.n151 VSS.n150 1.5005
R668 VSS.n148 VSS.n147 1.5005
R669 VSS.n77 VSS.n76 1.5005
R670 VSS.n142 VSS.n141 1.5005
R671 VSS.n139 VSS.n138 1.5005
R672 VSS.n87 VSS.n83 1.5005
R673 VSS.n133 VSS.n132 1.5005
R674 VSS.n130 VSS.n129 1.5005
R675 VSS.n92 VSS.n89 1.5005
R676 VSS.n124 VSS.n123 1.5005
R677 VSS.n121 VSS.n120 1.5005
R678 VSS.n98 VSS.n95 1.5005
R679 VSS.n116 VSS.n115 1.5005
R680 VSS.n113 VSS.n112 1.5005
R681 VSS.n104 VSS.n102 1.5005
R682 VSS.n107 VSS.n106 1.5005
R683 VSS.n15 VSS.t47 1.25759
R684 VSS.n94 VSS.t31 1.25759
R685 VSS.n123 VSS.n91 1.1405
R686 VSS.n188 VSS.n167 1.1405
R687 VSS.n188 VSS.n187 1.1405
R688 VSS.n183 VSS.n182 1.1405
R689 VSS.n182 VSS.n170 1.1405
R690 VSS.n184 VSS.n158 1.1405
R691 VSS.n169 VSS.n158 1.1405
R692 VSS.n185 VSS.n164 1.1405
R693 VSS.n168 VSS.n164 1.1405
R694 VSS.n235 VSS.n216 1.1405
R695 VSS.n235 VSS.n234 1.1405
R696 VSS.n230 VSS.n229 1.1405
R697 VSS.n231 VSS.n207 1.1405
R698 VSS.n218 VSS.n207 1.1405
R699 VSS.n232 VSS.n213 1.1405
R700 VSS.n217 VSS.n213 1.1405
R701 VSS.n140 VSS.n81 1.1405
R702 VSS.n256 VSS.n69 1.1405
R703 VSS.n68 VSS.n67 1.1405
R704 VSS.n19 VSS.n18 0.785088
R705 VSS.n22 VSS.n20 0.785088
R706 VSS.n114 VSS.n99 0.785088
R707 VSS.n101 VSS.n100 0.785088
R708 VSS.n26 VSS.n17 0.611167
R709 VSS.n19 VSS.n17 0.552645
R710 VSS.n18 VSS.t55 0.473
R711 VSS.n18 VSS.t53 0.473
R712 VSS.n20 VSS.t51 0.473
R713 VSS.n20 VSS.t49 0.473
R714 VSS.n99 VSS.t29 0.473
R715 VSS.n99 VSS.t27 0.473
R716 VSS.n100 VSS.t25 0.473
R717 VSS.n100 VSS.t23 0.473
R718 VSS.n91 VSS.t62 0.3785
R719 VSS.t60 VSS.n91 0.3785
R720 VSS.n187 VSS.t70 0.3785
R721 VSS.n187 VSS.t69 0.3785
R722 VSS.t75 VSS.n167 0.3785
R723 VSS.t74 VSS.n167 0.3785
R724 VSS.t78 VSS.n170 0.3785
R725 VSS.n170 VSS.t77 0.3785
R726 VSS.n183 VSS.t73 0.3785
R727 VSS.t72 VSS.n183 0.3785
R728 VSS.t77 VSS.n169 0.3785
R729 VSS.n169 VSS.t76 0.3785
R730 VSS.n184 VSS.t72 0.3785
R731 VSS.t71 VSS.n184 0.3785
R732 VSS.t76 VSS.n168 0.3785
R733 VSS.n168 VSS.t75 0.3785
R734 VSS.n185 VSS.t71 0.3785
R735 VSS.t70 VSS.n185 0.3785
R736 VSS.n234 VSS.t80 0.3785
R737 VSS.n234 VSS.t79 0.3785
R738 VSS.t85 VSS.n216 0.3785
R739 VSS.t84 VSS.n216 0.3785
R740 VSS.n230 VSS.t83 0.3785
R741 VSS.t82 VSS.n230 0.3785
R742 VSS.t87 VSS.n218 0.3785
R743 VSS.n218 VSS.t86 0.3785
R744 VSS.n231 VSS.t82 0.3785
R745 VSS.t81 VSS.n231 0.3785
R746 VSS.t86 VSS.n217 0.3785
R747 VSS.n217 VSS.t85 0.3785
R748 VSS.n232 VSS.t81 0.3785
R749 VSS.t80 VSS.n232 0.3785
R750 VSS.n81 VSS.t64 0.3785
R751 VSS.t62 VSS.n81 0.3785
R752 VSS.n69 VSS.t66 0.3785
R753 VSS.t64 VSS.n69 0.3785
R754 VSS.n68 VSS.t68 0.3785
R755 VSS.t66 VSS.n68 0.3785
R756 VSS.n190 VSS.n166 0.328197
R757 VSS.n237 VSS.n215 0.328197
R758 VSS.n180 VSS.n172 0.317004
R759 VSS.n227 VSS.n219 0.317004
R760 VSS.n186 VSS.n166 0.192017
R761 VSS.n233 VSS.n215 0.192017
R762 VSS.n182 VSS.n172 0.181584
R763 VSS.n229 VSS.n219 0.181584
R764 VSS.n172 VSS.n171 0.167812
R765 VSS.n188 VSS.n166 0.161355
R766 VSS.n235 VSS.n215 0.161355
R767 VSS.n24 VSS.n17 0.100692
R768 VSS.n180 VSS.n179 0.0755
R769 VSS.n179 VSS.n178 0.0755
R770 VSS.n178 VSS.n174 0.0755
R771 VSS.n174 VSS.n160 0.0755
R772 VSS.n204 VSS.n160 0.0755
R773 VSS.n204 VSS.n203 0.0755
R774 VSS.n203 VSS.n202 0.0755
R775 VSS.n202 VSS.n161 0.0755
R776 VSS.n198 VSS.n161 0.0755
R777 VSS.n198 VSS.n197 0.0755
R778 VSS.n197 VSS.n196 0.0755
R779 VSS.n196 VSS.n163 0.0755
R780 VSS.n192 VSS.n163 0.0755
R781 VSS.n192 VSS.n191 0.0755
R782 VSS.n191 VSS.n190 0.0755
R783 VSS.n181 VSS.n173 0.0755
R784 VSS.n177 VSS.n173 0.0755
R785 VSS.n177 VSS.n176 0.0755
R786 VSS.n176 VSS.n175 0.0755
R787 VSS.n205 VSS.n159 0.0755
R788 VSS.n201 VSS.n159 0.0755
R789 VSS.n201 VSS.n200 0.0755
R790 VSS.n200 VSS.n199 0.0755
R791 VSS.n199 VSS.n162 0.0755
R792 VSS.n195 VSS.n194 0.0755
R793 VSS.n194 VSS.n193 0.0755
R794 VSS.n193 VSS.n165 0.0755
R795 VSS.n189 VSS.n165 0.0755
R796 VSS.n189 VSS.n188 0.0755
R797 VSS.n227 VSS.n226 0.0755
R798 VSS.n226 VSS.n225 0.0755
R799 VSS.n225 VSS.n221 0.0755
R800 VSS.n221 VSS.n209 0.0755
R801 VSS.n251 VSS.n209 0.0755
R802 VSS.n251 VSS.n250 0.0755
R803 VSS.n250 VSS.n249 0.0755
R804 VSS.n249 VSS.n210 0.0755
R805 VSS.n245 VSS.n210 0.0755
R806 VSS.n245 VSS.n244 0.0755
R807 VSS.n244 VSS.n243 0.0755
R808 VSS.n243 VSS.n212 0.0755
R809 VSS.n239 VSS.n212 0.0755
R810 VSS.n239 VSS.n238 0.0755
R811 VSS.n238 VSS.n237 0.0755
R812 VSS.n228 VSS.n220 0.0755
R813 VSS.n224 VSS.n220 0.0755
R814 VSS.n224 VSS.n223 0.0755
R815 VSS.n223 VSS.n222 0.0755
R816 VSS.n252 VSS.n208 0.0755
R817 VSS.n248 VSS.n208 0.0755
R818 VSS.n248 VSS.n247 0.0755
R819 VSS.n247 VSS.n246 0.0755
R820 VSS.n246 VSS.n211 0.0755
R821 VSS.n242 VSS.n241 0.0755
R822 VSS.n241 VSS.n240 0.0755
R823 VSS.n240 VSS.n214 0.0755
R824 VSS.n236 VSS.n214 0.0755
R825 VSS.n236 VSS.n235 0.0755
R826 VSS.n32 VSS.n30 0.0755
R827 VSS.n49 VSS.n48 0.0755
R828 VSS.n66 VSS.n4 0.0755
R829 VSS.n257 VSS.n2 0.0755
R830 VSS.n148 VSS.n76 0.0755
R831 VSS.n132 VSS.n87 0.0755
R832 VSS.n115 VSS.n98 0.0755
R833 VSS.n27 VSS.n26 0.0755
R834 VSS.n43 VSS.n11 0.0755
R835 VSS.n44 VSS.n43 0.0755
R836 VSS.n44 VSS.n7 0.0755
R837 VSS.n54 VSS.n7 0.0755
R838 VSS.n55 VSS.n54 0.0755
R839 VSS.n63 VSS.n55 0.0755
R840 VSS.n63 VSS.n62 0.0755
R841 VSS.n154 VSS.n153 0.0755
R842 VSS.n153 VSS.n72 0.0755
R843 VSS.n145 VSS.n72 0.0755
R844 VSS.n145 VSS.n144 0.0755
R845 VSS.n144 VSS.n78 0.0755
R846 VSS.n136 VSS.n78 0.0755
R847 VSS.n136 VSS.n135 0.0755
R848 VSS.n135 VSS.n84 0.0755
R849 VSS.n127 VSS.n84 0.0755
R850 VSS.n127 VSS.n126 0.0755
R851 VSS.n118 VSS.n96 0.0755
R852 VSS.n110 VSS.n96 0.0755
R853 VSS.n110 VSS.n109 0.0755
R854 VSS.n23 VSS.n19 0.075125
R855 VSS.n150 VSS.n149 0.0749375
R856 VSS.n21 VSS.n15 0.072875
R857 VSS.n121 VSS.n94 0.07175
R858 VSS.n120 VSS.n119 0.07175
R859 VSS.n117 VSS.n95 0.07175
R860 VSS.n116 VSS.n97 0.07175
R861 VSS.n112 VSS.n111 0.07175
R862 VSS.n108 VSS.n102 0.07175
R863 VSS.n38 VSS.n9 0.0704375
R864 VSS.n113 VSS.n101 0.06875
R865 VSS.n254 VSS.n253 0.0680325
R866 VSS.n254 VSS.n206 0.0680325
R867 VSS.n255 VSS.n254 0.0680325
R868 VSS.n123 VSS.n122 0.0614375
R869 VSS.n34 VSS.n33 0.060875
R870 VSS.n35 VSS.n12 0.060875
R871 VSS.n42 VSS.n41 0.060875
R872 VSS.n45 VSS.n10 0.060875
R873 VSS.n47 VSS.n46 0.060875
R874 VSS.n53 VSS.n8 0.060875
R875 VSS.n52 VSS.n5 0.060875
R876 VSS.n65 VSS.n64 0.060875
R877 VSS.n61 VSS.n6 0.060875
R878 VSS.n60 VSS.n56 0.060875
R879 VSS.n51 VSS.n50 0.0606875
R880 VSS.n182 VSS.n181 0.0605
R881 VSS.n175 VSS.n158 0.0605
R882 VSS.n229 VSS.n228 0.0605
R883 VSS.n222 VSS.n207 0.0605
R884 VSS.n67 VSS.n66 0.0605
R885 VSS.n257 VSS.n256 0.0605
R886 VSS.n25 VSS.n16 0.059375
R887 VSS.n29 VSS.n28 0.059375
R888 VSS.n33 VSS.n14 0.059375
R889 VSS.n93 VSS.n92 0.0580625
R890 VSS.n131 VSS.n130 0.0576875
R891 VSS.n141 VSS.n80 0.0561875
R892 VSS.n75 VSS.n74 0.0550625
R893 VSS.n107 VSS 0.054875
R894 VSS.n40 VSS.n39 0.0505625
R895 VSS.n59 VSS.n58 0.0498125
R896 VSS.n259 VSS.n258 0.04925
R897 VSS.n59 VSS.n57 0.0460625
R898 VSS.n195 VSS.n164 0.0455
R899 VSS.n242 VSS.n213 0.0455
R900 VSS.n140 VSS.n139 0.0455
R901 VSS.n105 VSS.n104 0.0455
R902 VSS.n40 VSS.n37 0.0453125
R903 VSS.n86 VSS.n82 0.044375
R904 VSS.n114 VSS.n113 0.04325
R905 VSS.n156 VSS.n1 0.041375
R906 VSS.n155 VSS.n71 0.041375
R907 VSS.n152 VSS.n151 0.041375
R908 VSS.n147 VSS.n73 0.041375
R909 VSS.n146 VSS.n77 0.041375
R910 VSS.n143 VSS.n142 0.041375
R911 VSS.n138 VSS.n79 0.041375
R912 VSS.n137 VSS.n83 0.041375
R913 VSS.n134 VSS.n133 0.041375
R914 VSS.n129 VSS.n85 0.041375
R915 VSS.n128 VSS.n89 0.041375
R916 VSS.n125 VSS.n124 0.041375
R917 VSS.n120 VSS.n90 0.041375
R918 VSS.n74 VSS.n70 0.0408125
R919 VSS.n22 VSS.n21 0.039125
R920 VSS.n130 VSS.n88 0.0381875
R921 VSS.n92 VSS.n88 0.0378125
R922 VSS.n23 VSS.n22 0.036875
R923 VSS.n157 VSS.n70 0.0351875
R924 VSS.n258 VSS.n1 0.034625
R925 VSS.n156 VSS.n155 0.034625
R926 VSS.n152 VSS.n71 0.034625
R927 VSS.n151 VSS.n73 0.034625
R928 VSS.n147 VSS.n146 0.034625
R929 VSS.n143 VSS.n77 0.034625
R930 VSS.n142 VSS.n79 0.034625
R931 VSS.n138 VSS.n137 0.034625
R932 VSS.n134 VSS.n83 0.034625
R933 VSS.n133 VSS.n85 0.034625
R934 VSS.n129 VSS.n128 0.034625
R935 VSS.n125 VSS.n89 0.034625
R936 VSS.n124 VSS.n90 0.034625
R937 VSS.n115 VSS.n114 0.03275
R938 VSS.n37 VSS.n36 0.0306875
R939 VSS.n164 VSS.n162 0.0305
R940 VSS.n213 VSS.n211 0.0305
R941 VSS.n36 VSS.n13 0.0305
R942 VSS.n141 VSS.n140 0.0305
R943 VSS.n106 VSS.n105 0.0305
R944 VSS.n57 VSS.n4 0.0299375
R945 VSS.n139 VSS.n82 0.0295625
R946 VSS.n32 VSS.n31 0.0273125
R947 VSS.n259 VSS.n0 0.02675
R948 VSS.n58 VSS.n2 0.0261875
R949 VSS.n39 VSS.n38 0.0254375
R950 VSS.n150 VSS.n75 0.0209375
R951 VSS.n80 VSS.n76 0.0198125
R952 VSS.n31 VSS.n13 0.0186875
R953 VSS.n132 VSS.n131 0.0183125
R954 VSS.n123 VSS.n93 0.0179375
R955 VSS VSS.n103 0.017375
R956 VSS.n25 VSS.n24 0.016625
R957 VSS.n28 VSS.n16 0.016625
R958 VSS.n29 VSS.n14 0.016625
R959 VSS.n50 VSS.n49 0.0153125
R960 VSS.n35 VSS.n34 0.015125
R961 VSS.n41 VSS.n12 0.015125
R962 VSS.n42 VSS.n10 0.015125
R963 VSS.n47 VSS.n45 0.015125
R964 VSS.n46 VSS.n8 0.015125
R965 VSS.n53 VSS.n52 0.015125
R966 VSS.n65 VSS.n5 0.015125
R967 VSS.n64 VSS.n6 0.015125
R968 VSS.n61 VSS.n60 0.015125
R969 VSS.n56 VSS.n0 0.015125
R970 VSS.n122 VSS.n121 0.0145625
R971 VSS.n67 VSS.n3 0.0134375
R972 VSS.n206 VSS.n158 0.0123125
R973 VSS.n253 VSS.n207 0.0123125
R974 VSS.n256 VSS.n255 0.0123125
R975 VSS.n104 VSS.n101 0.00725
R976 VSS.n48 VSS.n9 0.0055625
R977 VSS.n98 VSS.n94 0.00425
R978 VSS.n119 VSS.n95 0.00425
R979 VSS.n117 VSS.n116 0.00425
R980 VSS.n112 VSS.n97 0.00425
R981 VSS.n111 VSS.n102 0.00425
R982 VSS.n108 VSS.n107 0.00425
R983 VSS.n206 VSS.n205 0.0036875
R984 VSS.n253 VSS.n252 0.0036875
R985 VSS.n255 VSS.n157 0.0036875
R986 VSS.n30 VSS.n15 0.003125
R987 VSS.n51 VSS.n3 0.0025625
R988 VSS.n87 VSS.n86 0.0025625
R989 VSS.n149 VSS.n148 0.0010625
C0 py1 py3 0.00603f
C1 ls b 0.40078f
C2 tb ta 0.00604f
C3 en_n t 0.00471f
C4 ny0 a_4834_1520# 0.07771f
C5 VDD ta 0.34196f
C6 out_p py2 0
C7 tb VDD 0.93681f
C8 a b 3.32307f
C9 ny4 VDD 3.59332f
C10 ls ta 0.01915f
C11 en_p py1 0.01669f
C12 ny1 a_4834_1520# 0
C13 ls tb 0
C14 py0 py3 0
C15 ls VDD 1.57899f
C16 a ta 1.36616f
C17 a tb 0.11219f
C18 en_n a_4834_1520# 0.00926f
C19 ny0 ny2 0.00602f
C20 a VDD 1.1105f
C21 py0 en_p 1.61625f
C22 a ls 0.00617f
C23 py2 py4 0.00668f
C24 ny1 ny2 1.3635f
C25 ny0 ny3 0
C26 en_n ny2 0.01564f
C27 ny0 b 1.52226f
C28 ny1 ny3 0.00603f
C29 a_9448_1520# py1 0
C30 en_p b 0.03836f
C31 py1 py4 0
C32 VDD py3 1.39912f
C33 en_n ny3 0.0111f
C34 ny0 ta 0
C35 ny1 b 0.00551f
C36 a_4834_1520# t 0
C37 ny0 ny4 0
C38 tb en_p 0.00253f
C39 ny0 VDD 0.35637f
C40 py0 py4 0
C41 py0 a_9448_1520# 0.07497f
C42 en_n b 0.29504f
C43 en_p VDD 1.91288f
C44 ny0 ls 0.06938f
C45 py1 py2 1.36352f
C46 ny1 ny4 0
C47 ny1 VDD 0.32058f
C48 a ny0 0
C49 ny1 ls 0.00148f
C50 a en_p 0.33381f
C51 out_p VDD 10.8686f
C52 en_n VDD 1.55241f
C53 py0 py2 0.00602f
C54 en_n ls 0.43122f
C55 a_9448_1520# b 0
C56 py0 py1 1.35393f
C57 t b 0.73571f
C58 a_9448_1520# VDD 0
C59 VDD py4 3.58597f
C60 en_p py3 0
C61 t ta 1.44336f
C62 tb t 1.36996f
C63 a a_9448_1520# 0.00915f
C64 t VDD 0.49796f
C65 a_4834_1520# b 0.00888f
C66 out_p py3 0.06951f
C67 VDD py2 0.42847f
C68 ny0 ny1 1.35334f
C69 ls t 1.38335f
C70 out_n ny2 0
C71 a t 0.45329f
C72 ny0 en_n 1.26391f
C73 ny2 ny3 1.41161f
C74 a py2 0
C75 a_4834_1520# VDD 0.00141f
C76 out_n ny3 0.08017f
C77 py0 b 0.00943f
C78 ny1 en_n 0.03101f
C79 a_4834_1520# ls 0
C80 py1 VDD 0.31684f
C81 py3 py4 3.10345f
C82 py0 VDD 0.36165f
C83 a py1 0
C84 ny2 ny4 0.00678f
C85 ny2 VDD 0.42942f
C86 a_9448_1520# en_p 0.01543f
C87 ls ny2 0
C88 out_n ny4 2.14292f
C89 out_n VDD 10.8632f
C90 py2 py3 1.41154f
C91 a py0 1.51239f
C92 ny0 t 0.00734f
C93 ny4 ny3 3.10104f
C94 VDD ny3 1.42428f
C95 out_p py4 2.14458f
C96 b ta 0.24752f
C97 en_p py2 0.00231f
C98 tb b 0.52528f
C99 b VDD 1.37403f
C100 out_p VSS 2.81838f
C101 en_p VSS 0.691337f
C102 ls VSS 0.636971f
C103 en_n VSS 0.58518f
C104 out_n VSS 2.81663f
C105 VDD VSS 257.062f
C106 a_9448_1520# VSS 0.13457f
C107 a_4834_1520# VSS 0.13527f
C108 py0 VSS 0.80282f
C109 py1 VSS 0.84746f
C110 tb VSS 1.43825f
C111 a VSS 2.02855f
C112 b VSS 2.81249f
C113 ny0 VSS 0.83789f
C114 ny1 VSS 0.84097f
C115 ta VSS 0.81172f
C116 t VSS 1.29448f
C117 py2 VSS 0.87503f
C118 ny2 VSS 0.88123f
C119 py3 VSS 1.65748f
C120 ny3 VSS 1.64243f
C121 py4 VSS 6.4852f
C122 ny4 VSS 6.46089f
C123 VDD.n0 VSS 0.0631601f
C124 VDD.n1 VSS 0.0181205f
C125 VDD.n2 VSS 0.0265878f
C126 VDD.n3 VSS 0.00867656f
C127 VDD.t57 VSS 0.434848f
C128 VDD.t55 VSS 0.240145f
C129 VDD.t53 VSS 0.240145f
C130 VDD.t51 VSS 0.240145f
C131 VDD.t49 VSS 0.438912f
C132 VDD.t8 VSS 0.422684f
C133 VDD.t6 VSS 0.309104f
C134 VDD.t33 VSS 0.41051f
C135 VDD.t35 VSS 0.41051f
C136 VDD.t13 VSS 0.365889f
C137 VDD.t47 VSS 0.264483f
C138 VDD.t37 VSS 0.35778f
C139 VDD.t41 VSS 0.459195f
C140 VDD.t39 VSS 0.41051f
C141 VDD.t10 VSS 0.394291f
C142 VDD.t40 VSS 0.0105165f
C143 VDD.n4 VSS 0.0479696f
C144 VDD.n5 VSS 0.0265878f
C145 VDD.t3 VSS 0.0254978f
C146 VDD.n6 VSS 0.0265878f
C147 VDD.t20 VSS 0.0193326f
C148 VDD.n7 VSS 0.0265878f
C149 VDD.t5 VSS 0.0114583f
C150 VDD.n8 VSS 0.0238845f
C151 VDD.t60 VSS 0.0105165f
C152 VDD.n9 VSS 0.0221667f
C153 VDD.t44 VSS 0.0114583f
C154 VDD.n10 VSS 0.0265878f
C155 VDD.t1 VSS 0.0114583f
C156 VDD.n11 VSS 0.0265878f
C157 VDD.t46 VSS 0.0105165f
C158 VDD.n12 VSS 0.0265878f
C159 VDD.t12 VSS 0.013961f
C160 VDD.n13 VSS 0.0265878f
C161 VDD.t22 VSS 0.0361102f
C162 VDD.n14 VSS 0.0265878f
C163 VDD.t18 VSS 0.0601778f
C164 VDD.n15 VSS 0.0186786f
C165 VDD.t32 VSS 0.231921f
C166 VDD.n16 VSS 0.10452f
C167 VDD.n17 VSS 0.0171787f
C168 VDD.n18 VSS 0.0171787f
C169 VDD.n19 VSS 0.0343574f
C170 VDD.n20 VSS 0.0171787f
C171 VDD.n21 VSS 0.0186437f
C172 VDD.n22 VSS 0.0171787f
C173 VDD.n23 VSS 0.0343574f
C174 VDD.n24 VSS 0.0217306f
C175 VDD.n25 VSS 0.0171787f
C176 VDD.n26 VSS 0.0194024f
C177 VDD.n27 VSS 0.0171787f
C178 VDD.n28 VSS 0.0171787f
C179 VDD.n29 VSS 0.0788564f
C180 VDD.n30 VSS 0.0343574f
C181 VDD.n31 VSS 0.0171787f
C182 VDD.n32 VSS 0.0217306f
C183 VDD.n33 VSS 0.0171787f
C184 VDD.n34 VSS 0.0171787f
C185 VDD.n35 VSS 0.0215998f
C186 VDD.n36 VSS 0.0173095f
C187 VDD.n37 VSS 0.0171787f
C188 VDD.n38 VSS 0.0171787f
C189 VDD.n39 VSS 0.058896f
C190 VDD.n40 VSS 0.0184083f
C191 VDD.n41 VSS 0.0179548f
C192 VDD.n42 VSS 0.054876f
C193 VDD.n43 VSS 0.0608144f
C194 VDD.n44 VSS 0.0212598f
C195 VDD.n45 VSS 0.0176496f
C196 VDD.n46 VSS 0.0384646f
C197 VDD.n47 VSS 0.019507f
C198 VDD.n48 VSS 0.0809841f
C199 VDD.n49 VSS 0.0171787f
C200 VDD.n50 VSS 0.0217306f
C201 VDD.n51 VSS 0.0171787f
C202 VDD.n52 VSS 0.0171787f
C203 VDD.n53 VSS 0.0217306f
C204 VDD.n54 VSS 0.0171787f
C205 VDD.n55 VSS 0.0171787f
C206 VDD.n56 VSS 0.0171787f
C207 VDD.n57 VSS 0.0343574f
C208 VDD.n58 VSS 0.0189838f
C209 VDD.n59 VSS 0.158594f
C210 VDD.n60 VSS 0.0324652f
C211 VDD.n61 VSS 0.0343574f
C212 VDD.n62 VSS 0.0171787f
C213 VDD.n63 VSS 0.0171787f
C214 VDD.t50 VSS 0.231921f
C215 VDD.t54 VSS 0.0429468f
C216 VDD.t52 VSS 0.0429468f
C217 VDD.n64 VSS 0.182853f
C218 VDD.n65 VSS 0.0676946f
C219 VDD.n66 VSS 0.0408714f
C220 VDD.t58 VSS 0.0429468f
C221 VDD.t56 VSS 0.0429468f
C222 VDD.n67 VSS 0.182853f
C223 VDD.n68 VSS 0.0254193f
C224 VDD.n69 VSS 0.149089f
C225 VDD.n70 VSS 0.109482f
C226 VDD.n71 VSS 0.137404f
C227 VDD.n72 VSS 0.0171787f
C228 VDD.n73 VSS 0.0171787f
C229 VDD.n74 VSS 0.0171787f
C230 VDD.n75 VSS 0.0254193f
C231 VDD.n76 VSS 0.10452f
C232 VDD.n77 VSS 0.0163154f
C233 VDD.n78 VSS 0.0343836f
C234 VDD.t9 VSS 0.0601778f
C235 VDD.n79 VSS 0.0442548f
C236 VDD.n80 VSS 0.0265878f
C237 VDD.n81 VSS 0.0171787f
C238 VDD.n82 VSS 0.0343574f
C239 VDD.n83 VSS 0.0171787f
C240 VDD.n84 VSS 0.0217306f
C241 VDD.n85 VSS 0.0265878f
C242 VDD.t36 VSS 0.013961f
C243 VDD.t34 VSS 0.0361102f
C244 VDD.t7 VSS 0.0601778f
C245 VDD.n86 VSS 0.0319594f
C246 VDD.n87 VSS 0.0365026f
C247 VDD.n88 VSS 0.0435485f
C248 VDD.n89 VSS 0.0205709f
C249 VDD.n90 VSS 0.0171787f
C250 VDD.n91 VSS 0.0184083f
C251 VDD.n92 VSS 0.0231956f
C252 VDD.t38 VSS 0.0114583f
C253 VDD.t48 VSS 0.0114583f
C254 VDD.n93 VSS 0.0228555f
C255 VDD.t14 VSS 0.0105165f
C256 VDD.n94 VSS 0.0434962f
C257 VDD.n95 VSS 0.042598f
C258 VDD.n96 VSS 0.0452664f
C259 VDD.t42 VSS 0.0105165f
C260 VDD.n97 VSS 0.0461645f
C261 VDD.n98 VSS 0.0217394f
C262 VDD.n99 VSS 0.0265878f
C263 VDD.n100 VSS 0.0239194f
C264 VDD.n101 VSS 0.0546841f
C265 VDD.n102 VSS 0.0184693f
C266 VDD.n103 VSS 0.0201436f
C267 VDD.n104 VSS 0.0265878f
C268 VDD.n105 VSS 0.0179548f
C269 VDD.n106 VSS 0.0171787f
C270 VDD.n107 VSS 0.0171787f
C271 VDD.n108 VSS 0.058896f
C272 VDD.n109 VSS 0.0343574f
C273 VDD.n110 VSS 0.0171787f
C274 VDD.n111 VSS 0.0171787f
C275 VDD.n112 VSS 0.0183385f
C276 VDD.n113 VSS 0.0265878f
C277 VDD.n114 VSS 0.0217306f
C278 VDD.n115 VSS 0.0171787f
C279 VDD.n116 VSS 0.0171787f
C280 VDD.n117 VSS 0.0343574f
C281 VDD.n118 VSS 0.0343574f
C282 VDD.n119 VSS 0.0171787f
C283 VDD.n120 VSS 0.0171787f
C284 VDD.n121 VSS 0.0179548f
C285 VDD.n122 VSS 0.0265878f
C286 VDD.n123 VSS 0.00760398f
C287 VDD.n124 VSS 0.0171787f
C288 VDD.n125 VSS 0.0171787f
C289 VDD.n126 VSS 0.019071f
C290 VDD.n127 VSS 0.125004f
C291 VDD.t62 VSS 0.520341f
C292 VDD.t61 VSS 0.763311f
C293 VDD.n128 VSS 0.248516f
C294 VDD.t63 VSS 0.520341f
C295 VDD.t64 VSS 0.763311f
C296 VDD.n129 VSS 0.248516f
C297 VDD.n130 VSS 0.0345493f
C298 VDD.n131 VSS 0.199343f
C299 VDD.t67 VSS 0.520341f
C300 VDD.t72 VSS 0.520341f
C301 VDD.t71 VSS 0.520341f
C302 VDD.t66 VSS 0.520341f
C303 VDD.t70 VSS 0.520341f
C304 VDD.t65 VSS 0.520341f
C305 VDD.n132 VSS 0.460651f
C306 VDD.n133 VSS 0.463232f
C307 VDD.t73 VSS 0.520341f
C308 VDD.t68 VSS 0.520341f
C309 VDD.t74 VSS 0.520341f
C310 VDD.t69 VSS 0.520341f
C311 VDD.n134 VSS 0.460651f
C312 VDD.n135 VSS 0.463232f
C313 VDD.n136 VSS 0.463232f
C314 VDD.n137 VSS 0.170087f
C315 VDD.n138 VSS 0.196003f
C316 VDD.n139 VSS 0.183577f
C317 VDD.t77 VSS 0.520341f
C318 VDD.t82 VSS 0.520341f
C319 VDD.t81 VSS 0.520341f
C320 VDD.t76 VSS 0.520341f
C321 VDD.t80 VSS 0.520341f
C322 VDD.t75 VSS 0.520341f
C323 VDD.n140 VSS 0.460651f
C324 VDD.n141 VSS 0.463232f
C325 VDD.t83 VSS 0.520341f
C326 VDD.t78 VSS 0.520341f
C327 VDD.t84 VSS 0.520341f
C328 VDD.t79 VSS 0.520341f
C329 VDD.n142 VSS 0.460651f
C330 VDD.n143 VSS 0.463232f
C331 VDD.n144 VSS 0.463232f
C332 VDD.n145 VSS 0.170087f
C333 VDD.n146 VSS 0.169032f
C334 VDD.n147 VSS 0.125004f
C335 VDD.n148 VSS 0.0343574f
C336 VDD.n149 VSS 0.0171787f
C337 VDD.n150 VSS 0.0180333f
C338 VDD.t30 VSS 0.0429468f
C339 VDD.t28 VSS 0.0429468f
C340 VDD.n151 VSS 0.182853f
C341 VDD.t26 VSS 0.0429468f
C342 VDD.t24 VSS 0.0429468f
C343 VDD.n152 VSS 0.182853f
C344 VDD.n153 VSS 0.0676946f
C345 VDD.n154 VSS 0.0171787f
C346 VDD.n155 VSS 0.0148068f
C347 VDD.n156 VSS 0.0187222f
C348 VDD.n157 VSS 0.0572827f
C349 VDD.n158 VSS 0.0133157f
C350 VDD.n159 VSS 0.0171787f
C351 VDD.n160 VSS 0.058896f
C352 VDD.n161 VSS 0.0343574f
C353 VDD.n162 VSS 0.0171787f
C354 VDD.n163 VSS 0.0171787f
C355 VDD.n164 VSS 0.0254193f
C356 VDD.n165 VSS 0.0676946f
C357 VDD.n166 VSS 0.0245647f
C358 VDD.n167 VSS 0.0171787f
C359 VDD.n168 VSS 0.0171787f
C360 VDD.n169 VSS 0.0343574f
C361 VDD.n170 VSS 0.0325524f
C362 VDD.n171 VSS 0.0171787f
C363 VDD.n172 VSS 0.0171787f
C364 VDD.n173 VSS 0.0188094f
C365 VDD.n174 VSS 0.0324477f
C366 VDD.t16 VSS 0.0604133f
C367 VDD.n175 VSS 0.0346714f
C368 VDD.n176 VSS 0.0316716f
C369 VDD.n177 VSS 0.0365026f
C370 VDD.n178 VSS 0.0435485f
C371 VDD.n179 VSS 0.0448565f
C372 VDD.n180 VSS 0.0439583f
C373 VDD.n181 VSS 0.042598f
C374 VDD.n182 VSS 0.0434962f
C375 VDD.n183 VSS 0.0450484f
C376 VDD.n184 VSS 0.0412028f
C377 VDD.n185 VSS 0.0371915f
C378 VDD.n186 VSS -0.058303f
C379 VDD.n187 VSS 0.134866f
C380 VDD.t23 VSS 0.434848f
C381 VDD.t25 VSS 0.240145f
C382 VDD.t27 VSS 0.240145f
C383 VDD.t29 VSS 0.240145f
C384 VDD.t31 VSS 0.397535f
C385 VDD.t15 VSS 0.381307f
C386 VDD.t17 VSS 0.309104f
C387 VDD.t21 VSS 0.41051f
C388 VDD.t11 VSS 0.41051f
C389 VDD.t45 VSS 0.447022f
C390 VDD.t0 VSS 0.345615f
C391 VDD.t43 VSS 0.264483f
C392 VDD.t59 VSS 0.365889f
C393 VDD.t4 VSS 0.41051f
C394 VDD.t19 VSS 0.41051f
C395 VDD.t2 VSS 0.254341f
C396 VDD.n188 VSS -0.032814f
C397 VDD.n189 VSS -0.0764758f
C398 VDD.n190 VSS 0.0336249f
C399 VDD.n191 VSS 0.0230648f
C400 VDD.n192 VSS 0.0188966f
C401 VDD.n193 VSS 0.0668313f
C402 VDD.t85 VSS 0.00289509f
C403 out_n.n0 VSS 0.10885f
C404 out_n.n1 VSS 0.0234662f
C405 out_n.n2 VSS 0.0232686f
C406 out_n.n3 VSS 0.0234662f
C407 out_n.n4 VSS 0.0234662f
C408 out_n.n5 VSS 0.0112648f
C409 out_n.t8 VSS 0.117324f
C410 out_n.t9 VSS 0.117324f
C411 out_n.n6 VSS 0.508053f
C412 out_n.n7 VSS 0.149936f
C413 out_n.t1 VSS 0.0469287f
C414 out_n.t3 VSS 0.0469287f
C415 out_n.n8 VSS 0.205499f
C416 out_n.n9 VSS 0.144028f
C417 out_n.n10 VSS 0.0185747f
C418 out_n.n11 VSS 0.00586472f
C419 out_n.n12 VSS 0.00586472f
C420 out_n.n13 VSS 0.0117331f
C421 out_n.n14 VSS 0.0224857f
C422 out_n.n15 VSS 0.0626497f
C423 out_n.n16 VSS 0.0234662f
C424 out_n.n17 VSS 0.0234662f
C425 out_n.n18 VSS 0.0234662f
C426 out_n.n19 VSS 0.0131014f
C427 out_n.n20 VSS 0.0117331f
C428 out_n.t0 VSS 0.117324f
C429 out_n.t5 VSS 0.117324f
C430 out_n.n21 VSS 0.508053f
C431 out_n.n22 VSS 0.149936f
C432 out_n.t2 VSS 0.0469287f
C433 out_n.t7 VSS 0.0469287f
C434 out_n.n23 VSS 0.205499f
C435 out_n.n24 VSS 0.144028f
C436 out_n.n25 VSS 0.00586472f
C437 out_n.n26 VSS 0.00586472f
C438 out_n.n27 VSS 0.0117331f
C439 out_n.n28 VSS 0.0105587f
C440 out_n.n29 VSS 0.0234662f
C441 out_n.n30 VSS 0.0234662f
C442 out_n.n31 VSS 0.0234662f
C443 out_n.n32 VSS 0.0234662f
C444 out_n.n33 VSS 0.0234662f
C445 out_n.t4 VSS 0.645766f
C446 out_n.n34 VSS 0.246871f
C447 out_n.n35 VSS 0.00586472f
C448 out_n.n36 VSS 0.00586472f
C449 out_n.t6 VSS 0.226291f
C450 out_n.n37 VSS 0.217093f
C451 out_n.n38 VSS 0.0111441f
C452 out_n.n39 VSS 0.0123185f
C453 out_n.n40 VSS 0.0539276f
C454 out_n.n41 VSS 0.0485934f
C455 en_n.t1 VSS 0.0289175f
C456 en_n.t0 VSS 0.0199761f
C457 en_n.n0 VSS 0.334997f
C458 ls.t1 VSS 0.0164412f
C459 ls.t0 VSS 0.00733082f
C460 ls.n0 VSS 0.282427f
C461 en_p.t1 VSS 0.0183972f
C462 en_p.t0 VSS 0.013451f
C463 en_p.n0 VSS 0.321065f
C464 out_p.n0 VSS 0.046671f
C465 out_p.n1 VSS 0.00586957f
C466 out_p.n2 VSS 0.0105638f
C467 out_p.n3 VSS 0.0234783f
C468 out_p.n4 VSS 0.0234783f
C469 out_p.n5 VSS 0.00586957f
C470 out_p.n6 VSS 0.0105638f
C471 out_p.n7 VSS 0.0234783f
C472 out_p.n8 VSS 0.0234783f
C473 out_p.n9 VSS 0.0503838f
C474 out_p.n10 VSS 0.00586957f
C475 out_p.n11 VSS 0.0110508f
C476 out_p.t7 VSS 0.117388f
C477 out_p.t4 VSS 0.117388f
C478 out_p.n12 VSS 0.508324f
C479 out_p.n13 VSS 0.15002f
C480 out_p.n14 VSS 0.012325f
C481 out_p.n15 VSS 0.00586957f
C482 out_p.t8 VSS 0.0469529f
C483 out_p.t9 VSS 0.0469529f
C484 out_p.n16 VSS 0.205611f
C485 out_p.n17 VSS 0.144103f
C486 out_p.n18 VSS 0.0117391f
C487 out_p.n19 VSS 0.0162393f
C488 out_p.n20 VSS 0.0234783f
C489 out_p.n21 VSS 0.0234783f
C490 out_p.n22 VSS 0.0234783f
C491 out_p.n23 VSS 0.0234783f
C492 out_p.n24 VSS 0.01937f
C493 out_p.t0 VSS 0.117388f
C494 out_p.t2 VSS 0.117388f
C495 out_p.n25 VSS 0.508324f
C496 out_p.n26 VSS 0.15002f
C497 out_p.n27 VSS 0.0117391f
C498 out_p.n28 VSS 0.00586957f
C499 out_p.t5 VSS 0.0469529f
C500 out_p.t6 VSS 0.0469529f
C501 out_p.n29 VSS 0.205611f
C502 out_p.n30 VSS 0.144103f
C503 out_p.n31 VSS 0.0117391f
C504 out_p.n32 VSS 0.0170229f
C505 out_p.n33 VSS 0.0234783f
C506 out_p.n34 VSS 0.0234783f
C507 out_p.n35 VSS 0.0234783f
C508 out_p.n36 VSS 0.0234783f
C509 out_p.n37 VSS 0.0185864f
C510 out_p.t1 VSS 0.646114f
C511 out_p.n38 VSS 0.247002f
C512 out_p.n39 VSS 0.0117391f
C513 out_p.n40 VSS 0.00586957f
C514 out_p.t3 VSS 0.226412f
C515 out_p.n41 VSS 0.217211f
C516 out_p.n42 VSS 0.105821f
C517 out_p.n43 VSS 0.046627f
.ends
