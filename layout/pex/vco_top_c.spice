* vco_top: magic R+C extraction of layout/vco_top.gds (layout/gen/pex.sh)
* extracted 2026-11-09T21:50:13+01:00 with magic 8.3.642, mode c, from vco_top.gds
.subckt vco_top VDD VDD_LS VSS vctrl bit0 bit1 bit2 bit3 bit4 bitb0 bitb1 bitb2 bitb3 bitb4 ck a0 vbn vg ls
X0 a_36978_7027# vbn a_36688_7607# VSS nfet_03v3 ad=0.56p pd=2.56u as=0.9p ps=4.9u w=2u l=1u
X1 w_36626_300# vbn a_36978_1227# VSS nfet_03v3 ad=0.56p pd=2.56u as=0.56p ps=2.56u w=2u l=1u
X2 a_41364_6447# vbn a_41654_7027# VSS nfet_03v3 ad=0.56p pd=2.56u as=0.56p ps=2.56u w=2u l=1u
X3 VDD VSS a_60350_8387# VDD pfet_03v3 ad=0.225p pd=1.9u as=0.225p ps=1.9u w=0.5u l=10u
X4 a_36978_3547# vbn a_36688_4127# VSS nfet_03v3 ad=0.56p pd=2.56u as=0.56p ps=2.56u w=2u l=1u
X5 a_36978_8187# vbn a_36688_7607# VSS nfet_03v3 ad=0.56p pd=2.56u as=0.56p ps=2.56u w=2u l=1u
X6 a_36978_5867# vbn a_36688_6447# VSS nfet_03v3 ad=0.56p pd=2.56u as=0.56p ps=2.56u w=2u l=1u
X7 a_36688_5287# vbn a_36978_4707# VSS nfet_03v3 ad=0.56p pd=2.56u as=0.56p ps=2.56u w=2u l=1u
X8 a_36688_6447# vbn a_36978_5867# VSS nfet_03v3 ad=0.56p pd=2.56u as=0.56p ps=2.56u w=2u l=1u
X9 a_41654_3547# vbn a_41364_4127# VSS nfet_03v3 ad=0.56p pd=2.56u as=0.56p ps=2.56u w=2u l=1u
X10 a_41654_3547# vbn a_41364_2967# VSS nfet_03v3 ad=0.56p pd=2.56u as=0.9p ps=4.9u w=2u l=1u
X11 a_36978_1227# vbn w_36626_300# VSS nfet_03v3 ad=0.56p pd=2.56u as=0.56p ps=2.56u w=2u l=1u
X12 a_41364_6447# vbn a_41654_7027# VSS nfet_03v3 ad=0.56p pd=2.56u as=0.56p ps=2.56u w=2u l=1u
X13 a_36688_4127# vbn a_36978_3547# VSS nfet_03v3 ad=0.56p pd=2.56u as=0.56p ps=2.56u w=2u l=1u
X14 a_36978_1227# vbn w_36626_300# VSS nfet_03v3 ad=0.56p pd=2.56u as=0.9p ps=4.9u w=2u l=1u
X15 a_36978_2387# vbn a_36688_1807# VSS nfet_03v3 ad=0.56p pd=2.56u as=0.56p ps=2.56u w=2u l=1u
X16 vg a_6896_6633# VSS VSS nfet_03v3 ad=0.336p pd=1.76u as=0.336p ps=1.76u w=1.2u l=5.335u
X17 a_36688_2967# vbn a_36978_2387# VSS nfet_03v3 ad=0.56p pd=2.56u as=0.56p ps=2.56u w=2u l=1u
X18 vbnf bitb0 a_6156_6633# VDD pfet_03v3 ad=2.25p pd=10.9u as=2.25p ps=10.9u w=5u l=0.28u
X19 a_36978_5867# vbn a_36688_6447# VSS nfet_03v3 ad=0.56p pd=2.56u as=0.56p ps=2.56u w=2u l=1u
X20 a_36978_5867# vbn a_36688_5287# VSS nfet_03v3 ad=0.56p pd=2.56u as=0.56p ps=2.56u w=2u l=1u
X21 a_36688_5287# vbn a_36978_4707# VSS nfet_03v3 ad=0.56p pd=2.56u as=0.56p ps=2.56u w=2u l=1u
X22 a_36978_7027# vbn a_36688_7607# VSS nfet_03v3 ad=0.56p pd=2.56u as=0.9p ps=4.9u w=2u l=1u
X23 vg a_6006_896# VSS VSS nfet_03v3 ad=0.336p pd=1.76u as=0.336p ps=1.76u w=1.2u l=5.335u
X24 a_36688_1807# vbn a_36978_2387# VSS nfet_03v3 ad=0.9p pd=4.9u as=0.56p ps=2.56u w=2u l=1u
X25 a_36978_8187# vbn a_36666_9481# VSS nfet_03v3 ad=0.56p pd=2.56u as=0.56p ps=2.56u w=2u l=1u
X26 VSS vg VSS VSS nfet_03v3 ad=13.8195p pd=62.32u as=0.60636n ps=2.37036m w=30.71u l=4u
X27 VSS vbnf vg VSS nfet_03v3 ad=0.336p pd=1.76u as=0.336p ps=1.76u w=1.2u l=5.335u
X28 a_36978_8187# vbn a_36688_7607# VSS nfet_03v3 ad=0.56p pd=2.56u as=0.56p ps=2.56u w=2u l=1u
X29 a_36688_5287# vbn a_36978_4707# VSS nfet_03v3 ad=0.56p pd=2.56u as=0.56p ps=2.56u w=2u l=1u
X30 a_36978_7027# vbn a_36688_7607# VSS nfet_03v3 ad=0.56p pd=2.56u as=0.56p ps=2.56u w=2u l=1u
X31 a_36688_1807# vbn a_36978_1227# VSS nfet_03v3 ad=0.56p pd=2.56u as=0.56p ps=2.56u w=2u l=1u
X32 a_41654_7027# vbn a_41364_6447# VSS nfet_03v3 ad=0.56p pd=2.56u as=0.9p ps=4.9u w=2u l=1u
X33 a_36978_4707# vbn a_36688_5287# VSS nfet_03v3 ad=0.56p pd=2.56u as=0.56p ps=2.56u w=2u l=1u
X34 a_36688_4127# vbn a_36978_3547# VSS nfet_03v3 ad=0.56p pd=2.56u as=0.56p ps=2.56u w=2u l=1u
X35 a_41654_8187# vbn a_41364_7607# VSS nfet_03v3 ad=0.56p pd=2.56u as=0.56p ps=2.56u w=2u l=1u
X36 a_36688_7607# vbn a_36978_8187# VSS nfet_03v3 ad=0.56p pd=2.56u as=0.56p ps=2.56u w=2u l=1u
X37 a_36978_7027# vbn a_36688_7607# VSS nfet_03v3 ad=0.56p pd=2.56u as=0.56p ps=2.56u w=2u l=1u
X38 a_36688_6447# vbn a_36978_5867# VSS nfet_03v3 ad=0.56p pd=2.56u as=0.56p ps=2.56u w=2u l=1u
X39 a_36978_4707# vbn a_36688_5287# VSS nfet_03v3 ad=0.56p pd=2.56u as=0.9p ps=4.9u w=2u l=1u
X40 a_41654_4707# vbn a_41364_4127# VSS nfet_03v3 ad=0.9p pd=4.9u as=0.56p ps=2.56u w=2u l=1u
X41 a_36978_2387# vbn a_36688_1807# VSS nfet_03v3 ad=0.56p pd=2.56u as=0.56p ps=2.56u w=2u l=1u
X42 a_36978_2387# vbn a_36688_2967# VSS nfet_03v3 ad=0.56p pd=2.56u as=0.56p ps=2.56u w=2u l=1u
X43 a_36978_2387# vbn a_36688_2967# VSS nfet_03v3 ad=0.56p pd=2.56u as=0.56p ps=2.56u w=2u l=1u
X44 a_36688_4127# vbn a_36978_3547# VSS nfet_03v3 ad=0.56p pd=2.56u as=0.56p ps=2.56u w=2u l=1u
X45 a_36688_1807# vbn a_36978_1227# VSS nfet_03v3 ad=0.56p pd=2.56u as=0.56p ps=2.56u w=2u l=1u
X46 a_36978_1227# vbn w_36626_300# VSS nfet_03v3 ad=0.56p pd=2.56u as=0.56p ps=2.56u w=2u l=1u
X47 a_36978_3547# vbn a_36688_4127# VSS nfet_03v3 ad=0.56p pd=2.56u as=0.9p ps=4.9u w=2u l=1u
X48 w_36626_300# w_37791_300# VSS nwell r_width=2u r_length=5.025u
X49 VSS a_n5549_6703# q1 VSS nfet_03v3 ad=0.27p pd=2.1u as=0.6p ps=3.2u w=0.6u l=0.28u
X50 a_36688_7607# vbn a_36978_8187# VSS nfet_03v3 ad=0.56p pd=2.56u as=0.56p ps=2.56u w=2u l=1u
X51 a_36688_5287# vbn a_36978_5867# VSS nfet_03v3 ad=0.56p pd=2.56u as=0.56p ps=2.56u w=2u l=1u
X52 a_36978_7027# vbn a_36688_7607# VSS nfet_03v3 ad=0.56p pd=2.56u as=0.56p ps=2.56u w=2u l=1u
X53 a_41364_4127# vbn a_41654_4707# VSS nfet_03v3 ad=0.56p pd=2.56u as=0.56p ps=2.56u w=2u l=1u
X54 a_6006_4704# bitb2 VSS VSS nfet_03v3 ad=0.45p pd=2.9u as=0.45p ps=2.9u w=1u l=0.28u
X55 a_41654_7027# vbn a_41364_7607# VSS nfet_03v3 ad=0.56p pd=2.56u as=0.56p ps=2.56u w=2u l=1u
X56 a_36978_5867# vbn a_36688_6447# VSS nfet_03v3 ad=0.56p pd=2.56u as=0.56p ps=2.56u w=2u l=1u
X57 a_36688_2967# vbn a_36978_3547# VSS nfet_03v3 ad=0.56p pd=2.56u as=0.56p ps=2.56u w=2u l=1u
X58 a_36688_2967# vbn a_36978_2387# VSS nfet_03v3 ad=0.56p pd=2.56u as=0.56p ps=2.56u w=2u l=1u
X59 a_41654_8187# vbn vbn VSS nfet_03v3 ad=0.9p pd=4.9u as=0.56p ps=2.56u w=2u l=1u
X60 a_36688_7607# vbn a_36978_7027# VSS nfet_03v3 ad=0.56p pd=2.56u as=0.56p ps=2.56u w=2u l=1u
X61 a_36978_5867# vbn a_36688_6447# VSS nfet_03v3 ad=0.56p pd=2.56u as=0.56p ps=2.56u w=2u l=1u
X62 a_36978_3547# vbn a_36688_4127# VSS nfet_03v3 ad=0.56p pd=2.56u as=0.9p ps=4.9u w=2u l=1u
X63 a_36978_2387# vbn a_36688_1807# VSS nfet_03v3 ad=0.56p pd=2.56u as=0.56p ps=2.56u w=2u l=1u
X64 a_36978_4707# vbn a_36688_5287# VSS nfet_03v3 ad=0.56p pd=2.56u as=0.56p ps=2.56u w=2u l=1u
X65 a_36688_5287# vbn a_36978_5867# VSS nfet_03v3 ad=0.56p pd=2.56u as=0.56p ps=2.56u w=2u l=1u
X66 a_36688_7607# vbn a_36978_8187# VSS nfet_03v3 ad=0.56p pd=2.56u as=0.56p ps=2.56u w=2u l=1u
X67 a_36978_8187# vbn a_36688_7607# VSS nfet_03v3 ad=0.56p pd=2.56u as=0.9p ps=4.9u w=2u l=1u
X68 a_41364_2967# vbn a_41654_3547# VSS nfet_03v3 ad=0.56p pd=2.56u as=0.56p ps=2.56u w=2u l=1u
X69 a_36978_3547# vbn a_36688_4127# VSS nfet_03v3 ad=0.56p pd=2.56u as=0.56p ps=2.56u w=2u l=1u
X70 a_36978_1227# vbn a_36688_1807# VSS nfet_03v3 ad=0.56p pd=2.56u as=0.56p ps=2.56u w=2u l=1u
X71 a_36688_6447# vbn a_36978_7027# VSS nfet_03v3 ad=0.56p pd=2.56u as=0.56p ps=2.56u w=2u l=1u
X72 a_36688_6447# vbn a_36978_5867# VSS nfet_03v3 ad=0.56p pd=2.56u as=0.56p ps=2.56u w=2u l=1u
X73 a_36978_2387# vbn a_36688_2967# VSS nfet_03v3 ad=0.56p pd=2.56u as=0.56p ps=2.56u w=2u l=1u
X74 VSS vbnf VSS VSS nfet_03v3 ad=13.7592p pd=49.7u as=0 ps=0 w=49.14u l=10u
X75 a_36688_7607# vbn a_36978_7027# VSS nfet_03v3 ad=0.56p pd=2.56u as=0.56p ps=2.56u w=2u l=1u
X76 vbn vbn a_41654_8187# VSS nfet_03v3 ad=0.56p pd=2.56u as=0.56p ps=2.56u w=2u l=1u
X77 a_36978_3547# vbn a_36688_4127# VSS nfet_03v3 ad=0.56p pd=2.56u as=0.56p ps=2.56u w=2u l=1u
X78 a_36978_8187# vbn a_36688_7607# VSS nfet_03v3 ad=0.56p pd=2.56u as=0.9p ps=4.9u w=2u l=1u
X79 a_41654_1227# vbn VSS VSS nfet_03v3 ad=0.9p pd=4.9u as=0.56p ps=2.56u w=2u l=1u
X80 a_36978_4707# vbn a_36688_4127# VSS nfet_03v3 ad=0.56p pd=2.56u as=0.56p ps=2.56u w=2u l=1u
X81 a_41364_4127# vbn a_41654_4707# VSS nfet_03v3 ad=0.56p pd=2.56u as=0.56p ps=2.56u w=2u l=1u
X82 a_41364_6447# vbn a_41654_7027# VSS nfet_03v3 ad=0.56p pd=2.56u as=0.56p ps=2.56u w=2u l=1u
X83 a_n4384_6451# a_n4642_7514# a_n5234_7514# VSS nfet_03v3 ad=0.28p pd=1.56u as=1p ps=4u w=1u l=0.28u
X84 a_36688_1807# vbn a_36978_1227# VSS nfet_03v3 ad=0.56p pd=2.56u as=0.56p ps=2.56u w=2u l=1u
X85 a_36978_5867# vbn a_36688_5287# VSS nfet_03v3 ad=0.56p pd=2.56u as=0.56p ps=2.56u w=2u l=1u
X86 a_36978_5867# vbn a_36688_6447# VSS nfet_03v3 ad=0.56p pd=2.56u as=0.56p ps=2.56u w=2u l=1u
X87 a_36978_8187# vbn a_36688_7607# VSS nfet_03v3 ad=0.56p pd=2.56u as=0.56p ps=2.56u w=2u l=1u
X88 a_36688_1807# vbn a_36978_2387# VSS nfet_03v3 ad=0.56p pd=2.56u as=0.56p ps=2.56u w=2u l=1u
X89 a_36978_3547# vbn a_36688_4127# VSS nfet_03v3 ad=0.56p pd=2.56u as=0.56p ps=2.56u w=2u l=1u
X90 a_36688_1807# vbn a_36978_1227# VSS nfet_03v3 ad=0.56p pd=2.56u as=0.56p ps=2.56u w=2u l=1u
X91 a_41654_3547# vbn a_41364_4127# VSS nfet_03v3 ad=0.56p pd=2.56u as=0.56p ps=2.56u w=2u l=1u
X92 VSS vbn a_41654_1227# VSS nfet_03v3 ad=0.56p pd=2.56u as=0.56p ps=2.56u w=2u l=1u
X93 a_36978_8187# vbn a_36688_7607# VSS nfet_03v3 ad=0.56p pd=2.56u as=0.56p ps=2.56u w=2u l=1u
X94 a_41654_4707# vbn a_41364_5287# VSS nfet_03v3 ad=0.9p pd=4.9u as=0.56p ps=2.56u w=2u l=1u
X95 a_41654_4707# vbn a_41364_4127# VSS nfet_03v3 ad=0.56p pd=2.56u as=0.9p ps=4.9u w=2u l=1u
X96 a_36978_8187# vbn a_36666_9481# VSS nfet_03v3 ad=0.56p pd=2.56u as=0.56p ps=2.56u w=2u l=1u
X97 a_36688_4127# vbn a_36978_3547# VSS nfet_03v3 ad=0.56p pd=2.56u as=0.56p ps=2.56u w=2u l=1u
X98 a_36688_2967# vbn a_36978_3547# VSS nfet_03v3 ad=0.56p pd=2.56u as=0.56p ps=2.56u w=2u l=1u
X99 vbn vbn a_41654_8187# VSS nfet_03v3 ad=0.56p pd=2.56u as=0.56p ps=2.56u w=2u l=1u
X100 a_36688_1807# vbn a_36978_1227# VSS nfet_03v3 ad=0.56p pd=2.56u as=0.56p ps=2.56u w=2u l=1u
X101 a_36688_5287# vbn a_36978_5867# VSS nfet_03v3 ad=0.56p pd=2.56u as=0.56p ps=2.56u w=2u l=1u
X102 a_36688_1807# vbn a_36978_2387# VSS nfet_03v3 ad=0.56p pd=2.56u as=0.56p ps=2.56u w=2u l=1u
X103 VSS vbnf VSS VSS nfet_03v3 ad=13.7592p pd=49.7u as=0 ps=0 w=49.14u l=10u
X104 a_41654_4707# vbn a_41364_4127# VSS nfet_03v3 ad=0.56p pd=2.56u as=0.56p ps=2.56u w=2u l=1u
X105 a_36688_2967# vbn a_36978_2387# VSS nfet_03v3 ad=0.56p pd=2.56u as=0.56p ps=2.56u w=2u l=1u
X106 a_36688_5287# vbn a_36978_5867# VSS nfet_03v3 ad=0.56p pd=2.56u as=0.56p ps=2.56u w=2u l=1u
X107 a_36978_8187# vbn a_36688_7607# VSS nfet_03v3 ad=0.56p pd=2.56u as=0.56p ps=2.56u w=2u l=1u
X108 a_36688_4127# vbn a_36978_3547# VSS nfet_03v3 ad=0.56p pd=2.56u as=0.56p ps=2.56u w=2u l=1u
X109 a_41364_5287# vbn a_41654_4707# VSS nfet_03v3 ad=0.56p pd=2.56u as=0.56p ps=2.56u w=2u l=1u
X110 a_41654_8187# vbn a_41364_7607# VSS nfet_03v3 ad=0.56p pd=2.56u as=0.56p ps=2.56u w=2u l=1u
X111 a_36688_6447# vbn a_36978_7027# VSS nfet_03v3 ad=0.56p pd=2.56u as=0.56p ps=2.56u w=2u l=1u
X112 a_41654_8187# vbn vbn VSS nfet_03v3 ad=0.56p pd=2.56u as=0.9p ps=4.9u w=2u l=1u
X113 a_36688_1807# vbn a_36978_1227# VSS nfet_03v3 ad=0.9p pd=4.9u as=0.56p ps=2.56u w=2u l=1u
X114 a_36688_5287# vbn a_36978_5867# VSS nfet_03v3 ad=0.56p pd=2.56u as=0.56p ps=2.56u w=2u l=1u
X115 a_36688_7607# vbn a_36978_8187# VSS nfet_03v3 ad=0.56p pd=2.56u as=0.56p ps=2.56u w=2u l=1u
X116 a_36978_7027# vbn a_36688_7607# VSS nfet_03v3 ad=0.56p pd=2.56u as=0.56p ps=2.56u w=2u l=1u
X117 a_1867_7085# a_1632_6633# VDD VDD pfet_03v3 ad=2.25p pd=10.9u as=2.25p ps=10.9u w=5u l=0.28u
X118 a_36978_1227# vbn w_36626_300# VSS nfet_03v3 ad=0.56p pd=2.56u as=0.56p ps=2.56u w=2u l=1u
X119 VSS vbn a_41654_1227# VSS nfet_03v3 ad=0.56p pd=2.56u as=0.56p ps=2.56u w=2u l=1u
X120 a_36688_6447# vbn a_36978_5867# VSS nfet_03v3 ad=0.56p pd=2.56u as=0.56p ps=2.56u w=2u l=1u
X121 a_36978_2387# vbn a_36688_2967# VSS nfet_03v3 ad=0.56p pd=2.56u as=0.56p ps=2.56u w=2u l=1u
X122 a_41654_8187# vbn vbn VSS nfet_03v3 ad=0.56p pd=2.56u as=0.56p ps=2.56u w=2u l=1u
X123 a_36978_1227# vbn a_36688_1807# VSS nfet_03v3 ad=0.56p pd=2.56u as=0.56p ps=2.56u w=2u l=1u
X124 a_36688_7607# vbn a_36978_7027# VSS nfet_03v3 ad=0.56p pd=2.56u as=0.56p ps=2.56u w=2u l=1u
X125 VSS a_n7601_6703# a_n8217_6703# VSS nfet_03v3 ad=0.27p pd=2.1u as=0.6p ps=3.2u w=0.6u l=0.28u
X126 a_36978_2387# vbn a_36688_1807# VSS nfet_03v3 ad=0.56p pd=2.56u as=0.56p ps=2.56u w=2u l=1u
X127 a_36978_3547# vbn a_36688_2967# VSS nfet_03v3 ad=0.56p pd=2.56u as=0.56p ps=2.56u w=2u l=1u
X128 VDD_LS a_n5549_6703# q1 VDD_LS pfet_03v3 ad=0.675p pd=3.9u as=1.5p ps=5u w=1.5u l=0.28u
X129 a_36688_7607# vbn a_36978_8187# VSS nfet_03v3 ad=0.56p pd=2.56u as=0.56p ps=2.56u w=2u l=1u
X130 a_36688_5287# vbn a_36978_5867# VSS nfet_03v3 ad=0.9p pd=4.9u as=0.56p ps=2.56u w=2u l=1u
X131 a_41654_1227# vbn VSS VSS nfet_03v3 ad=0.56p pd=2.56u as=0.9p ps=4.9u w=2u l=1u
X132 a_36978_4707# vbn a_36688_5287# VSS nfet_03v3 ad=0.56p pd=2.56u as=0.56p ps=2.56u w=2u l=1u
X133 a_36978_2387# vbn a_36688_2967# VSS nfet_03v3 ad=0.56p pd=2.56u as=0.56p ps=2.56u w=2u l=1u
X134 a_36978_5867# vbn a_36688_6447# VSS nfet_03v3 ad=0.56p pd=2.56u as=0.56p ps=2.56u w=2u l=1u
X135 a_36978_5867# vbn a_36688_5287# VSS nfet_03v3 ad=0.56p pd=2.56u as=0.56p ps=2.56u w=2u l=1u
X136 a_36688_1807# vbn a_36978_2387# VSS nfet_03v3 ad=0.56p pd=2.56u as=0.56p ps=2.56u w=2u l=1u
X137 a_41364_5287# vbn a_41654_4707# VSS nfet_03v3 ad=0.56p pd=2.56u as=0.56p ps=2.56u w=2u l=1u
X138 a_36978_7027# vbn a_36688_6447# VSS nfet_03v3 ad=0.56p pd=2.56u as=0.56p ps=2.56u w=2u l=1u
X139 a_36978_1227# vbn a_36688_1807# VSS nfet_03v3 ad=0.56p pd=2.56u as=0.56p ps=2.56u w=2u l=1u
X140 a_36688_2967# vbn a_36978_3547# VSS nfet_03v3 ad=0.56p pd=2.56u as=0.56p ps=2.56u w=2u l=1u
X141 a_41654_1227# vbn VSS VSS nfet_03v3 ad=0.56p pd=2.56u as=0.56p ps=2.56u w=2u l=1u
X142 vg a_6006_14# VSS VSS nfet_03v3 ad=0.336p pd=1.76u as=0.336p ps=1.76u w=1.2u l=5.335u
X143 a_36688_7607# vbn a_36978_7027# VSS nfet_03v3 ad=0.56p pd=2.56u as=0.56p ps=2.56u w=2u l=1u
X144 a_36978_3547# vbn a_36688_2967# VSS nfet_03v3 ad=0.56p pd=2.56u as=0.56p ps=2.56u w=2u l=1u
X145 a_36688_1807# vbn a_36978_2387# VSS nfet_03v3 ad=0.56p pd=2.56u as=0.56p ps=2.56u w=2u l=1u
X146 a_36978_5867# vbn a_36688_6447# VSS nfet_03v3 ad=0.56p pd=2.56u as=0.56p ps=2.56u w=2u l=1u
X147 a_41654_4707# vbn a_41364_5287# VSS nfet_03v3 ad=0.56p pd=2.56u as=0.9p ps=4.9u w=2u l=1u
X148 a_36688_1807# vbn a_36978_2387# VSS nfet_03v3 ad=0.56p pd=2.56u as=0.56p ps=2.56u w=2u l=1u
X149 vbn a_36666_9481# VDD VDD pfet_03v3 ad=3.92p pd=14.56u as=6.3p ps=28.9u w=14u l=14u
X150 a_36688_6447# vbn a_36978_7027# VSS nfet_03v3 ad=0.56p pd=2.56u as=0.56p ps=2.56u w=2u l=1u
X151 a_36688_4127# vbn a_36978_4707# VSS nfet_03v3 ad=0.9p pd=4.9u as=0.56p ps=2.56u w=2u l=1u
X152 a_36978_3547# vbn a_36688_4127# VSS nfet_03v3 ad=0.56p pd=2.56u as=0.56p ps=2.56u w=2u l=1u
X153 a_36688_2967# vbn a_36978_2387# VSS nfet_03v3 ad=0.56p pd=2.56u as=0.56p ps=2.56u w=2u l=1u
X154 a_36978_7027# vbn a_36688_7607# VSS nfet_03v3 ad=0.56p pd=2.56u as=0.56p ps=2.56u w=2u l=1u
X155 a_41654_2387# vbn a_41364_2967# VSS nfet_03v3 ad=0.9p pd=4.9u as=0.56p ps=2.56u w=2u l=1u
X156 a_36978_5867# vbn a_36688_5287# VSS nfet_03v3 ad=0.56p pd=2.56u as=0.56p ps=2.56u w=2u l=1u
X157 a_36688_2967# vbn a_36978_3547# VSS nfet_03v3 ad=0.56p pd=2.56u as=0.56p ps=2.56u w=2u l=1u
X158 a_41654_4707# vbn a_41364_5287# VSS nfet_03v3 ad=0.56p pd=2.56u as=0.56p ps=2.56u w=2u l=1u
X159 vg vbnf VSS VSS nfet_03v3 ad=0.336p pd=1.76u as=0.336p ps=1.76u w=1.2u l=5.335u
X160 a_36688_4127# vbn a_36978_3547# VSS nfet_03v3 ad=0.56p pd=2.56u as=0.56p ps=2.56u w=2u l=1u
X161 a_36978_7027# vbn a_36688_6447# VSS nfet_03v3 ad=0.56p pd=2.56u as=0.56p ps=2.56u w=2u l=1u
X162 a_41654_1227# vbn a_41364_1807# VSS nfet_03v3 ad=0.56p pd=2.56u as=0.56p ps=2.56u w=2u l=1u
X163 a_n4810_7514# a_n5549_6703# VDD_LS VDD_LS pfet_03v3 ad=0.56p pd=2.56u as=0.56p ps=2.56u w=2u l=0.28u
X164 vg a_6006_14# VSS VSS nfet_03v3 ad=0.336p pd=1.76u as=0.336p ps=1.76u w=1.2u l=5.335u
X165 a_36688_1807# vbn a_36978_2387# VSS nfet_03v3 ad=0.9p pd=4.9u as=0.56p ps=2.56u w=2u l=1u
X166 a_36688_6447# vbn a_36978_5867# VSS nfet_03v3 ad=0.56p pd=2.56u as=0.56p ps=2.56u w=2u l=1u
X167 a_36666_9481# vbn a_36978_8187# VSS nfet_03v3 ad=0.9p pd=4.9u as=0.56p ps=2.56u w=2u l=1u
X168 a_36978_8187# vbn a_36688_7607# VSS nfet_03v3 ad=0.56p pd=2.56u as=0.56p ps=2.56u w=2u l=1u
X169 a_36688_7607# vbn a_36978_7027# VSS nfet_03v3 ad=0.56p pd=2.56u as=0.56p ps=2.56u w=2u l=1u
X170 a_41654_5867# vbn a_41364_6447# VSS nfet_03v3 ad=0.9p pd=4.9u as=0.56p ps=2.56u w=2u l=1u
X171 vg a_6156_6633# VSS VSS nfet_03v3 ad=0.336p pd=1.76u as=0.54p ps=3.3u w=1.2u l=5.335u
X172 a_36688_6447# vbn a_36978_7027# VSS nfet_03v3 ad=0.56p pd=2.56u as=0.56p ps=2.56u w=2u l=1u
X173 a_36978_2387# vbn a_36688_1807# VSS nfet_03v3 ad=0.56p pd=2.56u as=0.56p ps=2.56u w=2u l=1u
X174 a_36978_4707# vbn a_36688_4127# VSS nfet_03v3 ad=0.56p pd=2.56u as=0.56p ps=2.56u w=2u l=1u
X175 a_36688_7607# vbn a_36978_8187# VSS nfet_03v3 ad=0.56p pd=2.56u as=0.56p ps=2.56u w=2u l=1u
X176 a_36688_7607# vbn a_36978_7027# VSS nfet_03v3 ad=0.56p pd=2.56u as=0.56p ps=2.56u w=2u l=1u
X177 a_41364_2967# vbn a_41654_2387# VSS nfet_03v3 ad=0.56p pd=2.56u as=0.56p ps=2.56u w=2u l=1u
X178 a_36688_4127# vbn a_36978_3547# VSS nfet_03v3 ad=0.56p pd=2.56u as=0.56p ps=2.56u w=2u l=1u
X179 a_41654_5867# vbn a_41364_5287# VSS nfet_03v3 ad=0.56p pd=2.56u as=0.56p ps=2.56u w=2u l=1u
X180 a_36688_1807# vbn a_36978_1227# VSS nfet_03v3 ad=0.56p pd=2.56u as=0.56p ps=2.56u w=2u l=1u
X181 vbnf bit1 a_6896_6633# VSS nfet_03v3 ad=0.9p pd=4.9u as=0.9p ps=4.9u w=2u l=0.28u
X182 vg a_6006_14# VSS VSS nfet_03v3 ad=0.336p pd=1.76u as=0.54p ps=3.3u w=1.2u l=5.335u
X183 a_36688_4127# vbn a_36978_4707# VSS nfet_03v3 ad=0.9p pd=4.9u as=0.56p ps=2.56u w=2u l=1u
X184 a_996_6587# a_1867_7085# VDD VDD pfet_03v3 ad=2.25p pd=10.9u as=2.25p ps=10.9u w=5u l=0.28u
X185 a_36688_7607# vbn a_36978_7027# VSS nfet_03v3 ad=0.56p pd=2.56u as=0.56p ps=2.56u w=2u l=1u
X186 a_36978_7027# vbn a_36688_7607# VSS nfet_03v3 ad=0.56p pd=2.56u as=0.56p ps=2.56u w=2u l=1u
X187 w_36626_300# vbn a_36978_1227# VSS nfet_03v3 ad=0.9p pd=4.9u as=0.56p ps=2.56u w=2u l=1u
X188 a_41364_2967# vbn a_41654_2387# VSS nfet_03v3 ad=0.56p pd=2.56u as=0.56p ps=2.56u w=2u l=1u
X189 a_36978_8187# vbn a_36666_9481# VSS nfet_03v3 ad=0.56p pd=2.56u as=0.56p ps=2.56u w=2u l=1u
X190 a_36978_7027# vbn a_36688_7607# VSS nfet_03v3 ad=0.56p pd=2.56u as=0.9p ps=4.9u w=2u l=1u
X191 a_36978_1227# vbn a_36688_1807# VSS nfet_03v3 ad=0.56p pd=2.56u as=0.56p ps=2.56u w=2u l=1u
X192 a_36978_2387# vbn a_36688_1807# VSS nfet_03v3 ad=0.56p pd=2.56u as=0.56p ps=2.56u w=2u l=1u
X193 a_36688_1807# vbn a_36978_1227# VSS nfet_03v3 ad=0.56p pd=2.56u as=0.56p ps=2.56u w=2u l=1u
X194 a_36978_3547# vbn a_36688_4127# VSS nfet_03v3 ad=0.56p pd=2.56u as=0.56p ps=2.56u w=2u l=1u
X195 a_36978_3547# vbn a_36688_2967# VSS nfet_03v3 ad=0.56p pd=2.56u as=0.56p ps=2.56u w=2u l=1u
X196 a_36978_4707# vbn a_36688_4127# VSS nfet_03v3 ad=0.56p pd=2.56u as=0.56p ps=2.56u w=2u l=1u
X197 a_41364_6447# vbn a_41654_5867# VSS nfet_03v3 ad=0.56p pd=2.56u as=0.56p ps=2.56u w=2u l=1u
X198 a_36688_7607# vbn a_36978_8187# VSS nfet_03v3 ad=0.56p pd=2.56u as=0.56p ps=2.56u w=2u l=1u
X199 a_36688_5287# vbn a_36978_5867# VSS nfet_03v3 ad=0.56p pd=2.56u as=0.56p ps=2.56u w=2u l=1u
X200 a_36666_9481# vbn a_36978_8187# VSS nfet_03v3 ad=0.9p pd=4.9u as=0.56p ps=2.56u w=2u l=1u
X201 a_41364_2967# vbn a_41654_2387# VSS nfet_03v3 ad=0.56p pd=2.56u as=0.56p ps=2.56u w=2u l=1u
X202 a_36978_1227# vbn a_36688_1807# VSS nfet_03v3 ad=0.56p pd=2.56u as=0.56p ps=2.56u w=2u l=1u
X203 vbnf bitb4 a_6006_14# VDD pfet_03v3 ad=2.25p pd=10.9u as=2.25p ps=10.9u w=5u l=0.28u
X204 a_41364_6447# vbn a_41654_5867# VSS nfet_03v3 ad=0.56p pd=2.56u as=0.56p ps=2.56u w=2u l=1u
X205 a_36688_5287# vbn a_36978_4707# VSS nfet_03v3 ad=0.9p pd=4.9u as=0.56p ps=2.56u w=2u l=1u
X206 a_36688_4127# vbn a_36978_3547# VSS nfet_03v3 ad=0.56p pd=2.56u as=0.56p ps=2.56u w=2u l=1u
X207 a_36978_3547# vbn a_36688_2967# VSS nfet_03v3 ad=0.56p pd=2.56u as=0.56p ps=2.56u w=2u l=1u
X208 a_36978_7027# vbn a_36688_6447# VSS nfet_03v3 ad=0.56p pd=2.56u as=0.56p ps=2.56u w=2u l=1u
X209 a_36978_8187# vbn a_36688_7607# VSS nfet_03v3 ad=0.56p pd=2.56u as=0.56p ps=2.56u w=2u l=1u
X210 a_36978_5867# vbn a_36688_5287# VSS nfet_03v3 ad=0.56p pd=2.56u as=0.56p ps=2.56u w=2u l=1u
X211 a_36688_5287# vbn a_36978_5867# VSS nfet_03v3 ad=0.56p pd=2.56u as=0.56p ps=2.56u w=2u l=1u
X212 a_36978_8187# vbn a_36666_9481# VSS nfet_03v3 ad=0.56p pd=2.56u as=0.56p ps=2.56u w=2u l=1u
X213 a_36978_1227# vbn w_36626_300# VSS nfet_03v3 ad=0.56p pd=2.56u as=0.56p ps=2.56u w=2u l=1u
X214 a_41364_6447# vbn a_41654_5867# VSS nfet_03v3 ad=0.56p pd=2.56u as=0.56p ps=2.56u w=2u l=1u
X215 a_41654_3547# vbn a_41364_2967# VSS nfet_03v3 ad=0.56p pd=2.56u as=0.56p ps=2.56u w=2u l=1u
X216 a_41654_2387# vbn a_41364_2967# VSS nfet_03v3 ad=0.56p pd=2.56u as=0.9p ps=4.9u w=2u l=1u
X217 a_36688_1807# vbn a_36978_1227# VSS nfet_03v3 ad=0.56p pd=2.56u as=0.56p ps=2.56u w=2u l=1u
X218 a_36978_4707# vbn a_36688_4127# VSS nfet_03v3 ad=0.56p pd=2.56u as=0.56p ps=2.56u w=2u l=1u
X219 a_36688_4127# vbn a_36978_3547# VSS nfet_03v3 ad=0.56p pd=2.56u as=0.56p ps=2.56u w=2u l=1u
X220 a_36688_2967# vbn a_36978_3547# VSS nfet_03v3 ad=0.56p pd=2.56u as=0.56p ps=2.56u w=2u l=1u
X221 a_41654_2387# vbn a_41364_1807# VSS nfet_03v3 ad=0.56p pd=2.56u as=0.56p ps=2.56u w=2u l=1u
X222 a_36978_5867# vbn a_36688_5287# VSS nfet_03v3 ad=0.56p pd=2.56u as=0.56p ps=2.56u w=2u l=1u
X223 w_36626_300# vbn a_36978_1227# VSS nfet_03v3 ad=0.9p pd=4.9u as=0.56p ps=2.56u w=2u l=1u
X224 a_36978_7027# vbn a_36688_7607# VSS nfet_03v3 ad=0.56p pd=2.56u as=0.56p ps=2.56u w=2u l=1u
X225 VSS vg VSS VSS nfet_03v3 ad=8.5988p pd=31.27u as=0 ps=0 w=30.71u l=4u
X226 vg a_6006_896# VSS VSS nfet_03v3 ad=0.336p pd=1.76u as=0.54p ps=3.3u w=1.2u l=5.335u
X227 VSS vbnf VSS VSS nfet_03v3 ad=13.7592p pd=49.7u as=0 ps=0 w=49.14u l=10u
X228 a_36978_7027# vbn a_36688_6447# VSS nfet_03v3 ad=0.56p pd=2.56u as=0.56p ps=2.56u w=2u l=1u
X229 a_36688_4127# vbn a_36978_3547# VSS nfet_03v3 ad=0.56p pd=2.56u as=0.56p ps=2.56u w=2u l=1u
X230 a_36688_7607# vbn a_36978_8187# VSS nfet_03v3 ad=0.56p pd=2.56u as=0.56p ps=2.56u w=2u l=1u
X231 a_36978_3547# vbn a_36688_4127# VSS nfet_03v3 ad=0.56p pd=2.56u as=0.56p ps=2.56u w=2u l=1u
X232 vg a_6006_896# VSS VSS nfet_03v3 ad=0.336p pd=1.76u as=0.54p ps=3.3u w=1.2u l=5.335u
X233 a_41654_7027# vbn a_41364_6447# VSS nfet_03v3 ad=0.56p pd=2.56u as=0.56p ps=2.56u w=2u l=1u
X234 a_41654_5867# vbn a_41364_6447# VSS nfet_03v3 ad=0.56p pd=2.56u as=0.9p ps=4.9u w=2u l=1u
X235 a_36978_4707# vbn a_36688_5287# VSS nfet_03v3 ad=0.56p pd=2.56u as=0.56p ps=2.56u w=2u l=1u
X236 a_36978_3547# vbn a_36688_4127# VSS nfet_03v3 ad=0.56p pd=2.56u as=0.9p ps=4.9u w=2u l=1u
X237 a_36688_2967# vbn a_36978_3547# VSS nfet_03v3 ad=0.56p pd=2.56u as=0.56p ps=2.56u w=2u l=1u
X238 a_36688_6447# vbn a_36978_7027# VSS nfet_03v3 ad=0.56p pd=2.56u as=0.56p ps=2.56u w=2u l=1u
X239 a_36978_8187# vbn a_36666_9481# VSS nfet_03v3 ad=0.56p pd=2.56u as=0.56p ps=2.56u w=2u l=1u
X240 a_36688_7607# vbn a_36978_8187# VSS nfet_03v3 ad=0.56p pd=2.56u as=0.56p ps=2.56u w=2u l=1u
X241 a_36688_5287# vbn a_36978_5867# VSS nfet_03v3 ad=0.56p pd=2.56u as=0.56p ps=2.56u w=2u l=1u
X242 a_36978_1227# vbn w_36626_300# VSS nfet_03v3 ad=0.56p pd=2.56u as=0.56p ps=2.56u w=2u l=1u
X243 a_36688_1807# vbn a_36978_2387# VSS nfet_03v3 ad=0.56p pd=2.56u as=0.56p ps=2.56u w=2u l=1u
X244 VSS VDD_LS VSS VSS nfet_03v3 ad=22.113p pd=99.18u as=0 ps=0 w=49.14u l=10u
X245 a_36688_5287# vbn a_36978_4707# VSS nfet_03v3 ad=0.9p pd=4.9u as=0.56p ps=2.56u w=2u l=1u
X246 a_36978_1227# vbn a_36688_1807# VSS nfet_03v3 ad=0.56p pd=2.56u as=0.56p ps=2.56u w=2u l=1u
X247 a_36978_1227# vbn a_36688_1807# VSS nfet_03v3 ad=0.56p pd=2.56u as=0.56p ps=2.56u w=2u l=1u
X248 a_36688_7607# vbn a_36978_8187# VSS nfet_03v3 ad=0.56p pd=2.56u as=0.56p ps=2.56u w=2u l=1u
X249 a_36688_2967# vbn a_36978_3547# VSS nfet_03v3 ad=0.56p pd=2.56u as=0.56p ps=2.56u w=2u l=1u
X250 VDD_LS q1 a_n7286_7514# VDD_LS pfet_03v3 ad=0.336p pd=1.76u as=1.2p ps=4.4u w=1.2u l=0.28u
X251 a_36978_3547# vbn a_36688_2967# VSS nfet_03v3 ad=0.56p pd=2.56u as=0.9p ps=4.9u w=2u l=1u
X252 a_36688_6447# vbn a_36978_7027# VSS nfet_03v3 ad=0.56p pd=2.56u as=0.56p ps=2.56u w=2u l=1u
X253 a_36688_4127# vbn a_36978_4707# VSS nfet_03v3 ad=0.56p pd=2.56u as=0.56p ps=2.56u w=2u l=1u
X254 a_36978_8187# vbn a_36688_7607# VSS nfet_03v3 ad=0.56p pd=2.56u as=0.56p ps=2.56u w=2u l=1u
X255 a_36978_8187# vbn a_36688_7607# VSS nfet_03v3 ad=0.56p pd=2.56u as=0.9p ps=4.9u w=2u l=1u
X256 a_36978_2387# vbn a_36688_1807# VSS nfet_03v3 ad=0.56p pd=2.56u as=0.56p ps=2.56u w=2u l=1u
X257 a_n4642_7514# ls a_n4810_7514# VDD_LS pfet_03v3 ad=2p pd=6u as=0.56p ps=2.56u w=2u l=0.28u
X258 a_n4642_7514# a_n5549_6703# VSS VSS nfet_03v3 ad=1p pd=4u as=0.28p ps=1.56u w=1u l=0.28u
X259 a_36688_1807# vbn a_36978_2387# VSS nfet_03v3 ad=0.56p pd=2.56u as=0.56p ps=2.56u w=2u l=1u
X260 a_36978_4707# vbn a_36688_5287# VSS nfet_03v3 ad=0.56p pd=2.56u as=0.56p ps=2.56u w=2u l=1u
X261 a_36688_1807# vbn a_36978_1227# VSS nfet_03v3 ad=0.56p pd=2.56u as=0.56p ps=2.56u w=2u l=1u
X262 a_41654_7027# vbn a_41364_7607# VSS nfet_03v3 ad=0.9p pd=4.9u as=0.56p ps=2.56u w=2u l=1u
X263 a_36978_5867# vbn a_36688_5287# VSS nfet_03v3 ad=0.56p pd=2.56u as=0.56p ps=2.56u w=2u l=1u
X264 a_36688_2967# vbn a_36978_2387# VSS nfet_03v3 ad=0.56p pd=2.56u as=0.56p ps=2.56u w=2u l=1u
X265 a_6006_896# bitb3 VSS VSS nfet_03v3 ad=0.45p pd=2.9u as=0.45p ps=2.9u w=1u l=0.28u
X266 a_36978_1227# vbn w_36626_300# VSS nfet_03v3 ad=0.56p pd=2.56u as=0.56p ps=2.56u w=2u l=1u
X267 a_36978_5867# vbn a_36688_5287# VSS nfet_03v3 ad=0.56p pd=2.56u as=0.56p ps=2.56u w=2u l=1u
X268 a_36688_4127# vbn a_36978_4707# VSS nfet_03v3 ad=0.56p pd=2.56u as=0.56p ps=2.56u w=2u l=1u
X269 a_36978_3547# vbn a_36688_4127# VSS nfet_03v3 ad=0.56p pd=2.56u as=0.56p ps=2.56u w=2u l=1u
X270 a_36978_3547# vbn a_36688_2967# VSS nfet_03v3 ad=0.56p pd=2.56u as=0.9p ps=4.9u w=2u l=1u
X271 a_36978_2387# vbn a_36688_1807# VSS nfet_03v3 ad=0.56p pd=2.56u as=0.56p ps=2.56u w=2u l=1u
X272 a_36688_6447# vbn a_36978_7027# VSS nfet_03v3 ad=0.56p pd=2.56u as=0.56p ps=2.56u w=2u l=1u
X273 VSS vbnf VSS VSS nfet_03v3 ad=13.7592p pd=49.7u as=0 ps=0 w=49.14u l=10u
X274 a_36978_7027# vbn a_36688_6447# VSS nfet_03v3 ad=0.56p pd=2.56u as=0.9p ps=4.9u w=2u l=1u
X275 vg a_996_6587# a0 VSS nfet_03v3 ad=0.9p pd=4.9u as=0.9p ps=4.9u w=2u l=0.28u
X276 a_36666_9481# vbn a_36978_8187# VSS nfet_03v3 ad=0.56p pd=2.56u as=0.56p ps=2.56u w=2u l=1u
X277 a_41364_2967# vbn a_41654_2387# VSS nfet_03v3 ad=0.56p pd=2.56u as=0.56p ps=2.56u w=2u l=1u
X278 a_36978_3547# vbn a_36688_2967# VSS nfet_03v3 ad=0.56p pd=2.56u as=0.56p ps=2.56u w=2u l=1u
X279 a_36978_1227# vbn a_36688_1807# VSS nfet_03v3 ad=0.56p pd=2.56u as=0.56p ps=2.56u w=2u l=1u
X280 a_41364_7607# vbn a_41654_7027# VSS nfet_03v3 ad=0.56p pd=2.56u as=0.56p ps=2.56u w=2u l=1u
X281 a_36688_6447# vbn a_36978_5867# VSS nfet_03v3 ad=0.56p pd=2.56u as=0.56p ps=2.56u w=2u l=1u
X282 a_36688_5287# vbn a_36978_5867# VSS nfet_03v3 ad=0.56p pd=2.56u as=0.56p ps=2.56u w=2u l=1u
X283 VSS a_6006_896# vg VSS nfet_03v3 ad=0.336p pd=1.76u as=0.336p ps=1.76u w=1.2u l=5.335u
X284 a_36978_3547# vbn a_36688_2967# VSS nfet_03v3 ad=0.56p pd=2.56u as=0.56p ps=2.56u w=2u l=1u
X285 a_36978_7027# vbn a_36688_6447# VSS nfet_03v3 ad=0.56p pd=2.56u as=0.9p ps=4.9u w=2u l=1u
X286 a_36688_1807# vbn a_36978_2387# VSS nfet_03v3 ad=0.56p pd=2.56u as=0.56p ps=2.56u w=2u l=1u
X287 a_36978_4707# vbn a_36688_5287# VSS nfet_03v3 ad=0.56p pd=2.56u as=0.56p ps=2.56u w=2u l=1u
X288 a_36978_8187# vbn a_36688_7607# VSS nfet_03v3 ad=0.56p pd=2.56u as=0.56p ps=2.56u w=2u l=1u
X289 a_36666_9481# vbn a_36978_8187# VSS nfet_03v3 ad=0.56p pd=2.56u as=0.56p ps=2.56u w=2u l=1u
X290 a_41364_6447# vbn a_41654_5867# VSS nfet_03v3 ad=0.56p pd=2.56u as=0.56p ps=2.56u w=2u l=1u
X291 a_36978_4707# vbn a_36688_4127# VSS nfet_03v3 ad=0.56p pd=2.56u as=0.56p ps=2.56u w=2u l=1u
X292 a_36978_7027# vbn a_36688_6447# VSS nfet_03v3 ad=0.56p pd=2.56u as=0.56p ps=2.56u w=2u l=1u
X293 a_36978_5867# vbn a_36688_5287# VSS nfet_03v3 ad=0.56p pd=2.56u as=0.56p ps=2.56u w=2u l=1u
X294 w_36626_300# vbn a_36978_1227# VSS nfet_03v3 ad=0.56p pd=2.56u as=0.56p ps=2.56u w=2u l=1u
X295 a_36978_7027# vbn a_36688_6447# VSS nfet_03v3 ad=0.56p pd=2.56u as=0.56p ps=2.56u w=2u l=1u
X296 a_36978_3547# vbn a_36688_2967# VSS nfet_03v3 ad=0.56p pd=2.56u as=0.56p ps=2.56u w=2u l=1u
X297 a_41654_3547# vbn a_41364_4127# VSS nfet_03v3 ad=0.9p pd=4.9u as=0.56p ps=2.56u w=2u l=1u
X298 a_41654_3547# vbn a_41364_2967# VSS nfet_03v3 ad=0.56p pd=2.56u as=0.56p ps=2.56u w=2u l=1u
X299 VSS VDD_LS VSS VSS nfet_03v3 ad=13.7592p pd=49.7u as=0 ps=0 w=49.14u l=10u
X300 VSS q1 a_n6436_6531# VSS nfet_03v3 ad=0.168p pd=1.16u as=0.168p ps=1.16u w=0.6u l=0.28u
X301 vbnf bit2 a_6006_4704# VSS nfet_03v3 ad=0.9p pd=4.9u as=0.9p ps=4.9u w=2u l=0.28u
X302 VSS vg VSS VSS nfet_03v3 ad=8.5988p pd=31.27u as=0 ps=0 w=30.71u l=4u
X303 a_36978_7027# vbn a_36688_7607# VSS nfet_03v3 ad=0.56p pd=2.56u as=0.56p ps=2.56u w=2u l=1u
X304 a_41364_7607# vbn a_41654_7027# VSS nfet_03v3 ad=0.56p pd=2.56u as=0.56p ps=2.56u w=2u l=1u
X305 a_36978_2387# vbn a_36688_1807# VSS nfet_03v3 ad=0.56p pd=2.56u as=0.56p ps=2.56u w=2u l=1u
X306 a_36688_2967# vbn a_36978_3547# VSS nfet_03v3 ad=0.56p pd=2.56u as=0.56p ps=2.56u w=2u l=1u
X307 a_36688_2967# vbn a_36978_2387# VSS nfet_03v3 ad=0.56p pd=2.56u as=0.56p ps=2.56u w=2u l=1u
X308 a_36688_4127# vbn a_36978_4707# VSS nfet_03v3 ad=0.56p pd=2.56u as=0.56p ps=2.56u w=2u l=1u
X309 a_36978_2387# vbn a_36688_1807# VSS nfet_03v3 ad=0.56p pd=2.56u as=0.56p ps=2.56u w=2u l=1u
X310 w_36626_300# vbn a_36978_1227# VSS nfet_03v3 ad=0.56p pd=2.56u as=0.56p ps=2.56u w=2u l=1u
X311 a_36978_8187# vbn a_36666_9481# VSS nfet_03v3 ad=0.56p pd=2.56u as=0.56p ps=2.56u w=2u l=1u
X312 a_36688_5287# vbn a_36978_4707# VSS nfet_03v3 ad=0.56p pd=2.56u as=0.56p ps=2.56u w=2u l=1u
X313 a_36688_1807# vbn a_36978_1227# VSS nfet_03v3 ad=0.56p pd=2.56u as=0.56p ps=2.56u w=2u l=1u
X314 a_36978_7027# vbn a_36688_6447# VSS nfet_03v3 ad=0.56p pd=2.56u as=0.56p ps=2.56u w=2u l=1u
X315 a_36688_4127# vbn a_36978_4707# VSS nfet_03v3 ad=0.56p pd=2.56u as=0.56p ps=2.56u w=2u l=1u
X316 a_41654_7027# vbn a_41364_6447# VSS nfet_03v3 ad=0.56p pd=2.56u as=0.56p ps=2.56u w=2u l=1u
X317 a_41364_4127# vbn a_41654_3547# VSS nfet_03v3 ad=0.56p pd=2.56u as=0.56p ps=2.56u w=2u l=1u
X318 VSS a_6006_896# vg VSS nfet_03v3 ad=0.336p pd=1.76u as=0.336p ps=1.76u w=1.2u l=5.335u
X319 a_36688_2967# vbn a_36978_3547# VSS nfet_03v3 ad=0.56p pd=2.56u as=0.56p ps=2.56u w=2u l=1u
X320 a_41654_7027# vbn a_41364_7607# VSS nfet_03v3 ad=0.56p pd=2.56u as=0.9p ps=4.9u w=2u l=1u
X321 a_36688_1807# vbn a_36978_2387# VSS nfet_03v3 ad=0.56p pd=2.56u as=0.56p ps=2.56u w=2u l=1u
X322 a_41654_8187# vbn a_41364_7607# VSS nfet_03v3 ad=0.9p pd=4.9u as=0.56p ps=2.56u w=2u l=1u
X323 a_36688_6447# vbn a_36978_7027# VSS nfet_03v3 ad=0.56p pd=2.56u as=0.56p ps=2.56u w=2u l=1u
X324 a_36688_6447# vbn a_36978_5867# VSS nfet_03v3 ad=0.56p pd=2.56u as=0.56p ps=2.56u w=2u l=1u
X325 a_36688_4127# vbn a_36978_4707# VSS nfet_03v3 ad=0.56p pd=2.56u as=0.56p ps=2.56u w=2u l=1u
X326 a_36666_9481# vbn a_36978_8187# VSS nfet_03v3 ad=0.56p pd=2.56u as=0.56p ps=2.56u w=2u l=1u
X327 VSS a_6006_14# vg VSS nfet_03v3 ad=0.336p pd=1.76u as=0.336p ps=1.76u w=1.2u l=5.335u
X328 a_36688_5287# vbn a_36978_4707# VSS nfet_03v3 ad=0.56p pd=2.56u as=0.56p ps=2.56u w=2u l=1u
X329 a_41654_7027# vbn a_41364_7607# VSS nfet_03v3 ad=0.56p pd=2.56u as=0.56p ps=2.56u w=2u l=1u
X330 a_36978_1227# vbn a_36688_1807# VSS nfet_03v3 ad=0.56p pd=2.56u as=0.56p ps=2.56u w=2u l=1u
X331 VSS a_6006_4704# vg VSS nfet_03v3 ad=0.336p pd=1.76u as=0.336p ps=1.76u w=1.2u l=5.335u
X332 VDD a_36666_9481# vbn VDD pfet_03v3 ad=6.3p pd=28.9u as=3.92p ps=14.56u w=14u l=14u
X333 a_36688_5287# vbn a_36978_5867# VSS nfet_03v3 ad=0.56p pd=2.56u as=0.56p ps=2.56u w=2u l=1u
X334 a_36978_1227# vbn w_36626_300# VSS nfet_03v3 ad=0.56p pd=2.56u as=0.56p ps=2.56u w=2u l=1u
X335 VDD a_36666_9481# vbn VDD pfet_03v3 ad=3.92p pd=14.56u as=3.92p ps=14.56u w=14u l=14u
X336 a_41364_7607# vbn a_41654_8187# VSS nfet_03v3 ad=0.56p pd=2.56u as=0.56p ps=2.56u w=2u l=1u
X337 a_36978_2387# vbn a_36688_1807# VSS nfet_03v3 ad=0.56p pd=2.56u as=0.56p ps=2.56u w=2u l=1u
X338 a_36666_9481# vbn a_36978_8187# VSS nfet_03v3 ad=0.56p pd=2.56u as=0.56p ps=2.56u w=2u l=1u
X339 a_36688_6447# vbn a_36978_7027# VSS nfet_03v3 ad=0.56p pd=2.56u as=0.56p ps=2.56u w=2u l=1u
X340 a_36978_2387# vbn a_36688_2967# VSS nfet_03v3 ad=0.56p pd=2.56u as=0.56p ps=2.56u w=2u l=1u
X341 a_36688_4127# vbn a_36978_4707# VSS nfet_03v3 ad=0.9p pd=4.9u as=0.56p ps=2.56u w=2u l=1u
X342 a_36666_9481# vbn a_36978_8187# VSS nfet_03v3 ad=0.56p pd=2.56u as=0.56p ps=2.56u w=2u l=1u
X343 a_36978_3547# vbn a_36688_4127# VSS nfet_03v3 ad=0.56p pd=2.56u as=0.56p ps=2.56u w=2u l=1u
X344 a_36978_1227# vbn a_36688_1807# VSS nfet_03v3 ad=0.56p pd=2.56u as=0.56p ps=2.56u w=2u l=1u
X345 a_36978_5867# vbn a_36688_5287# VSS nfet_03v3 ad=0.56p pd=2.56u as=0.56p ps=2.56u w=2u l=1u
X346 a_36978_4707# vbn a_36688_4127# VSS nfet_03v3 ad=0.56p pd=2.56u as=0.56p ps=2.56u w=2u l=1u
X347 w_36626_300# vbn a_36978_1227# VSS nfet_03v3 ad=0.56p pd=2.56u as=0.56p ps=2.56u w=2u l=1u
X348 a_41364_4127# vbn a_41654_3547# VSS nfet_03v3 ad=0.56p pd=2.56u as=0.56p ps=2.56u w=2u l=1u
X349 a_36978_4707# vbn a_36688_5287# VSS nfet_03v3 ad=0.56p pd=2.56u as=0.56p ps=2.56u w=2u l=1u
X350 a_36978_5867# vbn a_36688_6447# VSS nfet_03v3 ad=0.56p pd=2.56u as=0.56p ps=2.56u w=2u l=1u
X351 a_36688_2967# vbn a_36978_2387# VSS nfet_03v3 ad=0.56p pd=2.56u as=0.56p ps=2.56u w=2u l=1u
X352 a_n3607_6703# a_n3101_6703# VDD_LS VDD_LS pfet_03v3 ad=1.5p pd=5u as=0.675p ps=3.9u w=1.5u l=0.28u
X353 w_36626_300# vbn a_36978_1227# VSS nfet_03v3 ad=0.56p pd=2.56u as=0.56p ps=2.56u w=2u l=1u
X354 vbn a_60350_8387# a_36666_9481# VSS nfet_03v3 ad=0.45p pd=2.9u as=0.45p ps=2.9u w=1u l=0.28u
X355 a_36666_9481# vbn a_36978_8187# VSS nfet_03v3 ad=0.9p pd=4.9u as=0.56p ps=2.56u w=2u l=1u
X356 a_36978_2387# vbn a_36688_2967# VSS nfet_03v3 ad=0.56p pd=2.56u as=0.56p ps=2.56u w=2u l=1u
X357 a_41654_3547# vbn a_41364_4127# VSS nfet_03v3 ad=0.56p pd=2.56u as=0.9p ps=4.9u w=2u l=1u
X358 a_36978_5867# vbn a_36688_5287# VSS nfet_03v3 ad=0.56p pd=2.56u as=0.56p ps=2.56u w=2u l=1u
X359 w_36626_300# vbn a_36978_1227# VSS nfet_03v3 ad=0.56p pd=2.56u as=0.56p ps=2.56u w=2u l=1u
X360 vg a_6006_14# VSS VSS nfet_03v3 ad=0.336p pd=1.76u as=0.54p ps=3.3u w=1.2u l=5.335u
X361 a_36978_8187# vbn a_36688_7607# VSS nfet_03v3 ad=0.56p pd=2.56u as=0.56p ps=2.56u w=2u l=1u
X362 a_36978_8187# vbn a_36666_9481# VSS nfet_03v3 ad=0.56p pd=2.56u as=0.56p ps=2.56u w=2u l=1u
X363 a_41364_7607# vbn a_41654_8187# VSS nfet_03v3 ad=0.56p pd=2.56u as=0.56p ps=2.56u w=2u l=1u
X364 a_36688_5287# vbn a_36978_4707# VSS nfet_03v3 ad=0.56p pd=2.56u as=0.56p ps=2.56u w=2u l=1u
X365 a_36978_4707# vbn a_36688_4127# VSS nfet_03v3 ad=0.56p pd=2.56u as=0.56p ps=2.56u w=2u l=1u
X366 a_36688_1807# vbn a_36978_1227# VSS nfet_03v3 ad=0.56p pd=2.56u as=0.56p ps=2.56u w=2u l=1u
X367 a_36688_6447# vbn a_36978_5867# VSS nfet_03v3 ad=0.56p pd=2.56u as=0.56p ps=2.56u w=2u l=1u
X368 a_36978_3547# vbn a_36688_2967# VSS nfet_03v3 ad=0.56p pd=2.56u as=0.56p ps=2.56u w=2u l=1u
X369 a_41654_1227# vbn a_41364_1807# VSS nfet_03v3 ad=0.9p pd=4.9u as=0.56p ps=2.56u w=2u l=1u
X370 a_41654_3547# vbn a_41364_4127# VSS nfet_03v3 ad=0.56p pd=2.56u as=0.56p ps=2.56u w=2u l=1u
X371 a_36688_1807# vbn a_36978_2387# VSS nfet_03v3 ad=0.56p pd=2.56u as=0.56p ps=2.56u w=2u l=1u
X372 a_36688_2967# vbn a_36978_3547# VSS nfet_03v3 ad=0.56p pd=2.56u as=0.56p ps=2.56u w=2u l=1u
X373 a_36688_2967# vbn a_36978_2387# VSS nfet_03v3 ad=0.56p pd=2.56u as=0.56p ps=2.56u w=2u l=1u
X374 a_36688_5287# vbn a_36978_4707# VSS nfet_03v3 ad=0.56p pd=2.56u as=0.56p ps=2.56u w=2u l=1u
X375 a_36978_5867# vbn a_36688_6447# VSS nfet_03v3 ad=0.56p pd=2.56u as=0.56p ps=2.56u w=2u l=1u
X376 VSS vg VSS VSS nfet_03v3 ad=8.5988p pd=31.27u as=0 ps=0 w=30.71u l=4u
X377 w_36626_300# vbn a_36978_1227# VSS nfet_03v3 ad=0.9p pd=4.9u as=0.56p ps=2.56u w=2u l=1u
X378 a_41654_8187# vbn a_41364_7607# VSS nfet_03v3 ad=0.56p pd=2.56u as=0.9p ps=4.9u w=2u l=1u
X379 vg a_6006_14# VSS VSS nfet_03v3 ad=0.336p pd=1.76u as=0.336p ps=1.76u w=1.2u l=5.335u
X380 a_36688_5287# vbn a_36978_4707# VSS nfet_03v3 ad=0.56p pd=2.56u as=0.56p ps=2.56u w=2u l=1u
X381 vg a_6006_4704# VSS VSS nfet_03v3 ad=0.336p pd=1.76u as=0.54p ps=3.3u w=1.2u l=5.335u
X382 a_36688_7607# vbn a_36978_7027# VSS nfet_03v3 ad=0.9p pd=4.9u as=0.56p ps=2.56u w=2u l=1u
X383 a_36978_7027# vbn a_36688_6447# VSS nfet_03v3 ad=0.56p pd=2.56u as=0.56p ps=2.56u w=2u l=1u
X384 a_n7601_6703# a_n7286_7514# VDD_LS VDD_LS pfet_03v3 ad=1.2p pd=4.4u as=0.54p ps=3.3u w=1.2u l=0.28u
X385 a_36688_5287# vbn a_36978_5867# VSS nfet_03v3 ad=0.56p pd=2.56u as=0.56p ps=2.56u w=2u l=1u
X386 a_36978_1227# vbn w_36626_300# VSS nfet_03v3 ad=0.56p pd=2.56u as=0.56p ps=2.56u w=2u l=1u
X387 a_36978_8187# vbn a_36666_9481# VSS nfet_03v3 ad=0.56p pd=2.56u as=0.56p ps=2.56u w=2u l=1u
X388 a_41654_5867# vbn a_41364_5287# VSS nfet_03v3 ad=0.9p pd=4.9u as=0.56p ps=2.56u w=2u l=1u
X389 a_41654_8187# vbn a_41364_7607# VSS nfet_03v3 ad=0.56p pd=2.56u as=0.56p ps=2.56u w=2u l=1u
X390 a_36978_2387# vbn a_36688_1807# VSS nfet_03v3 ad=0.56p pd=2.56u as=0.56p ps=2.56u w=2u l=1u
X391 a_36688_6447# vbn a_36978_5867# VSS nfet_03v3 ad=0.56p pd=2.56u as=0.56p ps=2.56u w=2u l=1u
X392 a_36688_6447# vbn a_36978_7027# VSS nfet_03v3 ad=0.56p pd=2.56u as=0.56p ps=2.56u w=2u l=1u
X393 a_n6694_7514# a_n7601_6703# VSS VSS nfet_03v3 ad=0.6p pd=3.2u as=0.168p ps=1.16u w=0.6u l=0.28u
X394 a_41364_1807# vbn a_41654_1227# VSS nfet_03v3 ad=0.56p pd=2.56u as=0.56p ps=2.56u w=2u l=1u
X395 a_41654_4707# vbn a_41364_4127# VSS nfet_03v3 ad=0.56p pd=2.56u as=0.56p ps=2.56u w=2u l=1u
X396 a_36688_2967# vbn a_36978_3547# VSS nfet_03v3 ad=0.56p pd=2.56u as=0.56p ps=2.56u w=2u l=1u
X397 a_36688_5287# vbn a_36978_4707# VSS nfet_03v3 ad=0.9p pd=4.9u as=0.56p ps=2.56u w=2u l=1u
X398 a_1632_6633# a_452_6633# vg VSS nfet_03v3 ad=0.9p pd=4.9u as=0.9p ps=4.9u w=2u l=0.28u
X399 a_36978_2387# vbn a_36688_1807# VSS nfet_03v3 ad=0.56p pd=2.56u as=0.56p ps=2.56u w=2u l=1u
X400 a_41364_1807# vbn a_41654_1227# VSS nfet_03v3 ad=0.56p pd=2.56u as=0.56p ps=2.56u w=2u l=1u
X401 a_36978_4707# vbn a_36688_5287# VSS nfet_03v3 ad=0.56p pd=2.56u as=0.56p ps=2.56u w=2u l=1u
X402 a_36978_7027# vbn a_36688_7607# VSS nfet_03v3 ad=0.56p pd=2.56u as=0.56p ps=2.56u w=2u l=1u
X403 a_36978_1227# vbn w_36626_300# VSS nfet_03v3 ad=0.56p pd=2.56u as=0.56p ps=2.56u w=2u l=1u
X404 a_36688_6447# vbn a_36978_7027# VSS nfet_03v3 ad=0.56p pd=2.56u as=0.56p ps=2.56u w=2u l=1u
X405 a_36688_4127# vbn a_36978_4707# VSS nfet_03v3 ad=0.56p pd=2.56u as=0.56p ps=2.56u w=2u l=1u
X406 a_36978_3547# vbn a_36688_2967# VSS nfet_03v3 ad=0.56p pd=2.56u as=0.56p ps=2.56u w=2u l=1u
X407 a_36978_2387# vbn a_36688_2967# VSS nfet_03v3 ad=0.56p pd=2.56u as=0.56p ps=2.56u w=2u l=1u
X408 a_41364_5287# vbn a_41654_5867# VSS nfet_03v3 ad=0.56p pd=2.56u as=0.56p ps=2.56u w=2u l=1u
X409 a_41654_8187# vbn vbn VSS nfet_03v3 ad=0.56p pd=2.56u as=0.56p ps=2.56u w=2u l=1u
X410 a_36688_7607# vbn a_36978_7027# VSS nfet_03v3 ad=0.9p pd=4.9u as=0.56p ps=2.56u w=2u l=1u
X411 a_41364_1807# vbn a_41654_1227# VSS nfet_03v3 ad=0.56p pd=2.56u as=0.56p ps=2.56u w=2u l=1u
X412 a_36688_4127# vbn a_36978_3547# VSS nfet_03v3 ad=0.9p pd=4.9u as=0.56p ps=2.56u w=2u l=1u
X413 vg vbnf VSS VSS nfet_03v3 ad=0.336p pd=1.76u as=0.336p ps=1.76u w=1.2u l=5.335u
X414 vg a_6006_14# VSS VSS nfet_03v3 ad=0.336p pd=1.76u as=0.54p ps=3.3u w=1.2u l=5.335u
X415 VSS vbnf VSS VSS nfet_03v3 ad=13.7592p pd=49.7u as=0 ps=0 w=49.14u l=10u
X416 a_41364_5287# vbn a_41654_5867# VSS nfet_03v3 ad=0.56p pd=2.56u as=0.56p ps=2.56u w=2u l=1u
X417 a_36688_2967# vbn a_36978_3547# VSS nfet_03v3 ad=0.56p pd=2.56u as=0.56p ps=2.56u w=2u l=1u
X418 a_36978_4707# vbn a_36688_5287# VSS nfet_03v3 ad=0.56p pd=2.56u as=0.56p ps=2.56u w=2u l=1u
X419 a_36978_2387# vbn a_36688_2967# VSS nfet_03v3 ad=0.56p pd=2.56u as=0.56p ps=2.56u w=2u l=1u
X420 a_36688_1807# vbn a_36978_2387# VSS nfet_03v3 ad=0.56p pd=2.56u as=0.56p ps=2.56u w=2u l=1u
X421 a_36978_7027# vbn a_36688_6447# VSS nfet_03v3 ad=0.56p pd=2.56u as=0.56p ps=2.56u w=2u l=1u
X422 a_36978_5867# vbn a_36688_6447# VSS nfet_03v3 ad=0.56p pd=2.56u as=0.56p ps=2.56u w=2u l=1u
X423 a_36978_4707# vbn a_36688_4127# VSS nfet_03v3 ad=0.56p pd=2.56u as=0.56p ps=2.56u w=2u l=1u
X424 a_41654_2387# vbn a_41364_1807# VSS nfet_03v3 ad=0.9p pd=4.9u as=0.56p ps=2.56u w=2u l=1u
X425 a_36688_4127# vbn a_36978_4707# VSS nfet_03v3 ad=0.56p pd=2.56u as=0.56p ps=2.56u w=2u l=1u
X426 a_41654_1227# vbn a_41364_1807# VSS nfet_03v3 ad=0.56p pd=2.56u as=0.9p ps=4.9u w=2u l=1u
X427 a_36666_9481# vbn a_36978_8187# VSS nfet_03v3 ad=0.56p pd=2.56u as=0.56p ps=2.56u w=2u l=1u
X428 a_36978_7027# vbn a_36688_7607# VSS nfet_03v3 ad=0.56p pd=2.56u as=0.56p ps=2.56u w=2u l=1u
X429 VSS a_n7872_8894# VSS VSS nfet_03v3 ad=7.2p pd=32.9u as=0 ps=0 w=16u l=16u
X430 vg vbnf VSS VSS nfet_03v3 ad=0.336p pd=1.76u as=0.336p ps=1.76u w=1.2u l=5.335u
X431 a_41364_5287# vbn a_41654_5867# VSS nfet_03v3 ad=0.56p pd=2.56u as=0.56p ps=2.56u w=2u l=1u
X432 a_41654_2387# vbn a_41364_2967# VSS nfet_03v3 ad=0.56p pd=2.56u as=0.56p ps=2.56u w=2u l=1u
X433 a_41654_1227# vbn VSS VSS nfet_03v3 ad=0.56p pd=2.56u as=0.56p ps=2.56u w=2u l=1u
X434 a_36978_4707# vbn a_36688_4127# VSS nfet_03v3 ad=0.56p pd=2.56u as=0.56p ps=2.56u w=2u l=1u
X435 a_36688_2967# vbn a_36978_3547# VSS nfet_03v3 ad=0.56p pd=2.56u as=0.56p ps=2.56u w=2u l=1u
X436 a_36688_2967# vbn a_36978_2387# VSS nfet_03v3 ad=0.56p pd=2.56u as=0.56p ps=2.56u w=2u l=1u
X437 a_36978_5867# vbn a_36688_6447# VSS nfet_03v3 ad=0.56p pd=2.56u as=0.56p ps=2.56u w=2u l=1u
X438 a_36688_2967# vbn a_36978_3547# VSS nfet_03v3 ad=0.56p pd=2.56u as=0.56p ps=2.56u w=2u l=1u
X439 a_36688_7607# vbn a_36978_8187# VSS nfet_03v3 ad=0.9p pd=4.9u as=0.56p ps=2.56u w=2u l=1u
X440 a_36688_6447# vbn a_36978_7027# VSS nfet_03v3 ad=0.56p pd=2.56u as=0.56p ps=2.56u w=2u l=1u
X441 a_36978_8187# vbn a_36666_9481# VSS nfet_03v3 ad=0.56p pd=2.56u as=0.56p ps=2.56u w=2u l=1u
X442 a_36666_9481# vbn a_36978_8187# VSS nfet_03v3 ad=0.56p pd=2.56u as=0.56p ps=2.56u w=2u l=1u
X443 a_36978_3547# vbn a_36688_4127# VSS nfet_03v3 ad=0.56p pd=2.56u as=0.56p ps=2.56u w=2u l=1u
X444 a_36978_3547# vbn a_36688_2967# VSS nfet_03v3 ad=0.56p pd=2.56u as=0.56p ps=2.56u w=2u l=1u
X445 a_41654_5867# vbn a_41364_6447# VSS nfet_03v3 ad=0.56p pd=2.56u as=0.56p ps=2.56u w=2u l=1u
X446 a_41654_5867# vbn a_41364_5287# VSS nfet_03v3 ad=0.56p pd=2.56u as=0.9p ps=4.9u w=2u l=1u
X447 a_36978_3547# vbn a_36688_2967# VSS nfet_03v3 ad=0.56p pd=2.56u as=0.9p ps=4.9u w=2u l=1u
X448 VSS vg VSS VSS nfet_03v3 ad=8.5988p pd=31.27u as=0 ps=0 w=30.71u l=4u
X449 a_36688_2967# vbn a_36978_2387# VSS nfet_03v3 ad=0.56p pd=2.56u as=0.56p ps=2.56u w=2u l=1u
X450 a_36978_7027# vbn a_36688_7607# VSS nfet_03v3 ad=0.56p pd=2.56u as=0.56p ps=2.56u w=2u l=1u
X451 a_36688_6447# vbn a_36978_7027# VSS nfet_03v3 ad=0.56p pd=2.56u as=0.56p ps=2.56u w=2u l=1u
X452 a_36688_6447# vbn a_36978_5867# VSS nfet_03v3 ad=0.56p pd=2.56u as=0.56p ps=2.56u w=2u l=1u
X453 a_36688_4127# vbn a_36978_4707# VSS nfet_03v3 ad=0.56p pd=2.56u as=0.56p ps=2.56u w=2u l=1u
X454 a_41364_1807# vbn a_41654_2387# VSS nfet_03v3 ad=0.56p pd=2.56u as=0.56p ps=2.56u w=2u l=1u
X455 w_36626_300# vbn a_36978_1227# VSS nfet_03v3 ad=0.56p pd=2.56u as=0.56p ps=2.56u w=2u l=1u
X456 a_36978_8187# vbn a_36666_9481# VSS nfet_03v3 ad=0.56p pd=2.56u as=0.56p ps=2.56u w=2u l=1u
X457 a_36688_4127# vbn a_36978_3547# VSS nfet_03v3 ad=0.9p pd=4.9u as=0.56p ps=2.56u w=2u l=1u
X458 a_41654_4707# vbn a_41364_5287# VSS nfet_03v3 ad=0.56p pd=2.56u as=0.56p ps=2.56u w=2u l=1u
X459 VSS a_6896_6633# vg VSS nfet_03v3 ad=0.336p pd=1.76u as=0.336p ps=1.76u w=1.2u l=5.335u
X460 VSS ls a_n4384_6451# VSS nfet_03v3 ad=0.28p pd=1.56u as=0.28p ps=1.56u w=1u l=0.28u
X461 VSS vbnf VSS VSS nfet_03v3 ad=13.7592p pd=49.7u as=0 ps=0 w=49.14u l=10u
X462 a_36688_6447# vbn a_36978_7027# VSS nfet_03v3 ad=0.56p pd=2.56u as=0.56p ps=2.56u w=2u l=1u
X463 a_36978_7027# vbn a_36688_6447# VSS nfet_03v3 ad=0.56p pd=2.56u as=0.56p ps=2.56u w=2u l=1u
X464 a_36688_2967# vbn a_36978_2387# VSS nfet_03v3 ad=0.56p pd=2.56u as=0.56p ps=2.56u w=2u l=1u
X465 a_41364_1807# vbn a_41654_2387# VSS nfet_03v3 ad=0.56p pd=2.56u as=0.56p ps=2.56u w=2u l=1u
X466 a_36688_6447# vbn a_36978_5867# VSS nfet_03v3 ad=0.56p pd=2.56u as=0.56p ps=2.56u w=2u l=1u
X467 a_36978_2387# vbn a_36688_2967# VSS nfet_03v3 ad=0.56p pd=2.56u as=0.9p ps=4.9u w=2u l=1u
X468 a_36978_8187# vbn a_36688_7607# VSS nfet_03v3 ad=0.56p pd=2.56u as=0.56p ps=2.56u w=2u l=1u
X469 a_36978_7027# vbn a_36688_6447# VSS nfet_03v3 ad=0.56p pd=2.56u as=0.9p ps=4.9u w=2u l=1u
X470 a_36978_1227# vbn w_36626_300# VSS nfet_03v3 ad=0.56p pd=2.56u as=0.56p ps=2.56u w=2u l=1u
X471 VDD_LS ls a_n5234_7514# VDD_LS pfet_03v3 ad=0.56p pd=2.56u as=2p ps=6u w=2u l=0.28u
X472 w_36626_300# vbn a_36978_1227# VSS nfet_03v3 ad=0.56p pd=2.56u as=0.56p ps=2.56u w=2u l=1u
X473 a_36666_9481# vbn a_36978_8187# VSS nfet_03v3 ad=0.56p pd=2.56u as=0.56p ps=2.56u w=2u l=1u
X474 a_36978_3547# vbn a_36688_4127# VSS nfet_03v3 ad=0.56p pd=2.56u as=0.56p ps=2.56u w=2u l=1u
X475 a_36688_5287# vbn a_36978_4707# VSS nfet_03v3 ad=0.56p pd=2.56u as=0.56p ps=2.56u w=2u l=1u
X476 a_36978_4707# vbn a_36688_4127# VSS nfet_03v3 ad=0.56p pd=2.56u as=0.56p ps=2.56u w=2u l=1u
X477 a_36688_1807# vbn a_36978_1227# VSS nfet_03v3 ad=0.56p pd=2.56u as=0.56p ps=2.56u w=2u l=1u
X478 a_41364_1807# vbn a_41654_2387# VSS nfet_03v3 ad=0.56p pd=2.56u as=0.56p ps=2.56u w=2u l=1u
X479 a_36978_4707# vbn a_36688_4127# VSS nfet_03v3 ad=0.56p pd=2.56u as=0.56p ps=2.56u w=2u l=1u
X480 a_36688_7607# vbn a_36978_8187# VSS nfet_03v3 ad=0.9p pd=4.9u as=0.56p ps=2.56u w=2u l=1u
X481 VSS a_6006_14# vg VSS nfet_03v3 ad=0.336p pd=1.76u as=0.336p ps=1.76u w=1.2u l=5.335u
X482 a_36978_1227# vbn w_36626_300# VSS nfet_03v3 ad=0.56p pd=2.56u as=0.56p ps=2.56u w=2u l=1u
X483 a_36978_3547# vbn a_36688_2967# VSS nfet_03v3 ad=0.56p pd=2.56u as=0.56p ps=2.56u w=2u l=1u
X484 a_36978_2387# vbn a_36688_2967# VSS nfet_03v3 ad=0.56p pd=2.56u as=0.9p ps=4.9u w=2u l=1u
X485 a_36688_6447# vbn a_36978_5867# VSS nfet_03v3 ad=0.56p pd=2.56u as=0.56p ps=2.56u w=2u l=1u
X486 a_36688_7607# vbn a_36978_7027# VSS nfet_03v3 ad=0.56p pd=2.56u as=0.56p ps=2.56u w=2u l=1u
X487 a_36978_5867# vbn a_36688_6447# VSS nfet_03v3 ad=0.56p pd=2.56u as=0.9p ps=4.9u w=2u l=1u
X488 a_41364_1807# vbn a_41654_1227# VSS nfet_03v3 ad=0.56p pd=2.56u as=0.56p ps=2.56u w=2u l=1u
X489 a_36978_4707# vbn a_36688_5287# VSS nfet_03v3 ad=0.56p pd=2.56u as=0.56p ps=2.56u w=2u l=1u
X490 a_36688_4127# vbn a_36978_4707# VSS nfet_03v3 ad=0.56p pd=2.56u as=0.56p ps=2.56u w=2u l=1u
X491 a_36978_2387# vbn a_36688_2967# VSS nfet_03v3 ad=0.56p pd=2.56u as=0.56p ps=2.56u w=2u l=1u
X492 a_36978_8187# vbn a_36688_7607# VSS nfet_03v3 ad=0.56p pd=2.56u as=0.56p ps=2.56u w=2u l=1u
X493 a_36688_5287# vbn a_36978_4707# VSS nfet_03v3 ad=0.56p pd=2.56u as=0.56p ps=2.56u w=2u l=1u
X494 a_41654_2387# vbn a_41364_1807# VSS nfet_03v3 ad=0.56p pd=2.56u as=0.9p ps=4.9u w=2u l=1u
X495 a_36688_5287# vbn a_36978_5867# VSS nfet_03v3 ad=0.56p pd=2.56u as=0.56p ps=2.56u w=2u l=1u
X496 VSS vctrl vg VSS nfet_03v3 ad=0.54p pd=3.3u as=0.336p ps=1.76u w=1.2u l=21.335u
X497 a_36978_8187# vbn a_36666_9481# VSS nfet_03v3 ad=0.56p pd=2.56u as=0.56p ps=2.56u w=2u l=1u
X498 a_36978_3547# vbn a_36688_4127# VSS nfet_03v3 ad=0.56p pd=2.56u as=0.56p ps=2.56u w=2u l=1u
X499 w_36626_300# vbn a_36978_1227# VSS nfet_03v3 ad=0.56p pd=2.56u as=0.56p ps=2.56u w=2u l=1u
X500 a_36978_8187# vbn a_36666_9481# VSS nfet_03v3 ad=0.56p pd=2.56u as=0.56p ps=2.56u w=2u l=1u
X501 a_36978_2387# vbn a_36688_2967# VSS nfet_03v3 ad=0.56p pd=2.56u as=0.56p ps=2.56u w=2u l=1u
X502 a_36978_5867# vbn a_36688_6447# VSS nfet_03v3 ad=0.56p pd=2.56u as=0.9p ps=4.9u w=2u l=1u
X503 a_36978_7027# vbn a_36688_6447# VSS nfet_03v3 ad=0.56p pd=2.56u as=0.56p ps=2.56u w=2u l=1u
X504 a_36688_7607# vbn a_36978_7027# VSS nfet_03v3 ad=0.56p pd=2.56u as=0.56p ps=2.56u w=2u l=1u
X505 a_36978_4707# vbn a_36688_5287# VSS nfet_03v3 ad=0.56p pd=2.56u as=0.56p ps=2.56u w=2u l=1u
X506 a_n6436_6531# a_n6694_7514# a_n7286_7514# VSS nfet_03v3 ad=0.168p pd=1.16u as=0.6p ps=3.2u w=0.6u l=0.28u
X507 a_36978_4707# vbn a_36688_4127# VSS nfet_03v3 ad=0.56p pd=2.56u as=0.56p ps=2.56u w=2u l=1u
X508 a_41364_5287# vbn a_41654_5867# VSS nfet_03v3 ad=0.56p pd=2.56u as=0.56p ps=2.56u w=2u l=1u
X509 a_36666_9481# vbn a_36978_8187# VSS nfet_03v3 ad=0.56p pd=2.56u as=0.56p ps=2.56u w=2u l=1u
X510 a_36978_5867# vbn a_36688_6447# VSS nfet_03v3 ad=0.56p pd=2.56u as=0.56p ps=2.56u w=2u l=1u
X511 a_36688_5287# vbn a_36978_4707# VSS nfet_03v3 ad=0.56p pd=2.56u as=0.56p ps=2.56u w=2u l=1u
X512 a_36978_2387# vbn a_36688_2967# VSS nfet_03v3 ad=0.56p pd=2.56u as=0.56p ps=2.56u w=2u l=1u
X513 a_36978_8187# vbn a_36688_7607# VSS nfet_03v3 ad=0.56p pd=2.56u as=0.56p ps=2.56u w=2u l=1u
X514 a_36978_5867# vbn a_36688_6447# VSS nfet_03v3 ad=0.56p pd=2.56u as=0.56p ps=2.56u w=2u l=1u
X515 vbnf bitb1 a_6896_6633# VDD pfet_03v3 ad=2.25p pd=10.9u as=2.25p ps=10.9u w=5u l=0.28u
X516 a_41654_3547# vbn a_41364_2967# VSS nfet_03v3 ad=0.9p pd=4.9u as=0.56p ps=2.56u w=2u l=1u
X517 a_41654_2387# vbn a_41364_2967# VSS nfet_03v3 ad=0.56p pd=2.56u as=0.56p ps=2.56u w=2u l=1u
X518 a_36978_1227# vbn w_36626_300# VSS nfet_03v3 ad=0.56p pd=2.56u as=0.56p ps=2.56u w=2u l=1u
X519 a_36978_1227# vbn w_36626_300# VSS nfet_03v3 ad=0.56p pd=2.56u as=0.56p ps=2.56u w=2u l=1u
X520 a_36688_1807# vbn a_36978_1227# VSS nfet_03v3 ad=0.56p pd=2.56u as=0.56p ps=2.56u w=2u l=1u
X521 vbnf bit3 a_6006_896# VSS nfet_03v3 ad=0.9p pd=4.9u as=0.9p ps=4.9u w=2u l=0.28u
X522 a_36688_2967# vbn a_36978_2387# VSS nfet_03v3 ad=0.56p pd=2.56u as=0.56p ps=2.56u w=2u l=1u
X523 a_36978_7027# vbn a_36688_7607# VSS nfet_03v3 ad=0.56p pd=2.56u as=0.56p ps=2.56u w=2u l=1u
X524 a_36688_4127# vbn a_36978_3547# VSS nfet_03v3 ad=0.56p pd=2.56u as=0.56p ps=2.56u w=2u l=1u
X525 a_36978_8187# vbn a_36666_9481# VSS nfet_03v3 ad=0.56p pd=2.56u as=0.56p ps=2.56u w=2u l=1u
X526 a_36978_5867# vbn a_36688_6447# VSS nfet_03v3 ad=0.56p pd=2.56u as=0.56p ps=2.56u w=2u l=1u
X527 w_36626_300# vbn a_36978_1227# VSS nfet_03v3 ad=0.56p pd=2.56u as=0.56p ps=2.56u w=2u l=1u
X528 a_41654_7027# vbn a_41364_6447# VSS nfet_03v3 ad=0.9p pd=4.9u as=0.56p ps=2.56u w=2u l=1u
X529 a_41654_5867# vbn a_41364_6447# VSS nfet_03v3 ad=0.56p pd=2.56u as=0.56p ps=2.56u w=2u l=1u
X530 a_41364_2967# vbn a_41654_3547# VSS nfet_03v3 ad=0.56p pd=2.56u as=0.56p ps=2.56u w=2u l=1u
X531 a_36688_2967# vbn a_36978_2387# VSS nfet_03v3 ad=0.56p pd=2.56u as=0.56p ps=2.56u w=2u l=1u
X532 a_36978_4707# vbn a_36688_5287# VSS nfet_03v3 ad=0.56p pd=2.56u as=0.56p ps=2.56u w=2u l=1u
X533 a_36688_1807# vbn a_36978_2387# VSS nfet_03v3 ad=0.56p pd=2.56u as=0.56p ps=2.56u w=2u l=1u
X534 a_36688_6447# vbn a_36978_5867# VSS nfet_03v3 ad=0.56p pd=2.56u as=0.56p ps=2.56u w=2u l=1u
X535 a_36688_5287# vbn a_36978_5867# VSS nfet_03v3 ad=0.56p pd=2.56u as=0.56p ps=2.56u w=2u l=1u
X536 a_36978_4707# vbn a_36688_5287# VSS nfet_03v3 ad=0.56p pd=2.56u as=0.56p ps=2.56u w=2u l=1u
X537 a_36688_7607# vbn a_36978_7027# VSS nfet_03v3 ad=0.56p pd=2.56u as=0.56p ps=2.56u w=2u l=1u
X538 a_36688_4127# vbn a_36978_3547# VSS nfet_03v3 ad=0.56p pd=2.56u as=0.56p ps=2.56u w=2u l=1u
X539 w_37791_300# VSS VSS nplus_u r_width=2u r_length=100u
X540 a_36688_4127# vbn a_36978_4707# VSS nfet_03v3 ad=0.56p pd=2.56u as=0.56p ps=2.56u w=2u l=1u
X541 a_36688_7607# vbn a_36978_8187# VSS nfet_03v3 ad=0.56p pd=2.56u as=0.56p ps=2.56u w=2u l=1u
X542 a_36688_7607# vbn a_36978_7027# VSS nfet_03v3 ad=0.56p pd=2.56u as=0.56p ps=2.56u w=2u l=1u
X543 a_41364_1807# vbn a_41654_2387# VSS nfet_03v3 ad=0.56p pd=2.56u as=0.56p ps=2.56u w=2u l=1u
X544 a_41364_6447# vbn a_41654_7027# VSS nfet_03v3 ad=0.56p pd=2.56u as=0.56p ps=2.56u w=2u l=1u
X545 a_36978_1227# vbn w_36626_300# VSS nfet_03v3 ad=0.56p pd=2.56u as=0.56p ps=2.56u w=2u l=1u
X546 a_36978_1227# vbn a_36688_1807# VSS nfet_03v3 ad=0.56p pd=2.56u as=0.56p ps=2.56u w=2u l=1u
X547 a_36688_5287# vbn a_36978_4707# VSS nfet_03v3 ad=0.56p pd=2.56u as=0.56p ps=2.56u w=2u l=1u
X548 a_36688_6447# vbn a_36978_5867# VSS nfet_03v3 ad=0.56p pd=2.56u as=0.56p ps=2.56u w=2u l=1u
X549 a_36688_7607# vbn a_36978_7027# VSS nfet_03v3 ad=0.56p pd=2.56u as=0.56p ps=2.56u w=2u l=1u
X550 a_36688_7607# vbn a_36978_8187# VSS nfet_03v3 ad=0.56p pd=2.56u as=0.56p ps=2.56u w=2u l=1u
X551 vg a_6006_14# VSS VSS nfet_03v3 ad=0.336p pd=1.76u as=0.336p ps=1.76u w=1.2u l=5.335u
X552 a_36978_3547# vbn a_36688_2967# VSS nfet_03v3 ad=0.56p pd=2.56u as=0.56p ps=2.56u w=2u l=1u
X553 a_36978_4707# vbn a_36688_4127# VSS nfet_03v3 ad=0.56p pd=2.56u as=0.56p ps=2.56u w=2u l=1u
X554 a_41364_2967# vbn a_41654_3547# VSS nfet_03v3 ad=0.56p pd=2.56u as=0.56p ps=2.56u w=2u l=1u
X555 a_36666_9481# vbn a_36978_8187# VSS nfet_03v3 ad=0.56p pd=2.56u as=0.56p ps=2.56u w=2u l=1u
X556 a_36978_3547# vbn a_36688_4127# VSS nfet_03v3 ad=0.56p pd=2.56u as=0.56p ps=2.56u w=2u l=1u
X557 a_36978_4707# vbn a_36688_5287# VSS nfet_03v3 ad=0.56p pd=2.56u as=0.56p ps=2.56u w=2u l=1u
X558 a_36688_1807# vbn a_36978_1227# VSS nfet_03v3 ad=0.56p pd=2.56u as=0.56p ps=2.56u w=2u l=1u
X559 a_36978_5867# vbn a_36688_5287# VSS nfet_03v3 ad=0.56p pd=2.56u as=0.56p ps=2.56u w=2u l=1u
X560 a_6156_6633# bitb0 VSS VSS nfet_03v3 ad=0.45p pd=2.9u as=0.45p ps=2.9u w=1u l=0.28u
X561 a_36688_7607# vbn a_36978_7027# VSS nfet_03v3 ad=0.9p pd=4.9u as=0.56p ps=2.56u w=2u l=1u
X562 a_36978_1227# vbn a_36688_1807# VSS nfet_03v3 ad=0.56p pd=2.56u as=0.56p ps=2.56u w=2u l=1u
X563 a_36978_4707# vbn a_36688_4127# VSS nfet_03v3 ad=0.56p pd=2.56u as=0.56p ps=2.56u w=2u l=1u
X564 a_36978_7027# vbn a_36688_6447# VSS nfet_03v3 ad=0.56p pd=2.56u as=0.56p ps=2.56u w=2u l=1u
X565 a_36978_7027# vbn a_36688_7607# VSS nfet_03v3 ad=0.56p pd=2.56u as=0.56p ps=2.56u w=2u l=1u
X566 a_41654_3547# vbn a_41364_2967# VSS nfet_03v3 ad=0.56p pd=2.56u as=0.9p ps=4.9u w=2u l=1u
X567 a_41364_6447# vbn a_41654_7027# VSS nfet_03v3 ad=0.56p pd=2.56u as=0.56p ps=2.56u w=2u l=1u
X568 a_36978_8187# vbn a_36666_9481# VSS nfet_03v3 ad=0.56p pd=2.56u as=0.56p ps=2.56u w=2u l=1u
X569 a_36688_4127# vbn a_36978_3547# VSS nfet_03v3 ad=0.56p pd=2.56u as=0.56p ps=2.56u w=2u l=1u
X570 a_36688_1807# vbn a_36978_2387# VSS nfet_03v3 ad=0.56p pd=2.56u as=0.56p ps=2.56u w=2u l=1u
X571 vg a_6006_896# VSS VSS nfet_03v3 ad=0.336p pd=1.76u as=0.336p ps=1.76u w=1.2u l=5.335u
X572 VDD a_36666_9481# a_36666_9481# VDD pfet_03v3 ad=3.92p pd=14.56u as=3.92p ps=14.56u w=14u l=14u
X573 a_36978_8187# vbn a_36688_7607# VSS nfet_03v3 ad=0.56p pd=2.56u as=0.56p ps=2.56u w=2u l=1u
X574 a_36688_5287# vbn a_36978_5867# VSS nfet_03v3 ad=0.56p pd=2.56u as=0.56p ps=2.56u w=2u l=1u
X575 a_36978_2387# vbn a_36688_2967# VSS nfet_03v3 ad=0.56p pd=2.56u as=0.56p ps=2.56u w=2u l=1u
X576 a_36688_1807# vbn a_36978_1227# VSS nfet_03v3 ad=0.56p pd=2.56u as=0.56p ps=2.56u w=2u l=1u
X577 a_41654_3547# vbn a_41364_2967# VSS nfet_03v3 ad=0.56p pd=2.56u as=0.56p ps=2.56u w=2u l=1u
X578 w_36626_300# vbn a_36978_1227# VSS nfet_03v3 ad=0.56p pd=2.56u as=0.56p ps=2.56u w=2u l=1u
X579 a_n7872_8894# ls VSS ppolyf_u_1k r_width=1u r_length=0.15912m
X580 a_36688_4127# vbn a_36978_3547# VSS nfet_03v3 ad=0.56p pd=2.56u as=0.56p ps=2.56u w=2u l=1u
X581 VSS vbnf VSS VSS nfet_03v3 ad=13.7592p pd=49.7u as=0 ps=0 w=49.14u l=10u
X582 a_36688_2967# vbn a_36978_2387# VSS nfet_03v3 ad=0.56p pd=2.56u as=0.56p ps=2.56u w=2u l=1u
X583 a_36978_5867# vbn a_36688_5287# VSS nfet_03v3 ad=0.56p pd=2.56u as=0.56p ps=2.56u w=2u l=1u
X584 a_41654_7027# vbn a_41364_6447# VSS nfet_03v3 ad=0.56p pd=2.56u as=0.9p ps=4.9u w=2u l=1u
X585 a_36978_8187# vbn a_36666_9481# VSS nfet_03v3 ad=0.56p pd=2.56u as=0.56p ps=2.56u w=2u l=1u
X586 a_36688_4127# vbn a_36978_3547# VSS nfet_03v3 ad=0.56p pd=2.56u as=0.56p ps=2.56u w=2u l=1u
X587 a_36688_7607# vbn a_36978_8187# VSS nfet_03v3 ad=0.56p pd=2.56u as=0.56p ps=2.56u w=2u l=1u
X588 a_36688_4127# vbn a_36978_4707# VSS nfet_03v3 ad=0.56p pd=2.56u as=0.56p ps=2.56u w=2u l=1u
X589 a_36978_5867# vbn a_36688_6447# VSS nfet_03v3 ad=0.56p pd=2.56u as=0.56p ps=2.56u w=2u l=1u
X590 a_36978_1227# vbn w_36626_300# VSS nfet_03v3 ad=0.56p pd=2.56u as=0.56p ps=2.56u w=2u l=1u
X591 VDD a_996_6587# a0 VDD pfet_03v3 ad=2.25p pd=10.9u as=2.25p ps=10.9u w=5u l=0.28u
X592 a_36978_7027# vbn a_36688_7607# VSS nfet_03v3 ad=0.56p pd=2.56u as=0.56p ps=2.56u w=2u l=1u
X593 a_41654_4707# vbn a_41364_4127# VSS nfet_03v3 ad=0.9p pd=4.9u as=0.56p ps=2.56u w=2u l=1u
X594 a_41654_7027# vbn a_41364_6447# VSS nfet_03v3 ad=0.56p pd=2.56u as=0.56p ps=2.56u w=2u l=1u
X595 ck a_n8217_6703# VDD_LS VDD_LS pfet_03v3 ad=2.5p pd=7u as=1.125p ps=5.9u w=2.5u l=0.28u
X596 a_n5549_6703# a_n5234_7514# VDD_LS VDD_LS pfet_03v3 ad=2p pd=6u as=0.9p ps=4.9u w=2u l=0.28u
X597 a_36688_5287# vbn a_36978_4707# VSS nfet_03v3 ad=0.56p pd=2.56u as=0.56p ps=2.56u w=2u l=1u
X598 a_36688_5287# vbn a_36978_5867# VSS nfet_03v3 ad=0.56p pd=2.56u as=0.56p ps=2.56u w=2u l=1u
X599 a_36688_6447# vbn a_36978_5867# VSS nfet_03v3 ad=0.56p pd=2.56u as=0.56p ps=2.56u w=2u l=1u
X600 a_36688_7607# vbn a_36978_8187# VSS nfet_03v3 ad=0.56p pd=2.56u as=0.56p ps=2.56u w=2u l=1u
X601 a_36978_2387# vbn a_36688_1807# VSS nfet_03v3 ad=0.56p pd=2.56u as=0.56p ps=2.56u w=2u l=1u
X602 a_36688_4127# vbn a_36978_3547# VSS nfet_03v3 ad=0.9p pd=4.9u as=0.56p ps=2.56u w=2u l=1u
X603 a_36688_7607# vbn a_36978_8187# VSS nfet_03v3 ad=0.56p pd=2.56u as=0.56p ps=2.56u w=2u l=1u
X604 a_36688_2967# vbn a_36978_2387# VSS nfet_03v3 ad=0.56p pd=2.56u as=0.56p ps=2.56u w=2u l=1u
X605 a_36978_1227# vbn w_36626_300# VSS nfet_03v3 ad=0.56p pd=2.56u as=0.56p ps=2.56u w=2u l=1u
X606 a_36666_9481# vbn a_36978_8187# VSS nfet_03v3 ad=0.56p pd=2.56u as=0.56p ps=2.56u w=2u l=1u
X607 a_36978_4707# vbn a_36688_5287# VSS nfet_03v3 ad=0.56p pd=2.56u as=0.56p ps=2.56u w=2u l=1u
X608 a_36978_3547# vbn a_36688_4127# VSS nfet_03v3 ad=0.56p pd=2.56u as=0.56p ps=2.56u w=2u l=1u
X609 a_41654_8187# vbn vbn VSS nfet_03v3 ad=0.9p pd=4.9u as=0.56p ps=2.56u w=2u l=1u
X610 a_41364_4127# vbn a_41654_4707# VSS nfet_03v3 ad=0.56p pd=2.56u as=0.56p ps=2.56u w=2u l=1u
X611 a_41654_7027# vbn a_41364_7607# VSS nfet_03v3 ad=0.56p pd=2.56u as=0.56p ps=2.56u w=2u l=1u
X612 a_36978_1227# vbn a_36688_1807# VSS nfet_03v3 ad=0.56p pd=2.56u as=0.56p ps=2.56u w=2u l=1u
X613 a_36688_1807# vbn a_36978_2387# VSS nfet_03v3 ad=0.56p pd=2.56u as=0.56p ps=2.56u w=2u l=1u
X614 a_36688_6447# vbn a_36978_5867# VSS nfet_03v3 ad=0.56p pd=2.56u as=0.56p ps=2.56u w=2u l=1u
X615 a_36978_2387# vbn a_36688_2967# VSS nfet_03v3 ad=0.56p pd=2.56u as=0.56p ps=2.56u w=2u l=1u
X616 VSS vbnf VSS VSS nfet_03v3 ad=13.7592p pd=49.7u as=0 ps=0 w=49.14u l=10u
X617 a_36688_7607# vbn a_36978_8187# VSS nfet_03v3 ad=0.9p pd=4.9u as=0.56p ps=2.56u w=2u l=1u
X618 vbnf bitb2 a_6006_4704# VDD pfet_03v3 ad=2.25p pd=10.9u as=2.25p ps=10.9u w=5u l=0.28u
X619 a_36978_2387# vbn a_36688_1807# VSS nfet_03v3 ad=0.56p pd=2.56u as=0.56p ps=2.56u w=2u l=1u
X620 a_36978_4707# vbn a_36688_5287# VSS nfet_03v3 ad=0.56p pd=2.56u as=0.56p ps=2.56u w=2u l=1u
X621 a_36978_8187# vbn a_36688_7607# VSS nfet_03v3 ad=0.56p pd=2.56u as=0.56p ps=2.56u w=2u l=1u
X622 a_41364_4127# vbn a_41654_4707# VSS nfet_03v3 ad=0.56p pd=2.56u as=0.56p ps=2.56u w=2u l=1u
X623 a_36688_2967# vbn a_36978_3547# VSS nfet_03v3 ad=0.9p pd=4.9u as=0.56p ps=2.56u w=2u l=1u
X624 ls a_n3607_6703# VDD_LS VDD_LS pfet_03v3 ad=3p pd=8u as=1.35p ps=6.9u w=3u l=0.28u
X625 a_36978_3547# vbn a_36688_4127# VSS nfet_03v3 ad=0.56p pd=2.56u as=0.56p ps=2.56u w=2u l=1u
X626 a_36978_1227# vbn a_36688_1807# VSS nfet_03v3 ad=0.56p pd=2.56u as=0.56p ps=2.56u w=2u l=1u
X627 w_36626_300# vbn a_36978_1227# VSS nfet_03v3 ad=0.56p pd=2.56u as=0.56p ps=2.56u w=2u l=1u
X628 a_41654_1227# vbn VSS VSS nfet_03v3 ad=0.9p pd=4.9u as=0.56p ps=2.56u w=2u l=1u
X629 a_36688_7607# vbn a_36978_7027# VSS nfet_03v3 ad=0.56p pd=2.56u as=0.56p ps=2.56u w=2u l=1u
X630 a_36978_5867# vbn a_36688_6447# VSS nfet_03v3 ad=0.56p pd=2.56u as=0.56p ps=2.56u w=2u l=1u
X631 a_36978_5867# vbn a_36688_5287# VSS nfet_03v3 ad=0.56p pd=2.56u as=0.56p ps=2.56u w=2u l=1u
X632 a_36688_2967# vbn a_36978_2387# VSS nfet_03v3 ad=0.56p pd=2.56u as=0.56p ps=2.56u w=2u l=1u
X633 vbn vbn a_41654_8187# VSS nfet_03v3 ad=0.56p pd=2.56u as=0.56p ps=2.56u w=2u l=1u
X634 a_41654_1227# vbn a_41364_1807# VSS nfet_03v3 ad=0.56p pd=2.56u as=0.56p ps=2.56u w=2u l=1u
X635 a_36688_1807# vbn a_36978_2387# VSS nfet_03v3 ad=0.56p pd=2.56u as=0.56p ps=2.56u w=2u l=1u
X636 a_41364_4127# vbn a_41654_4707# VSS nfet_03v3 ad=0.56p pd=2.56u as=0.56p ps=2.56u w=2u l=1u
X637 a_36688_1807# vbn a_36978_1227# VSS nfet_03v3 ad=0.56p pd=2.56u as=0.56p ps=2.56u w=2u l=1u
X638 a_n5549_6703# ls a_n5128_6451# VSS nfet_03v3 ad=1p pd=4u as=0.28p ps=1.56u w=1u l=0.28u
X639 a_36688_2967# vbn a_36978_2387# VSS nfet_03v3 ad=0.56p pd=2.56u as=0.56p ps=2.56u w=2u l=1u
X640 vbn vbn a_41654_8187# VSS nfet_03v3 ad=0.56p pd=2.56u as=0.56p ps=2.56u w=2u l=1u
X641 a_36688_6447# vbn a_36978_7027# VSS nfet_03v3 ad=0.9p pd=4.9u as=0.56p ps=2.56u w=2u l=1u
X642 a_36978_5867# vbn a_36688_5287# VSS nfet_03v3 ad=0.56p pd=2.56u as=0.56p ps=2.56u w=2u l=1u
X643 a_36688_5287# vbn a_36978_4707# VSS nfet_03v3 ad=0.56p pd=2.56u as=0.56p ps=2.56u w=2u l=1u
X644 a_36688_2967# vbn a_36978_2387# VSS nfet_03v3 ad=0.56p pd=2.56u as=0.56p ps=2.56u w=2u l=1u
X645 a_36978_7027# vbn a_36688_7607# VSS nfet_03v3 ad=0.56p pd=2.56u as=0.56p ps=2.56u w=2u l=1u
X646 a_36688_6447# vbn a_36978_5867# VSS nfet_03v3 ad=0.56p pd=2.56u as=0.56p ps=2.56u w=2u l=1u
X647 a_41654_4707# vbn a_41364_5287# VSS nfet_03v3 ad=0.9p pd=4.9u as=0.56p ps=2.56u w=2u l=1u
X648 a_36978_8187# vbn a_36688_7607# VSS nfet_03v3 ad=0.56p pd=2.56u as=0.56p ps=2.56u w=2u l=1u
X649 a_36688_7607# vbn a_36978_7027# VSS nfet_03v3 ad=0.56p pd=2.56u as=0.56p ps=2.56u w=2u l=1u
X650 a_41654_4707# vbn a_41364_4127# VSS nfet_03v3 ad=0.56p pd=2.56u as=0.9p ps=4.9u w=2u l=1u
X651 a_36978_3547# vbn a_36688_2967# VSS nfet_03v3 ad=0.56p pd=2.56u as=0.56p ps=2.56u w=2u l=1u
X652 a_36978_2387# vbn a_36688_2967# VSS nfet_03v3 ad=0.56p pd=2.56u as=0.56p ps=2.56u w=2u l=1u
X653 VSS VDD_LS VSS VSS nfet_03v3 ad=13.7592p pd=49.7u as=0 ps=0 w=49.14u l=10u
X654 a_36688_1807# vbn a_36978_1227# VSS nfet_03v3 ad=0.56p pd=2.56u as=0.56p ps=2.56u w=2u l=1u
X655 vbn vbn a_41654_8187# VSS nfet_03v3 ad=0.56p pd=2.56u as=0.56p ps=2.56u w=2u l=1u
X656 a_41654_5867# vbn a_41364_5287# VSS nfet_03v3 ad=0.56p pd=2.56u as=0.56p ps=2.56u w=2u l=1u
X657 VSS vbn a_41654_1227# VSS nfet_03v3 ad=0.56p pd=2.56u as=0.56p ps=2.56u w=2u l=1u
X658 a_41654_3547# vbn a_41364_4127# VSS nfet_03v3 ad=0.56p pd=2.56u as=0.56p ps=2.56u w=2u l=1u
X659 a_36978_7027# vbn a_36688_7607# VSS nfet_03v3 ad=0.56p pd=2.56u as=0.56p ps=2.56u w=2u l=1u
X660 a_36688_6447# vbn a_36978_5867# VSS nfet_03v3 ad=0.56p pd=2.56u as=0.56p ps=2.56u w=2u l=1u
X661 a_36688_5287# vbn a_36978_5867# VSS nfet_03v3 ad=0.56p pd=2.56u as=0.56p ps=2.56u w=2u l=1u
X662 a_36978_2387# vbn a_36688_2967# VSS nfet_03v3 ad=0.56p pd=2.56u as=0.9p ps=4.9u w=2u l=1u
X663 a_36688_2967# vbn a_36978_3547# VSS nfet_03v3 ad=0.9p pd=4.9u as=0.56p ps=2.56u w=2u l=1u
X664 a_36688_6447# vbn a_36978_5867# VSS nfet_03v3 ad=0.56p pd=2.56u as=0.56p ps=2.56u w=2u l=1u
X665 a_36688_1807# vbn a_36978_1227# VSS nfet_03v3 ad=0.56p pd=2.56u as=0.56p ps=2.56u w=2u l=1u
X666 a_36978_1227# vbn a_36688_1807# VSS nfet_03v3 ad=0.56p pd=2.56u as=0.9p ps=4.9u w=2u l=1u
X667 VSS vbn a_41654_1227# VSS nfet_03v3 ad=0.56p pd=2.56u as=0.56p ps=2.56u w=2u l=1u
X668 a_36978_5867# vbn a_36688_6447# VSS nfet_03v3 ad=0.56p pd=2.56u as=0.56p ps=2.56u w=2u l=1u
X669 a_41654_8187# vbn vbn VSS nfet_03v3 ad=0.56p pd=2.56u as=0.9p ps=4.9u w=2u l=1u
X670 a_36978_7027# vbn a_36688_6447# VSS nfet_03v3 ad=0.56p pd=2.56u as=0.56p ps=2.56u w=2u l=1u
X671 ck a_n8217_6703# VSS VSS nfet_03v3 ad=1p pd=4u as=0.45p ps=2.9u w=1u l=0.28u
X672 a_36688_5287# vbn a_36978_5867# VSS nfet_03v3 ad=0.56p pd=2.56u as=0.56p ps=2.56u w=2u l=1u
X673 a_36688_7607# vbn a_36978_7027# VSS nfet_03v3 ad=0.56p pd=2.56u as=0.56p ps=2.56u w=2u l=1u
X674 a_36978_5867# vbn a_36688_6447# VSS nfet_03v3 ad=0.56p pd=2.56u as=0.9p ps=4.9u w=2u l=1u
X675 a_41364_5287# vbn a_41654_4707# VSS nfet_03v3 ad=0.56p pd=2.56u as=0.56p ps=2.56u w=2u l=1u
X676 a_36978_2387# vbn a_36688_1807# VSS nfet_03v3 ad=0.56p pd=2.56u as=0.56p ps=2.56u w=2u l=1u
X677 a_6896_6633# bitb1 VSS VSS nfet_03v3 ad=0.45p pd=2.9u as=0.45p ps=2.9u w=1u l=0.28u
X678 a_36666_9481# a_36666_9481# VDD VDD pfet_03v3 ad=3.92p pd=14.56u as=3.92p ps=14.56u w=14u l=14u
X679 a_36688_4127# vbn a_36978_3547# VSS nfet_03v3 ad=0.56p pd=2.56u as=0.56p ps=2.56u w=2u l=1u
X680 a_36978_3547# vbn a_36688_2967# VSS nfet_03v3 ad=0.56p pd=2.56u as=0.56p ps=2.56u w=2u l=1u
X681 a_41654_8187# vbn a_41364_7607# VSS nfet_03v3 ad=0.56p pd=2.56u as=0.56p ps=2.56u w=2u l=1u
X682 VSS vbn a_41654_1227# VSS nfet_03v3 ad=0.56p pd=2.56u as=0.56p ps=2.56u w=2u l=1u
X683 a_36688_6447# vbn a_36978_7027# VSS nfet_03v3 ad=0.9p pd=4.9u as=0.56p ps=2.56u w=2u l=1u
X684 a_36978_1227# vbn a_36688_1807# VSS nfet_03v3 ad=0.56p pd=2.56u as=0.9p ps=4.9u w=2u l=1u
X685 a_n7180_6531# a_n7286_7514# VSS VSS nfet_03v3 ad=0.168p pd=1.16u as=0.27p ps=2.1u w=0.6u l=0.28u
X686 a_36978_2387# vbn a_36688_2967# VSS nfet_03v3 ad=0.56p pd=2.56u as=0.56p ps=2.56u w=2u l=1u
X687 VSS vbn a_60350_8387# VSS nfet_03v3 ad=0.9p pd=4.9u as=2.36p ps=6.36u w=2u l=0.28u
X688 a_36688_5287# vbn a_36978_5867# VSS nfet_03v3 ad=0.56p pd=2.56u as=0.56p ps=2.56u w=2u l=1u
X689 VSS a_6006_896# vg VSS nfet_03v3 ad=0.54p pd=3.3u as=0.336p ps=1.76u w=1.2u l=5.335u
X690 a_36978_5867# vbn a_36688_5287# VSS nfet_03v3 ad=0.56p pd=2.56u as=0.9p ps=4.9u w=2u l=1u
X691 a_41364_5287# vbn a_41654_4707# VSS nfet_03v3 ad=0.56p pd=2.56u as=0.56p ps=2.56u w=2u l=1u
X692 a_36978_3547# vbn a_36688_4127# VSS nfet_03v3 ad=0.56p pd=2.56u as=0.56p ps=2.56u w=2u l=1u
X693 a_36688_4127# vbn a_36978_3547# VSS nfet_03v3 ad=0.56p pd=2.56u as=0.56p ps=2.56u w=2u l=1u
X694 a_36978_2387# vbn a_36688_1807# VSS nfet_03v3 ad=0.56p pd=2.56u as=0.56p ps=2.56u w=2u l=1u
X695 a_36978_1227# vbn a_36688_1807# VSS nfet_03v3 ad=0.56p pd=2.56u as=0.56p ps=2.56u w=2u l=1u
X696 a_36978_7027# vbn a_36688_6447# VSS nfet_03v3 ad=0.56p pd=2.56u as=0.56p ps=2.56u w=2u l=1u
X697 a_41654_1227# vbn VSS VSS nfet_03v3 ad=0.56p pd=2.56u as=0.9p ps=4.9u w=2u l=1u
X698 a_36688_7607# vbn a_36978_8187# VSS nfet_03v3 ad=0.56p pd=2.56u as=0.56p ps=2.56u w=2u l=1u
X699 a_36688_4127# vbn a_36978_4707# VSS nfet_03v3 ad=0.56p pd=2.56u as=0.56p ps=2.56u w=2u l=1u
X700 a_41654_2387# vbn a_41364_1807# VSS nfet_03v3 ad=0.56p pd=2.56u as=0.56p ps=2.56u w=2u l=1u
X701 a_36978_7027# vbn a_36688_7607# VSS nfet_03v3 ad=0.56p pd=2.56u as=0.56p ps=2.56u w=2u l=1u
X702 a_41364_5287# vbn a_41654_4707# VSS nfet_03v3 ad=0.56p pd=2.56u as=0.56p ps=2.56u w=2u l=1u
X703 a_36978_7027# vbn a_36688_7607# VSS nfet_03v3 ad=0.56p pd=2.56u as=0.56p ps=2.56u w=2u l=1u
X704 a_36978_3547# vbn a_36688_4127# VSS nfet_03v3 ad=0.56p pd=2.56u as=0.56p ps=2.56u w=2u l=1u
X705 a_36978_3547# vbn a_36688_2967# VSS nfet_03v3 ad=0.56p pd=2.56u as=0.56p ps=2.56u w=2u l=1u
X706 a_36978_1227# vbn a_36688_1807# VSS nfet_03v3 ad=0.56p pd=2.56u as=0.56p ps=2.56u w=2u l=1u
X707 a_36688_1807# vbn a_36978_2387# VSS nfet_03v3 ad=0.56p pd=2.56u as=0.56p ps=2.56u w=2u l=1u
X708 a_36978_5867# vbn a_36688_5287# VSS nfet_03v3 ad=0.56p pd=2.56u as=0.9p ps=4.9u w=2u l=1u
X709 a_36978_5867# vbn a_36688_6447# VSS nfet_03v3 ad=0.56p pd=2.56u as=0.56p ps=2.56u w=2u l=1u
X710 a_41364_4127# vbn a_41654_4707# VSS nfet_03v3 ad=0.56p pd=2.56u as=0.56p ps=2.56u w=2u l=1u
X711 a_36978_8187# vbn a_36688_7607# VSS nfet_03v3 ad=0.56p pd=2.56u as=0.56p ps=2.56u w=2u l=1u
X712 a_36688_7607# vbn a_36978_7027# VSS nfet_03v3 ad=0.56p pd=2.56u as=0.56p ps=2.56u w=2u l=1u
X713 a_36688_7607# vbn a_36978_8187# VSS nfet_03v3 ad=0.56p pd=2.56u as=0.56p ps=2.56u w=2u l=1u
X714 a_36978_5867# vbn a_36688_5287# VSS nfet_03v3 ad=0.56p pd=2.56u as=0.56p ps=2.56u w=2u l=1u
X715 a_36688_1807# vbn a_36978_2387# VSS nfet_03v3 ad=0.56p pd=2.56u as=0.56p ps=2.56u w=2u l=1u
X716 a_41654_4707# vbn a_41364_5287# VSS nfet_03v3 ad=0.56p pd=2.56u as=0.9p ps=4.9u w=2u l=1u
X717 a_36666_9481# vbn a_36978_8187# VSS nfet_03v3 ad=0.56p pd=2.56u as=0.56p ps=2.56u w=2u l=1u
X718 a_36688_4127# vbn a_36978_3547# VSS nfet_03v3 ad=0.56p pd=2.56u as=0.56p ps=2.56u w=2u l=1u
X719 a_36978_1227# vbn a_36688_1807# VSS nfet_03v3 ad=0.56p pd=2.56u as=0.56p ps=2.56u w=2u l=1u
X720 a_36978_7027# vbn a_36688_6447# VSS nfet_03v3 ad=0.56p pd=2.56u as=0.56p ps=2.56u w=2u l=1u
X721 a_41654_1227# vbn a_41364_1807# VSS nfet_03v3 ad=0.56p pd=2.56u as=0.56p ps=2.56u w=2u l=1u
X722 a_36978_8187# vbn a_36688_7607# VSS nfet_03v3 ad=0.56p pd=2.56u as=0.56p ps=2.56u w=2u l=1u
X723 a_36978_5867# vbn a_36688_5287# VSS nfet_03v3 ad=0.56p pd=2.56u as=0.56p ps=2.56u w=2u l=1u
X724 a_1632_6633# a_452_6633# VDD VDD pfet_03v3 ad=2.25p pd=10.9u as=2.25p ps=10.9u w=5u l=0.28u
X725 a_41654_2387# vbn a_41364_2967# VSS nfet_03v3 ad=0.9p pd=4.9u as=0.56p ps=2.56u w=2u l=1u
X726 a_36688_1807# vbn a_36978_1227# VSS nfet_03v3 ad=0.56p pd=2.56u as=0.56p ps=2.56u w=2u l=1u
X727 vbn vbn a_41654_8187# VSS nfet_03v3 ad=0.56p pd=2.56u as=0.56p ps=2.56u w=2u l=1u
X728 a_36688_1807# vbn a_36978_2387# VSS nfet_03v3 ad=0.56p pd=2.56u as=0.56p ps=2.56u w=2u l=1u
X729 a_36978_7027# vbn a_36688_7607# VSS nfet_03v3 ad=0.56p pd=2.56u as=0.56p ps=2.56u w=2u l=1u
X730 a_36688_2967# vbn a_36978_3547# VSS nfet_03v3 ad=0.56p pd=2.56u as=0.56p ps=2.56u w=2u l=1u
X731 a_36978_2387# vbn a_36688_1807# VSS nfet_03v3 ad=0.56p pd=2.56u as=0.9p ps=4.9u w=2u l=1u
X732 VSS a_6006_14# vg VSS nfet_03v3 ad=0.54p pd=3.3u as=0.336p ps=1.76u w=1.2u l=5.335u
X733 a_36688_7607# vbn a_36978_8187# VSS nfet_03v3 ad=0.56p pd=2.56u as=0.56p ps=2.56u w=2u l=1u
X734 w_36626_300# vbn a_36978_1227# VSS nfet_03v3 ad=0.56p pd=2.56u as=0.56p ps=2.56u w=2u l=1u
X735 a_36978_5867# vbn a_36688_5287# VSS nfet_03v3 ad=0.56p pd=2.56u as=0.56p ps=2.56u w=2u l=1u
X736 a_36688_1807# vbn a_36978_1227# VSS nfet_03v3 ad=0.56p pd=2.56u as=0.56p ps=2.56u w=2u l=1u
X737 a_41364_2967# vbn a_41654_2387# VSS nfet_03v3 ad=0.56p pd=2.56u as=0.56p ps=2.56u w=2u l=1u
X738 a_36978_3547# vbn a_36688_4127# VSS nfet_03v3 ad=0.56p pd=2.56u as=0.56p ps=2.56u w=2u l=1u
X739 a_41654_5867# vbn a_41364_6447# VSS nfet_03v3 ad=0.9p pd=4.9u as=0.56p ps=2.56u w=2u l=1u
X740 a_41654_5867# vbn a_41364_5287# VSS nfet_03v3 ad=0.56p pd=2.56u as=0.56p ps=2.56u w=2u l=1u
X741 a_36688_4127# vbn a_36978_4707# VSS nfet_03v3 ad=0.56p pd=2.56u as=0.56p ps=2.56u w=2u l=1u
X742 a_36978_3547# vbn a_36688_4127# VSS nfet_03v3 ad=0.56p pd=2.56u as=0.56p ps=2.56u w=2u l=1u
X743 VSS a_6006_14# vg VSS nfet_03v3 ad=0.54p pd=3.3u as=0.336p ps=1.76u w=1.2u l=5.335u
X744 a_36688_5287# vbn a_36978_5867# VSS nfet_03v3 ad=0.56p pd=2.56u as=0.56p ps=2.56u w=2u l=1u
X745 a_36688_2967# vbn a_36978_3547# VSS nfet_03v3 ad=0.56p pd=2.56u as=0.56p ps=2.56u w=2u l=1u
X746 a_36978_2387# vbn a_36688_1807# VSS nfet_03v3 ad=0.56p pd=2.56u as=0.9p ps=4.9u w=2u l=1u
X747 a_36688_6447# vbn a_36978_7027# VSS nfet_03v3 ad=0.56p pd=2.56u as=0.56p ps=2.56u w=2u l=1u
X748 VSS vbn a_41654_1227# VSS nfet_03v3 ad=0.56p pd=2.56u as=0.56p ps=2.56u w=2u l=1u
X749 a_41364_6447# vbn a_41654_5867# VSS nfet_03v3 ad=0.56p pd=2.56u as=0.56p ps=2.56u w=2u l=1u
X750 a_36688_4127# vbn a_36978_3547# VSS nfet_03v3 ad=0.56p pd=2.56u as=0.56p ps=2.56u w=2u l=1u
X751 a_36978_2387# vbn a_36688_1807# VSS nfet_03v3 ad=0.56p pd=2.56u as=0.56p ps=2.56u w=2u l=1u
X752 a_36666_9481# a_36666_9481# VDD VDD pfet_03v3 ad=3.92p pd=14.56u as=3.92p ps=14.56u w=14u l=14u
X753 a_36978_8187# vbn a_36688_7607# VSS nfet_03v3 ad=0.56p pd=2.56u as=0.56p ps=2.56u w=2u l=1u
X754 a_36688_5287# vbn a_36978_4707# VSS nfet_03v3 ad=0.56p pd=2.56u as=0.56p ps=2.56u w=2u l=1u
X755 a_36688_5287# vbn a_36978_5867# VSS nfet_03v3 ad=0.56p pd=2.56u as=0.56p ps=2.56u w=2u l=1u
X756 a_6006_14# bitb4 VSS VSS nfet_03v3 ad=0.45p pd=2.9u as=0.45p ps=2.9u w=1u l=0.28u
X757 a_36666_9481# vbn a_36978_8187# VSS nfet_03v3 ad=0.56p pd=2.56u as=0.56p ps=2.56u w=2u l=1u
X758 a_36978_8187# vbn a_36688_7607# VSS nfet_03v3 ad=0.56p pd=2.56u as=0.56p ps=2.56u w=2u l=1u
X759 a_36688_6447# vbn a_36978_7027# VSS nfet_03v3 ad=0.56p pd=2.56u as=0.56p ps=2.56u w=2u l=1u
X760 a_36978_2387# vbn a_36688_1807# VSS nfet_03v3 ad=0.56p pd=2.56u as=0.56p ps=2.56u w=2u l=1u
X761 a_36978_2387# vbn a_36688_2967# VSS nfet_03v3 ad=0.56p pd=2.56u as=0.56p ps=2.56u w=2u l=1u
X762 a_36688_7607# vbn a_36978_7027# VSS nfet_03v3 ad=0.56p pd=2.56u as=0.56p ps=2.56u w=2u l=1u
X763 a_41364_2967# vbn a_41654_2387# VSS nfet_03v3 ad=0.56p pd=2.56u as=0.56p ps=2.56u w=2u l=1u
X764 a_41364_5287# vbn a_41654_4707# VSS nfet_03v3 ad=0.56p pd=2.56u as=0.56p ps=2.56u w=2u l=1u
X765 a_36978_3547# vbn a_36688_4127# VSS nfet_03v3 ad=0.56p pd=2.56u as=0.56p ps=2.56u w=2u l=1u
X766 a_36978_3547# vbn a_36688_2967# VSS nfet_03v3 ad=0.56p pd=2.56u as=0.56p ps=2.56u w=2u l=1u
X767 a_36978_4707# vbn a_36688_4127# VSS nfet_03v3 ad=0.56p pd=2.56u as=0.56p ps=2.56u w=2u l=1u
X768 a_36688_7607# vbn a_36978_8187# VSS nfet_03v3 ad=0.56p pd=2.56u as=0.56p ps=2.56u w=2u l=1u
X769 a_n7601_6703# q1 a_n7180_6531# VSS nfet_03v3 ad=0.6p pd=3.2u as=0.168p ps=1.16u w=0.6u l=0.28u
X770 VDD_LS a_n2245_6719# a_n3101_6703# VDD_LS pfet_03v3 ad=0.225p pd=1.9u as=1.1p ps=5.4u w=0.5u l=0.28u
X771 a_n3607_6703# a_n3101_6703# VSS VSS nfet_03v3 ad=0.6p pd=3.2u as=0.27p ps=2.1u w=0.6u l=0.28u
X772 a_36978_2387# vbn a_36688_1807# VSS nfet_03v3 ad=0.56p pd=2.56u as=0.56p ps=2.56u w=2u l=1u
X773 a_41654_2387# vbn a_41364_1807# VSS nfet_03v3 ad=0.56p pd=2.56u as=0.56p ps=2.56u w=2u l=1u
X774 a_36978_7027# vbn a_36688_7607# VSS nfet_03v3 ad=0.56p pd=2.56u as=0.56p ps=2.56u w=2u l=1u
X775 VSS vbnf vg VSS nfet_03v3 ad=0.336p pd=1.76u as=0.336p ps=1.76u w=1.2u l=5.335u
X776 a_36978_5867# vbn a_36688_6447# VSS nfet_03v3 ad=0.56p pd=2.56u as=0.56p ps=2.56u w=2u l=1u
X777 a_41654_2387# vbn a_41364_2967# VSS nfet_03v3 ad=0.56p pd=2.56u as=0.9p ps=4.9u w=2u l=1u
X778 a_41364_6447# vbn a_41654_5867# VSS nfet_03v3 ad=0.56p pd=2.56u as=0.56p ps=2.56u w=2u l=1u
X779 w_36626_300# vbn a_36978_1227# VSS nfet_03v3 ad=0.56p pd=2.56u as=0.56p ps=2.56u w=2u l=1u
X780 a_36688_2967# vbn a_36978_3547# VSS nfet_03v3 ad=0.56p pd=2.56u as=0.56p ps=2.56u w=2u l=1u
X781 a_36978_7027# vbn a_36688_6447# VSS nfet_03v3 ad=0.56p pd=2.56u as=0.56p ps=2.56u w=2u l=1u
X782 a_36688_1807# vbn a_36978_2387# VSS nfet_03v3 ad=0.56p pd=2.56u as=0.56p ps=2.56u w=2u l=1u
X783 a_452_6633# a0 vg VSS nfet_03v3 ad=0.9p pd=4.9u as=0.9p ps=4.9u w=2u l=0.28u
X784 a_36688_4127# vbn a_36978_4707# VSS nfet_03v3 ad=0.56p pd=2.56u as=0.56p ps=2.56u w=2u l=1u
X785 a_36978_8187# vbn a_36688_7607# VSS nfet_03v3 ad=0.56p pd=2.56u as=0.56p ps=2.56u w=2u l=1u
X786 a_36978_1227# vbn a_36688_1807# VSS nfet_03v3 ad=0.56p pd=2.56u as=0.56p ps=2.56u w=2u l=1u
X787 a_36978_8187# vbn a_36666_9481# VSS nfet_03v3 ad=0.56p pd=2.56u as=0.56p ps=2.56u w=2u l=1u
X788 a_41654_2387# vbn a_41364_2967# VSS nfet_03v3 ad=0.56p pd=2.56u as=0.56p ps=2.56u w=2u l=1u
X789 a_36978_4707# vbn a_36688_4127# VSS nfet_03v3 ad=0.56p pd=2.56u as=0.56p ps=2.56u w=2u l=1u
X790 a_36688_2967# vbn a_36978_3547# VSS nfet_03v3 ad=0.56p pd=2.56u as=0.56p ps=2.56u w=2u l=1u
X791 a_36688_1807# vbn a_36978_1227# VSS nfet_03v3 ad=0.56p pd=2.56u as=0.56p ps=2.56u w=2u l=1u
X792 a_36978_7027# vbn a_36688_7607# VSS nfet_03v3 ad=0.56p pd=2.56u as=0.56p ps=2.56u w=2u l=1u
X793 a_36688_1807# vbn a_36978_2387# VSS nfet_03v3 ad=0.56p pd=2.56u as=0.56p ps=2.56u w=2u l=1u
X794 a_41654_5867# vbn a_41364_6447# VSS nfet_03v3 ad=0.56p pd=2.56u as=0.9p ps=4.9u w=2u l=1u
X795 a_36688_5287# vbn a_36978_4707# VSS nfet_03v3 ad=0.56p pd=2.56u as=0.56p ps=2.56u w=2u l=1u
X796 a_36688_2967# vbn a_36978_3547# VSS nfet_03v3 ad=0.56p pd=2.56u as=0.56p ps=2.56u w=2u l=1u
X797 a_36688_6447# vbn a_36978_7027# VSS nfet_03v3 ad=0.56p pd=2.56u as=0.56p ps=2.56u w=2u l=1u
X798 a_n6862_7514# a_n7601_6703# VDD_LS VDD_LS pfet_03v3 ad=0.336p pd=1.76u as=0.336p ps=1.76u w=1.2u l=0.28u
X799 VSS a_n2245_6719# a_n3101_6703# VSS nfet_03v3 ad=0.1686p pd=1.74u as=0.5448p ps=5.16u w=0.22u l=0.28u
X800 a_36666_9481# vbn a_36978_8187# VSS nfet_03v3 ad=0.56p pd=2.56u as=0.56p ps=2.56u w=2u l=1u
X801 a_36978_5867# vbn a_36688_5287# VSS nfet_03v3 ad=0.56p pd=2.56u as=0.56p ps=2.56u w=2u l=1u
X802 VDD a_36666_9481# a_36666_9481# VDD pfet_03v3 ad=3.92p pd=14.56u as=3.92p ps=14.56u w=14u l=14u
X803 a_36688_4127# vbn a_36978_3547# VSS nfet_03v3 ad=0.56p pd=2.56u as=0.56p ps=2.56u w=2u l=1u
X804 a_41654_5867# vbn a_41364_6447# VSS nfet_03v3 ad=0.56p pd=2.56u as=0.56p ps=2.56u w=2u l=1u
X805 a_36688_4127# vbn a_36978_4707# VSS nfet_03v3 ad=0.56p pd=2.56u as=0.56p ps=2.56u w=2u l=1u
X806 a_36688_6447# vbn a_36978_7027# VSS nfet_03v3 ad=0.56p pd=2.56u as=0.56p ps=2.56u w=2u l=1u
X807 a_36688_5287# vbn a_36978_5867# VSS nfet_03v3 ad=0.56p pd=2.56u as=0.56p ps=2.56u w=2u l=1u
X808 a_36978_8187# vbn a_36666_9481# VSS nfet_03v3 ad=0.56p pd=2.56u as=0.56p ps=2.56u w=2u l=1u
X809 a_36978_1227# vbn w_36626_300# VSS nfet_03v3 ad=0.56p pd=2.56u as=0.56p ps=2.56u w=2u l=1u
X810 a_36688_6447# vbn a_36978_7027# VSS nfet_03v3 ad=0.56p pd=2.56u as=0.56p ps=2.56u w=2u l=1u
X811 a_36688_1807# vbn a_36978_1227# VSS nfet_03v3 ad=0.56p pd=2.56u as=0.56p ps=2.56u w=2u l=1u
X812 vbnf bit0 a_6156_6633# VSS nfet_03v3 ad=0.9p pd=4.9u as=0.9p ps=4.9u w=2u l=0.28u
X813 a_36688_2967# vbn a_36978_3547# VSS nfet_03v3 ad=0.9p pd=4.9u as=0.56p ps=2.56u w=2u l=1u
X814 a_36688_7607# vbn a_36978_7027# VSS nfet_03v3 ad=0.56p pd=2.56u as=0.56p ps=2.56u w=2u l=1u
X815 a_36978_3547# vbn a_36688_4127# VSS nfet_03v3 ad=0.56p pd=2.56u as=0.56p ps=2.56u w=2u l=1u
X816 a_41654_7027# vbn a_41364_7607# VSS nfet_03v3 ad=0.9p pd=4.9u as=0.56p ps=2.56u w=2u l=1u
X817 a_36978_3547# vbn a_36688_2967# VSS nfet_03v3 ad=0.56p pd=2.56u as=0.56p ps=2.56u w=2u l=1u
X818 VSS a_6006_14# vg VSS nfet_03v3 ad=0.336p pd=1.76u as=0.336p ps=1.76u w=1.2u l=5.335u
X819 a_36688_7607# vbn a_36978_8187# VSS nfet_03v3 ad=0.56p pd=2.56u as=0.56p ps=2.56u w=2u l=1u
X820 a_36666_9481# vbn a_36978_8187# VSS nfet_03v3 ad=0.56p pd=2.56u as=0.56p ps=2.56u w=2u l=1u
X821 w_36626_300# vbn a_36978_1227# VSS nfet_03v3 ad=0.56p pd=2.56u as=0.56p ps=2.56u w=2u l=1u
X822 VSS a_6006_14# vg VSS nfet_03v3 ad=0.336p pd=1.76u as=0.336p ps=1.76u w=1.2u l=5.335u
X823 a_36978_4707# vbn a_36688_5287# VSS nfet_03v3 ad=0.56p pd=2.56u as=0.56p ps=2.56u w=2u l=1u
X824 a_36978_1227# vbn a_36688_1807# VSS nfet_03v3 ad=0.56p pd=2.56u as=0.56p ps=2.56u w=2u l=1u
X825 a_36688_6447# vbn a_36978_7027# VSS nfet_03v3 ad=0.9p pd=4.9u as=0.56p ps=2.56u w=2u l=1u
X826 a_36688_5287# vbn a_36978_5867# VSS nfet_03v3 ad=0.56p pd=2.56u as=0.56p ps=2.56u w=2u l=1u
X827 a_36978_1227# vbn w_36626_300# VSS nfet_03v3 ad=0.56p pd=2.56u as=0.56p ps=2.56u w=2u l=1u
X828 a_36978_3547# vbn a_36688_4127# VSS nfet_03v3 ad=0.56p pd=2.56u as=0.56p ps=2.56u w=2u l=1u
X829 a_n5128_6451# a_n5234_7514# VSS VSS nfet_03v3 ad=0.28p pd=1.56u as=0.45p ps=2.9u w=1u l=0.28u
X830 a_36978_8187# vbn a_36688_7607# VSS nfet_03v3 ad=0.56p pd=2.56u as=0.56p ps=2.56u w=2u l=1u
X831 a_36978_7027# vbn a_36688_6447# VSS nfet_03v3 ad=0.56p pd=2.56u as=0.56p ps=2.56u w=2u l=1u
X832 vbnf bitb3 a_6006_896# VDD pfet_03v3 ad=2.25p pd=10.9u as=2.25p ps=10.9u w=5u l=0.28u
X833 a_36688_1807# vbn a_36978_1227# VSS nfet_03v3 ad=0.56p pd=2.56u as=0.56p ps=2.56u w=2u l=1u
X834 a_36978_2387# vbn a_36688_1807# VSS nfet_03v3 ad=0.56p pd=2.56u as=0.56p ps=2.56u w=2u l=1u
X835 a_36688_2967# vbn a_36978_2387# VSS nfet_03v3 ad=0.9p pd=4.9u as=0.56p ps=2.56u w=2u l=1u
X836 a_36978_3547# vbn a_36688_2967# VSS nfet_03v3 ad=0.56p pd=2.56u as=0.56p ps=2.56u w=2u l=1u
X837 a_36688_5287# vbn a_36978_4707# VSS nfet_03v3 ad=0.56p pd=2.56u as=0.56p ps=2.56u w=2u l=1u
X838 a_36978_4707# vbn a_36688_4127# VSS nfet_03v3 ad=0.56p pd=2.56u as=0.56p ps=2.56u w=2u l=1u
X839 a_41364_7607# vbn a_41654_7027# VSS nfet_03v3 ad=0.56p pd=2.56u as=0.56p ps=2.56u w=2u l=1u
X840 a_36978_5867# vbn a_36688_5287# VSS nfet_03v3 ad=0.56p pd=2.56u as=0.56p ps=2.56u w=2u l=1u
X841 w_36626_300# vbn a_36978_1227# VSS nfet_03v3 ad=0.56p pd=2.56u as=0.56p ps=2.56u w=2u l=1u
X842 a_36688_1807# vbn a_36978_2387# VSS nfet_03v3 ad=0.56p pd=2.56u as=0.56p ps=2.56u w=2u l=1u
X843 a_36978_4707# vbn a_36688_5287# VSS nfet_03v3 ad=0.56p pd=2.56u as=0.56p ps=2.56u w=2u l=1u
X844 a_36978_8187# vbn a_36688_7607# VSS nfet_03v3 ad=0.56p pd=2.56u as=0.56p ps=2.56u w=2u l=1u
X845 a_36688_1807# vbn a_36978_1227# VSS nfet_03v3 ad=0.56p pd=2.56u as=0.56p ps=2.56u w=2u l=1u
X846 a_41364_7607# vbn a_41654_7027# VSS nfet_03v3 ad=0.56p pd=2.56u as=0.56p ps=2.56u w=2u l=1u
X847 a_36978_7027# vbn a_36688_6447# VSS nfet_03v3 ad=0.56p pd=2.56u as=0.56p ps=2.56u w=2u l=1u
X848 a_36978_4707# vbn a_36688_4127# VSS nfet_03v3 ad=0.56p pd=2.56u as=0.56p ps=2.56u w=2u l=1u
X849 a_36688_4127# vbn a_36978_3547# VSS nfet_03v3 ad=0.56p pd=2.56u as=0.56p ps=2.56u w=2u l=1u
X850 a_36688_1807# vbn a_36978_1227# VSS nfet_03v3 ad=0.56p pd=2.56u as=0.56p ps=2.56u w=2u l=1u
X851 a_36688_6447# vbn a_36978_5867# VSS nfet_03v3 ad=0.9p pd=4.9u as=0.56p ps=2.56u w=2u l=1u
X852 a_41654_3547# vbn a_41364_4127# VSS nfet_03v3 ad=0.9p pd=4.9u as=0.56p ps=2.56u w=2u l=1u
X853 a_36978_8187# vbn a_36666_9481# VSS nfet_03v3 ad=0.56p pd=2.56u as=0.56p ps=2.56u w=2u l=1u
X854 a_36688_5287# vbn a_36978_5867# VSS nfet_03v3 ad=0.56p pd=2.56u as=0.56p ps=2.56u w=2u l=1u
X855 VSS a_6006_896# vg VSS nfet_03v3 ad=0.54p pd=3.3u as=0.336p ps=1.76u w=1.2u l=5.335u
X856 a_36978_1227# vbn a_36688_1807# VSS nfet_03v3 ad=0.56p pd=2.56u as=0.56p ps=2.56u w=2u l=1u
X857 a_41364_7607# vbn a_41654_7027# VSS nfet_03v3 ad=0.56p pd=2.56u as=0.56p ps=2.56u w=2u l=1u
X858 a_41654_4707# vbn a_41364_4127# VSS nfet_03v3 ad=0.56p pd=2.56u as=0.56p ps=2.56u w=2u l=1u
X859 a_36978_2387# vbn a_36688_2967# VSS nfet_03v3 ad=0.56p pd=2.56u as=0.56p ps=2.56u w=2u l=1u
X860 a_36688_5287# vbn a_36978_4707# VSS nfet_03v3 ad=0.56p pd=2.56u as=0.56p ps=2.56u w=2u l=1u
X861 a_36978_1227# vbn a_36688_1807# VSS nfet_03v3 ad=0.56p pd=2.56u as=0.9p ps=4.9u w=2u l=1u
X862 a_36688_4127# vbn a_36978_4707# VSS nfet_03v3 ad=0.56p pd=2.56u as=0.56p ps=2.56u w=2u l=1u
X863 a_41654_3547# vbn a_41364_2967# VSS nfet_03v3 ad=0.56p pd=2.56u as=0.56p ps=2.56u w=2u l=1u
X864 a_36688_5287# vbn a_36978_5867# VSS nfet_03v3 ad=0.56p pd=2.56u as=0.56p ps=2.56u w=2u l=1u
X865 a_36688_2967# vbn a_36978_2387# VSS nfet_03v3 ad=0.9p pd=4.9u as=0.56p ps=2.56u w=2u l=1u
X866 a_36688_1807# vbn a_36978_2387# VSS nfet_03v3 ad=0.56p pd=2.56u as=0.56p ps=2.56u w=2u l=1u
X867 a_36978_8187# vbn a_36666_9481# VSS nfet_03v3 ad=0.56p pd=2.56u as=0.56p ps=2.56u w=2u l=1u
X868 a_36688_7607# vbn a_36978_8187# VSS nfet_03v3 ad=0.56p pd=2.56u as=0.56p ps=2.56u w=2u l=1u
X869 a_36688_5287# vbn a_36978_5867# VSS nfet_03v3 ad=0.56p pd=2.56u as=0.56p ps=2.56u w=2u l=1u
X870 a_41654_8187# vbn a_41364_7607# VSS nfet_03v3 ad=0.9p pd=4.9u as=0.56p ps=2.56u w=2u l=1u
X871 a_41654_7027# vbn a_41364_7607# VSS nfet_03v3 ad=0.56p pd=2.56u as=0.9p ps=4.9u w=2u l=1u
X872 a_36688_4127# vbn a_36978_4707# VSS nfet_03v3 ad=0.56p pd=2.56u as=0.56p ps=2.56u w=2u l=1u
X873 a_41654_8187# vbn vbn VSS nfet_03v3 ad=0.56p pd=2.56u as=0.56p ps=2.56u w=2u l=1u
X874 a_36978_5867# vbn a_36688_6447# VSS nfet_03v3 ad=0.56p pd=2.56u as=0.56p ps=2.56u w=2u l=1u
X875 a_36978_5867# vbn a_36688_5287# VSS nfet_03v3 ad=0.56p pd=2.56u as=0.56p ps=2.56u w=2u l=1u
X876 a_41364_4127# vbn a_41654_3547# VSS nfet_03v3 ad=0.56p pd=2.56u as=0.56p ps=2.56u w=2u l=1u
X877 a_36978_1227# vbn w_36626_300# VSS nfet_03v3 ad=0.56p pd=2.56u as=0.56p ps=2.56u w=2u l=1u
X878 a_n6694_7514# q1 a_n6862_7514# VDD_LS pfet_03v3 ad=1.2p pd=4.4u as=0.336p ps=1.76u w=1.2u l=0.28u
X879 VSS a_6006_14# vg VSS nfet_03v3 ad=0.54p pd=3.3u as=0.336p ps=1.76u w=1.2u l=5.335u
X880 a_36666_9481# vbn a_36978_8187# VSS nfet_03v3 ad=0.56p pd=2.56u as=0.56p ps=2.56u w=2u l=1u
X881 a_36978_5867# vbn a_36688_5287# VSS nfet_03v3 ad=0.56p pd=2.56u as=0.9p ps=4.9u w=2u l=1u
X882 a_41654_7027# vbn a_41364_6447# VSS nfet_03v3 ad=0.56p pd=2.56u as=0.56p ps=2.56u w=2u l=1u
X883 a_36688_2967# vbn a_36978_3547# VSS nfet_03v3 ad=0.56p pd=2.56u as=0.56p ps=2.56u w=2u l=1u
X884 a_36978_2387# vbn a_36688_2967# VSS nfet_03v3 ad=0.56p pd=2.56u as=0.56p ps=2.56u w=2u l=1u
X885 a_36978_2387# vbn a_36688_1807# VSS nfet_03v3 ad=0.56p pd=2.56u as=0.56p ps=2.56u w=2u l=1u
X886 a_36688_6447# vbn a_36978_5867# VSS nfet_03v3 ad=0.9p pd=4.9u as=0.56p ps=2.56u w=2u l=1u
X887 a_36978_1227# vbn a_36688_1807# VSS nfet_03v3 ad=0.56p pd=2.56u as=0.56p ps=2.56u w=2u l=1u
X888 a_41364_4127# vbn a_41654_3547# VSS nfet_03v3 ad=0.56p pd=2.56u as=0.56p ps=2.56u w=2u l=1u
X889 a_36688_4127# vbn a_36978_4707# VSS nfet_03v3 ad=0.56p pd=2.56u as=0.56p ps=2.56u w=2u l=1u
X890 a_36978_4707# vbn a_36688_4127# VSS nfet_03v3 ad=0.56p pd=2.56u as=0.9p ps=4.9u w=2u l=1u
X891 a_36978_1227# vbn w_36626_300# VSS nfet_03v3 ad=0.56p pd=2.56u as=0.56p ps=2.56u w=2u l=1u
X892 a_36666_9481# vbn a_36978_8187# VSS nfet_03v3 ad=0.56p pd=2.56u as=0.56p ps=2.56u w=2u l=1u
X893 a_36978_3547# vbn a_36688_2967# VSS nfet_03v3 ad=0.56p pd=2.56u as=0.56p ps=2.56u w=2u l=1u
X894 a_36688_1807# vbn a_36978_2387# VSS nfet_03v3 ad=0.56p pd=2.56u as=0.56p ps=2.56u w=2u l=1u
X895 a_36688_6447# vbn a_36978_7027# VSS nfet_03v3 ad=0.56p pd=2.56u as=0.56p ps=2.56u w=2u l=1u
X896 a_36978_4707# vbn a_36688_5287# VSS nfet_03v3 ad=0.56p pd=2.56u as=0.56p ps=2.56u w=2u l=1u
X897 a_36978_5867# vbn a_36688_6447# VSS nfet_03v3 ad=0.56p pd=2.56u as=0.56p ps=2.56u w=2u l=1u
X898 a_41364_7607# vbn a_41654_8187# VSS nfet_03v3 ad=0.56p pd=2.56u as=0.56p ps=2.56u w=2u l=1u
X899 a_36688_2967# vbn a_36978_3547# VSS nfet_03v3 ad=0.56p pd=2.56u as=0.56p ps=2.56u w=2u l=1u
X900 a_41654_1227# vbn VSS VSS nfet_03v3 ad=0.56p pd=2.56u as=0.56p ps=2.56u w=2u l=1u
X901 a_41364_4127# vbn a_41654_3547# VSS nfet_03v3 ad=0.56p pd=2.56u as=0.56p ps=2.56u w=2u l=1u
X902 w_36626_300# vbn a_36978_1227# VSS nfet_03v3 ad=0.56p pd=2.56u as=0.56p ps=2.56u w=2u l=1u
X903 a_36978_4707# vbn a_36688_4127# VSS nfet_03v3 ad=0.56p pd=2.56u as=0.9p ps=4.9u w=2u l=1u
X904 a_36688_1807# vbn a_36978_2387# VSS nfet_03v3 ad=0.56p pd=2.56u as=0.56p ps=2.56u w=2u l=1u
X905 a_36978_3547# vbn a_36688_2967# VSS nfet_03v3 ad=0.56p pd=2.56u as=0.56p ps=2.56u w=2u l=1u
X906 a_36978_2387# vbn a_36688_2967# VSS nfet_03v3 ad=0.56p pd=2.56u as=0.56p ps=2.56u w=2u l=1u
X907 a_36978_5867# vbn a_36688_5287# VSS nfet_03v3 ad=0.56p pd=2.56u as=0.56p ps=2.56u w=2u l=1u
X908 a_36666_9481# vbn a_36978_8187# VSS nfet_03v3 ad=0.56p pd=2.56u as=0.56p ps=2.56u w=2u l=1u
X909 a_1867_7085# a_1632_6633# vg VSS nfet_03v3 ad=0.9p pd=4.9u as=0.9p ps=4.9u w=2u l=0.28u
X910 a_36978_8187# vbn a_36666_9481# VSS nfet_03v3 ad=0.56p pd=2.56u as=0.9p ps=4.9u w=2u l=1u
X911 a_36688_1807# vbn a_36978_2387# VSS nfet_03v3 ad=0.56p pd=2.56u as=0.56p ps=2.56u w=2u l=1u
X912 a_41364_7607# vbn a_41654_8187# VSS nfet_03v3 ad=0.56p pd=2.56u as=0.56p ps=2.56u w=2u l=1u
X913 a_36978_4707# vbn a_36688_5287# VSS nfet_03v3 ad=0.56p pd=2.56u as=0.56p ps=2.56u w=2u l=1u
X914 a_36978_7027# vbn a_36688_6447# VSS nfet_03v3 ad=0.56p pd=2.56u as=0.56p ps=2.56u w=2u l=1u
X915 a_36978_4707# vbn a_36688_4127# VSS nfet_03v3 ad=0.56p pd=2.56u as=0.56p ps=2.56u w=2u l=1u
X916 a_36688_6447# vbn a_36978_7027# VSS nfet_03v3 ad=0.56p pd=2.56u as=0.56p ps=2.56u w=2u l=1u
X917 a_41654_3547# vbn a_41364_4127# VSS nfet_03v3 ad=0.56p pd=2.56u as=0.9p ps=4.9u w=2u l=1u
X918 a_36688_7607# vbn a_36978_7027# VSS nfet_03v3 ad=0.56p pd=2.56u as=0.56p ps=2.56u w=2u l=1u
X919 w_36626_300# vbn a_36978_1227# VSS nfet_03v3 ad=0.56p pd=2.56u as=0.56p ps=2.56u w=2u l=1u
X920 a_36978_2387# vbn a_36688_1807# VSS nfet_03v3 ad=0.56p pd=2.56u as=0.56p ps=2.56u w=2u l=1u
X921 a_41364_7607# vbn a_41654_8187# VSS nfet_03v3 ad=0.56p pd=2.56u as=0.56p ps=2.56u w=2u l=1u
X922 a_41654_4707# vbn a_41364_5287# VSS nfet_03v3 ad=0.56p pd=2.56u as=0.56p ps=2.56u w=2u l=1u
X923 a_36978_4707# vbn a_36688_4127# VSS nfet_03v3 ad=0.56p pd=2.56u as=0.56p ps=2.56u w=2u l=1u
X924 a_36688_2967# vbn a_36978_3547# VSS nfet_03v3 ad=0.56p pd=2.56u as=0.56p ps=2.56u w=2u l=1u
X925 a_36978_2387# vbn a_36688_1807# VSS nfet_03v3 ad=0.56p pd=2.56u as=0.9p ps=4.9u w=2u l=1u
X926 a_36978_7027# vbn a_36688_6447# VSS nfet_03v3 ad=0.56p pd=2.56u as=0.56p ps=2.56u w=2u l=1u
X927 a_36978_5867# vbn a_36688_6447# VSS nfet_03v3 ad=0.56p pd=2.56u as=0.56p ps=2.56u w=2u l=1u
X928 a_36688_5287# vbn a_36978_4707# VSS nfet_03v3 ad=0.56p pd=2.56u as=0.56p ps=2.56u w=2u l=1u
X929 a_41654_1227# vbn a_41364_1807# VSS nfet_03v3 ad=0.9p pd=4.9u as=0.56p ps=2.56u w=2u l=1u
X930 a_36978_8187# vbn a_36666_9481# VSS nfet_03v3 ad=0.56p pd=2.56u as=0.9p ps=4.9u w=2u l=1u
X931 a_41364_7607# vbn a_41654_7027# VSS nfet_03v3 ad=0.56p pd=2.56u as=0.56p ps=2.56u w=2u l=1u
X932 w_36626_300# vbn a_36978_1227# VSS nfet_03v3 ad=0.56p pd=2.56u as=0.56p ps=2.56u w=2u l=1u
X933 a_36978_1227# vbn w_36626_300# VSS nfet_03v3 ad=0.56p pd=2.56u as=0.9p ps=4.9u w=2u l=1u
X934 a_36978_8187# vbn a_36666_9481# VSS nfet_03v3 ad=0.56p pd=2.56u as=0.56p ps=2.56u w=2u l=1u
X935 a_36688_2967# vbn a_36978_2387# VSS nfet_03v3 ad=0.56p pd=2.56u as=0.56p ps=2.56u w=2u l=1u
X936 a_41654_8187# vbn a_41364_7607# VSS nfet_03v3 ad=0.56p pd=2.56u as=0.9p ps=4.9u w=2u l=1u
X937 a_36688_5287# vbn a_36978_4707# VSS nfet_03v3 ad=0.56p pd=2.56u as=0.56p ps=2.56u w=2u l=1u
X938 a_36978_4707# vbn a_36688_4127# VSS nfet_03v3 ad=0.56p pd=2.56u as=0.56p ps=2.56u w=2u l=1u
X939 a_36688_6447# vbn a_36978_7027# VSS nfet_03v3 ad=0.56p pd=2.56u as=0.56p ps=2.56u w=2u l=1u
X940 VSS a_6006_4704# vg VSS nfet_03v3 ad=0.54p pd=3.3u as=0.336p ps=1.76u w=1.2u l=5.335u
X941 a_41654_4707# vbn a_41364_4127# VSS nfet_03v3 ad=0.56p pd=2.56u as=0.56p ps=2.56u w=2u l=1u
X942 a_41364_1807# vbn a_41654_1227# VSS nfet_03v3 ad=0.56p pd=2.56u as=0.56p ps=2.56u w=2u l=1u
X943 a_36978_8187# vbn a_36666_9481# VSS nfet_03v3 ad=0.56p pd=2.56u as=0.56p ps=2.56u w=2u l=1u
X944 a_36978_3547# vbn a_36688_2967# VSS nfet_03v3 ad=0.56p pd=2.56u as=0.56p ps=2.56u w=2u l=1u
X945 a_41654_5867# vbn a_41364_5287# VSS nfet_03v3 ad=0.9p pd=4.9u as=0.56p ps=2.56u w=2u l=1u
X946 a_36688_4127# vbn a_36978_4707# VSS nfet_03v3 ad=0.56p pd=2.56u as=0.56p ps=2.56u w=2u l=1u
X947 a_36978_3547# vbn a_36688_2967# VSS nfet_03v3 ad=0.56p pd=2.56u as=0.56p ps=2.56u w=2u l=1u
X948 a_36978_1227# vbn w_36626_300# VSS nfet_03v3 ad=0.56p pd=2.56u as=0.9p ps=4.9u w=2u l=1u
X949 VSS vbnf vg VSS nfet_03v3 ad=0.336p pd=1.76u as=0.336p ps=1.76u w=1.2u l=5.335u
X950 a_36688_2967# vbn a_36978_2387# VSS nfet_03v3 ad=0.56p pd=2.56u as=0.56p ps=2.56u w=2u l=1u
X951 a_36978_2387# vbn a_36688_1807# VSS nfet_03v3 ad=0.56p pd=2.56u as=0.56p ps=2.56u w=2u l=1u
X952 a_36688_5287# vbn a_36978_4707# VSS nfet_03v3 ad=0.56p pd=2.56u as=0.56p ps=2.56u w=2u l=1u
X953 a_36688_6447# vbn a_36978_5867# VSS nfet_03v3 ad=0.56p pd=2.56u as=0.56p ps=2.56u w=2u l=1u
X954 a_36978_4707# vbn a_36688_5287# VSS nfet_03v3 ad=0.56p pd=2.56u as=0.9p ps=4.9u w=2u l=1u
X955 vbn vbnf VSS ppolyf_u_1k r_width=1u r_length=0.97023m
X956 a_36978_1227# vbn w_36626_300# VSS nfet_03v3 ad=0.56p pd=2.56u as=0.56p ps=2.56u w=2u l=1u
X957 a_36978_8187# vbn a_36666_9481# VSS nfet_03v3 ad=0.56p pd=2.56u as=0.56p ps=2.56u w=2u l=1u
X958 a_41364_5287# vbn a_41654_5867# VSS nfet_03v3 ad=0.56p pd=2.56u as=0.56p ps=2.56u w=2u l=1u
X959 a_36978_7027# vbn a_36688_6447# VSS nfet_03v3 ad=0.56p pd=2.56u as=0.56p ps=2.56u w=2u l=1u
X960 a_36688_4127# vbn a_36978_3547# VSS nfet_03v3 ad=0.56p pd=2.56u as=0.56p ps=2.56u w=2u l=1u
X961 a_36688_2967# vbn a_36978_3547# VSS nfet_03v3 ad=0.56p pd=2.56u as=0.56p ps=2.56u w=2u l=1u
X962 a_36688_4127# vbn a_36978_4707# VSS nfet_03v3 ad=0.56p pd=2.56u as=0.56p ps=2.56u w=2u l=1u
X963 a_41654_8187# vbn vbn VSS nfet_03v3 ad=0.56p pd=2.56u as=0.56p ps=2.56u w=2u l=1u
X964 a_36978_7027# vbn a_36688_6447# VSS nfet_03v3 ad=0.56p pd=2.56u as=0.56p ps=2.56u w=2u l=1u
X965 ls a_n3607_6703# VSS VSS nfet_03v3 ad=1.2p pd=4.4u as=0.54p ps=3.3u w=1.2u l=0.28u
X966 a_36688_7607# vbn a_36978_7027# VSS nfet_03v3 ad=0.56p pd=2.56u as=0.56p ps=2.56u w=2u l=1u
X967 a_36978_1227# vbn w_36626_300# VSS nfet_03v3 ad=0.56p pd=2.56u as=0.56p ps=2.56u w=2u l=1u
X968 a_36666_9481# vbn a_36978_8187# VSS nfet_03v3 ad=0.56p pd=2.56u as=0.56p ps=2.56u w=2u l=1u
X969 a_36978_4707# vbn a_36688_5287# VSS nfet_03v3 ad=0.56p pd=2.56u as=0.9p ps=4.9u w=2u l=1u
X970 a_36688_6447# vbn a_36978_5867# VSS nfet_03v3 ad=0.56p pd=2.56u as=0.56p ps=2.56u w=2u l=1u
X971 a_36978_1227# vbn a_36688_1807# VSS nfet_03v3 ad=0.56p pd=2.56u as=0.56p ps=2.56u w=2u l=1u
X972 VSS a_6006_14# vg VSS nfet_03v3 ad=0.336p pd=1.76u as=0.336p ps=1.76u w=1.2u l=5.335u
X973 a_41364_1807# vbn a_41654_1227# VSS nfet_03v3 ad=0.56p pd=2.56u as=0.56p ps=2.56u w=2u l=1u
X974 a_41364_4127# vbn a_41654_3547# VSS nfet_03v3 ad=0.56p pd=2.56u as=0.56p ps=2.56u w=2u l=1u
X975 a_36688_6447# vbn a_36978_7027# VSS nfet_03v3 ad=0.56p pd=2.56u as=0.56p ps=2.56u w=2u l=1u
X976 a_36978_3547# vbn a_36688_2967# VSS nfet_03v3 ad=0.56p pd=2.56u as=0.56p ps=2.56u w=2u l=1u
X977 a_36978_2387# vbn a_36688_2967# VSS nfet_03v3 ad=0.56p pd=2.56u as=0.56p ps=2.56u w=2u l=1u
X978 a_36978_4707# vbn a_36688_5287# VSS nfet_03v3 ad=0.56p pd=2.56u as=0.56p ps=2.56u w=2u l=1u
X979 a_36688_7607# vbn a_36978_8187# VSS nfet_03v3 ad=0.56p pd=2.56u as=0.56p ps=2.56u w=2u l=1u
X980 a_36666_9481# vbn a_36978_8187# VSS nfet_03v3 ad=0.56p pd=2.56u as=0.56p ps=2.56u w=2u l=1u
X981 vbn a_36666_9481# VDD VDD pfet_03v3 ad=3.92p pd=14.56u as=3.92p ps=14.56u w=14u l=14u
X982 a_36978_1227# vbn w_36626_300# VSS nfet_03v3 ad=0.56p pd=2.56u as=0.56p ps=2.56u w=2u l=1u
X983 a_36978_4707# vbn a_36688_5287# VSS nfet_03v3 ad=0.56p pd=2.56u as=0.56p ps=2.56u w=2u l=1u
X984 a_41654_1227# vbn VSS VSS nfet_03v3 ad=0.56p pd=2.56u as=0.56p ps=2.56u w=2u l=1u
X985 a_41654_1227# vbn a_41364_1807# VSS nfet_03v3 ad=0.56p pd=2.56u as=0.9p ps=4.9u w=2u l=1u
X986 a_996_6587# a_1867_7085# vg VSS nfet_03v3 ad=0.9p pd=4.9u as=0.9p ps=4.9u w=2u l=0.28u
X987 a_41654_2387# vbn a_41364_1807# VSS nfet_03v3 ad=0.9p pd=4.9u as=0.56p ps=2.56u w=2u l=1u
X988 a_36978_5867# vbn a_36688_5287# VSS nfet_03v3 ad=0.56p pd=2.56u as=0.56p ps=2.56u w=2u l=1u
X989 a_41364_5287# vbn a_41654_5867# VSS nfet_03v3 ad=0.56p pd=2.56u as=0.56p ps=2.56u w=2u l=1u
X990 w_36626_300# vbn a_36978_1227# VSS nfet_03v3 ad=0.56p pd=2.56u as=0.56p ps=2.56u w=2u l=1u
X991 a_36688_2967# vbn a_36978_2387# VSS nfet_03v3 ad=0.56p pd=2.56u as=0.56p ps=2.56u w=2u l=1u
X992 a_36978_5867# vbn a_36688_6447# VSS nfet_03v3 ad=0.56p pd=2.56u as=0.56p ps=2.56u w=2u l=1u
X993 a_36978_7027# vbn a_36688_6447# VSS nfet_03v3 ad=0.56p pd=2.56u as=0.56p ps=2.56u w=2u l=1u
X994 a_41364_7607# vbn a_41654_8187# VSS nfet_03v3 ad=0.56p pd=2.56u as=0.56p ps=2.56u w=2u l=1u
X995 a_36978_7027# vbn a_36688_7607# VSS nfet_03v3 ad=0.56p pd=2.56u as=0.56p ps=2.56u w=2u l=1u
X996 a_n7872_8894# VSS a_n2245_6719# VDD_LS pfet_03v3 ad=0.2808p pd=2.76u as=0.2808p ps=2.76u w=0.22u l=2u
X997 a_41654_1227# vbn a_41364_1807# VSS nfet_03v3 ad=0.56p pd=2.56u as=0.56p ps=2.56u w=2u l=1u
X998 a_36978_4707# vbn a_36688_5287# VSS nfet_03v3 ad=0.56p pd=2.56u as=0.56p ps=2.56u w=2u l=1u
X999 a_36688_2967# vbn a_36978_2387# VSS nfet_03v3 ad=0.56p pd=2.56u as=0.56p ps=2.56u w=2u l=1u
X1000 w_36626_300# vbn a_36978_1227# VSS nfet_03v3 ad=0.56p pd=2.56u as=0.56p ps=2.56u w=2u l=1u
X1001 a_41654_4707# vbn a_41364_5287# VSS nfet_03v3 ad=0.56p pd=2.56u as=0.56p ps=2.56u w=2u l=1u
X1002 a_41364_1807# vbn a_41654_2387# VSS nfet_03v3 ad=0.56p pd=2.56u as=0.56p ps=2.56u w=2u l=1u
X1003 a_36688_4127# vbn a_36978_3547# VSS nfet_03v3 ad=0.56p pd=2.56u as=0.56p ps=2.56u w=2u l=1u
X1004 a_41654_5867# vbn a_41364_5287# VSS nfet_03v3 ad=0.56p pd=2.56u as=0.9p ps=4.9u w=2u l=1u
X1005 a_36688_5287# vbn a_36978_4707# VSS nfet_03v3 ad=0.56p pd=2.56u as=0.56p ps=2.56u w=2u l=1u
X1006 a_36688_2967# vbn a_36978_2387# VSS nfet_03v3 ad=0.56p pd=2.56u as=0.56p ps=2.56u w=2u l=1u
X1007 a_36688_6447# vbn a_36978_5867# VSS nfet_03v3 ad=0.56p pd=2.56u as=0.56p ps=2.56u w=2u l=1u
X1008 VSS VDD_LS VSS VSS nfet_03v3 ad=13.7592p pd=49.7u as=0 ps=0 w=49.14u l=10u
X1009 vbnf bit4 a_6006_14# VSS nfet_03v3 ad=0.9p pd=4.9u as=0.9p ps=4.9u w=2u l=0.28u
X1010 a_36688_7607# vbn a_36978_7027# VSS nfet_03v3 ad=0.56p pd=2.56u as=0.56p ps=2.56u w=2u l=1u
X1011 a_36978_4707# vbn a_36688_4127# VSS nfet_03v3 ad=0.56p pd=2.56u as=0.56p ps=2.56u w=2u l=1u
X1012 a_36688_2967# vbn a_36978_3547# VSS nfet_03v3 ad=0.56p pd=2.56u as=0.56p ps=2.56u w=2u l=1u
X1013 a_41654_5867# vbn a_41364_5287# VSS nfet_03v3 ad=0.56p pd=2.56u as=0.56p ps=2.56u w=2u l=1u
X1014 a_36688_4127# vbn a_36978_4707# VSS nfet_03v3 ad=0.56p pd=2.56u as=0.56p ps=2.56u w=2u l=1u
X1015 a_36688_6447# vbn a_36978_5867# VSS nfet_03v3 ad=0.56p pd=2.56u as=0.56p ps=2.56u w=2u l=1u
X1016 a_36978_7027# vbn a_36688_7607# VSS nfet_03v3 ad=0.56p pd=2.56u as=0.56p ps=2.56u w=2u l=1u
X1017 a_36688_5287# vbn a_36978_4707# VSS nfet_03v3 ad=0.56p pd=2.56u as=0.56p ps=2.56u w=2u l=1u
X1018 a_36688_7607# vbn a_36978_8187# VSS nfet_03v3 ad=0.56p pd=2.56u as=0.56p ps=2.56u w=2u l=1u
X1019 a_36688_6447# vbn a_36978_5867# VSS nfet_03v3 ad=0.56p pd=2.56u as=0.56p ps=2.56u w=2u l=1u
X1020 a_36688_2967# vbn a_36978_2387# VSS nfet_03v3 ad=0.9p pd=4.9u as=0.56p ps=2.56u w=2u l=1u
X1021 a_36978_8187# vbn a_36666_9481# VSS nfet_03v3 ad=0.56p pd=2.56u as=0.56p ps=2.56u w=2u l=1u
X1022 a_36978_2387# vbn a_36688_1807# VSS nfet_03v3 ad=0.56p pd=2.56u as=0.56p ps=2.56u w=2u l=1u
X1023 a_36688_6447# vbn a_36978_7027# VSS nfet_03v3 ad=0.56p pd=2.56u as=0.56p ps=2.56u w=2u l=1u
X1024 a_36978_3547# vbn a_36688_2967# VSS nfet_03v3 ad=0.56p pd=2.56u as=0.56p ps=2.56u w=2u l=1u
X1025 a_36978_2387# vbn a_36688_2967# VSS nfet_03v3 ad=0.56p pd=2.56u as=0.56p ps=2.56u w=2u l=1u
X1026 a_36688_7607# vbn a_36978_7027# VSS nfet_03v3 ad=0.56p pd=2.56u as=0.56p ps=2.56u w=2u l=1u
X1027 a_41364_1807# vbn a_41654_2387# VSS nfet_03v3 ad=0.56p pd=2.56u as=0.56p ps=2.56u w=2u l=1u
X1028 a_36666_9481# vbn a_36978_8187# VSS nfet_03v3 ad=0.56p pd=2.56u as=0.56p ps=2.56u w=2u l=1u
X1029 VSS vbnf VSS VSS nfet_03v3 ad=13.7592p pd=49.7u as=0 ps=0 w=49.14u l=10u
X1030 a_36978_3547# vbn a_36688_4127# VSS nfet_03v3 ad=0.56p pd=2.56u as=0.56p ps=2.56u w=2u l=1u
X1031 a_36688_4127# vbn a_36978_4707# VSS nfet_03v3 ad=0.56p pd=2.56u as=0.56p ps=2.56u w=2u l=1u
X1032 VSS vbnf VSS VSS nfet_03v3 ad=22.113p pd=99.18u as=0 ps=0 w=49.14u l=10u
X1033 a_36688_6447# vbn a_36978_5867# VSS nfet_03v3 ad=0.9p pd=4.9u as=0.56p ps=2.56u w=2u l=1u
X1034 VDD_LS a_n7601_6703# a_n8217_6703# VDD_LS pfet_03v3 ad=0.675p pd=3.9u as=1.5p ps=5u w=1.5u l=0.28u
X1035 VSS vg VSS VSS nfet_03v3 ad=8.5988p pd=31.27u as=0 ps=0 w=30.71u l=4u
X1036 a_36978_3547# vbn a_36688_2967# VSS nfet_03v3 ad=0.56p pd=2.56u as=0.56p ps=2.56u w=2u l=1u
X1037 a_36978_7027# vbn a_36688_6447# VSS nfet_03v3 ad=0.56p pd=2.56u as=0.56p ps=2.56u w=2u l=1u
X1038 a_41654_2387# vbn a_41364_1807# VSS nfet_03v3 ad=0.56p pd=2.56u as=0.9p ps=4.9u w=2u l=1u
X1039 a_36978_5867# vbn a_36688_6447# VSS nfet_03v3 ad=0.56p pd=2.56u as=0.56p ps=2.56u w=2u l=1u
X1040 a_36978_1227# vbn w_36626_300# VSS nfet_03v3 ad=0.56p pd=2.56u as=0.56p ps=2.56u w=2u l=1u
X1041 a_36688_1807# vbn a_36978_1227# VSS nfet_03v3 ad=0.9p pd=4.9u as=0.56p ps=2.56u w=2u l=1u
X1042 a_36688_4127# vbn a_36978_3547# VSS nfet_03v3 ad=0.56p pd=2.56u as=0.56p ps=2.56u w=2u l=1u
X1043 a_36978_8187# vbn a_36688_7607# VSS nfet_03v3 ad=0.56p pd=2.56u as=0.56p ps=2.56u w=2u l=1u
X1044 a_36978_2387# vbn a_36688_2967# VSS nfet_03v3 ad=0.56p pd=2.56u as=0.56p ps=2.56u w=2u l=1u
X1045 a_36978_4707# vbn a_36688_4127# VSS nfet_03v3 ad=0.56p pd=2.56u as=0.56p ps=2.56u w=2u l=1u
X1046 w_36626_300# vbn a_36978_1227# VSS nfet_03v3 ad=0.56p pd=2.56u as=0.56p ps=2.56u w=2u l=1u
X1047 a_41654_2387# vbn a_41364_1807# VSS nfet_03v3 ad=0.56p pd=2.56u as=0.56p ps=2.56u w=2u l=1u
X1048 a_36666_9481# vbn a_36978_8187# VSS nfet_03v3 ad=0.56p pd=2.56u as=0.56p ps=2.56u w=2u l=1u
X1049 a_36978_3547# vbn a_36688_4127# VSS nfet_03v3 ad=0.56p pd=2.56u as=0.56p ps=2.56u w=2u l=1u
X1050 a_36978_7027# vbn a_36688_6447# VSS nfet_03v3 ad=0.56p pd=2.56u as=0.56p ps=2.56u w=2u l=1u
X1051 a_36978_5867# vbn a_36688_6447# VSS nfet_03v3 ad=0.56p pd=2.56u as=0.56p ps=2.56u w=2u l=1u
X1052 a_36688_2967# vbn a_36978_3547# VSS nfet_03v3 ad=0.56p pd=2.56u as=0.56p ps=2.56u w=2u l=1u
X1053 a_36688_7607# vbn a_36978_8187# VSS nfet_03v3 ad=0.56p pd=2.56u as=0.56p ps=2.56u w=2u l=1u
X1054 a_36978_7027# vbn a_36688_7607# VSS nfet_03v3 ad=0.56p pd=2.56u as=0.56p ps=2.56u w=2u l=1u
X1055 a_36688_5287# vbn a_36978_5867# VSS nfet_03v3 ad=0.9p pd=4.9u as=0.56p ps=2.56u w=2u l=1u
X1056 a_36978_4707# vbn a_36688_5287# VSS nfet_03v3 ad=0.56p pd=2.56u as=0.56p ps=2.56u w=2u l=1u
X1057 a_36688_4127# vbn a_36978_4707# VSS nfet_03v3 ad=0.56p pd=2.56u as=0.56p ps=2.56u w=2u l=1u
X1058 a_41654_3547# vbn a_41364_2967# VSS nfet_03v3 ad=0.9p pd=4.9u as=0.56p ps=2.56u w=2u l=1u
X1059 a_36978_8187# vbn a_36666_9481# VSS nfet_03v3 ad=0.56p pd=2.56u as=0.56p ps=2.56u w=2u l=1u
X1060 a_36688_4127# vbn a_36978_3547# VSS nfet_03v3 ad=0.56p pd=2.56u as=0.56p ps=2.56u w=2u l=1u
X1061 a_36978_1227# vbn a_36688_1807# VSS nfet_03v3 ad=0.56p pd=2.56u as=0.56p ps=2.56u w=2u l=1u
X1062 a_36688_5287# vbn a_36978_4707# VSS nfet_03v3 ad=0.56p pd=2.56u as=0.56p ps=2.56u w=2u l=1u
X1063 a_36978_8187# vbn a_36688_7607# VSS nfet_03v3 ad=0.56p pd=2.56u as=0.56p ps=2.56u w=2u l=1u
X1064 a_36688_4127# vbn a_36978_4707# VSS nfet_03v3 ad=0.56p pd=2.56u as=0.56p ps=2.56u w=2u l=1u
X1065 a_36688_1807# vbn a_36978_1227# VSS nfet_03v3 ad=0.9p pd=4.9u as=0.56p ps=2.56u w=2u l=1u
X1066 a_41654_2387# vbn a_41364_2967# VSS nfet_03v3 ad=0.56p pd=2.56u as=0.56p ps=2.56u w=2u l=1u
X1067 w_36626_300# vbn a_36978_1227# VSS nfet_03v3 ad=0.56p pd=2.56u as=0.56p ps=2.56u w=2u l=1u
X1068 a_36978_7027# vbn a_36688_7607# VSS nfet_03v3 ad=0.56p pd=2.56u as=0.56p ps=2.56u w=2u l=1u
X1069 a_36688_6447# vbn a_36978_7027# VSS nfet_03v3 ad=0.56p pd=2.56u as=0.56p ps=2.56u w=2u l=1u
X1070 a_36688_4127# vbn a_36978_4707# VSS nfet_03v3 ad=0.56p pd=2.56u as=0.56p ps=2.56u w=2u l=1u
X1071 a_36666_9481# vbn a_36978_8187# VSS nfet_03v3 ad=0.56p pd=2.56u as=0.56p ps=2.56u w=2u l=1u
X1072 a_41654_7027# vbn a_41364_6447# VSS nfet_03v3 ad=0.9p pd=4.9u as=0.56p ps=2.56u w=2u l=1u
X1073 a_36978_4707# vbn a_36688_4127# VSS nfet_03v3 ad=0.56p pd=2.56u as=0.56p ps=2.56u w=2u l=1u
X1074 vg a_6006_4704# VSS VSS nfet_03v3 ad=0.336p pd=1.76u as=0.336p ps=1.76u w=1.2u l=5.335u
X1075 vg a_6006_14# VSS VSS nfet_03v3 ad=0.336p pd=1.76u as=0.336p ps=1.76u w=1.2u l=5.335u
X1076 a_41654_7027# vbn a_41364_7607# VSS nfet_03v3 ad=0.56p pd=2.56u as=0.56p ps=2.56u w=2u l=1u
X1077 a_36688_7607# vbn a_36978_8187# VSS nfet_03v3 ad=0.56p pd=2.56u as=0.56p ps=2.56u w=2u l=1u
X1078 a_36688_7607# vbn a_36978_7027# VSS nfet_03v3 ad=0.56p pd=2.56u as=0.56p ps=2.56u w=2u l=1u
X1079 a_36978_5867# vbn a_36688_5287# VSS nfet_03v3 ad=0.56p pd=2.56u as=0.56p ps=2.56u w=2u l=1u
X1080 a_36978_4707# vbn a_36688_4127# VSS nfet_03v3 ad=0.56p pd=2.56u as=0.9p ps=4.9u w=2u l=1u
X1081 a_41364_2967# vbn a_41654_3547# VSS nfet_03v3 ad=0.56p pd=2.56u as=0.56p ps=2.56u w=2u l=1u
X1082 a_36978_1227# vbn w_36626_300# VSS nfet_03v3 ad=0.56p pd=2.56u as=0.56p ps=2.56u w=2u l=1u
X1083 a_36666_9481# vbn a_36978_8187# VSS nfet_03v3 ad=0.56p pd=2.56u as=0.56p ps=2.56u w=2u l=1u
X1084 a_36978_1227# vbn a_36688_1807# VSS nfet_03v3 ad=0.56p pd=2.56u as=0.56p ps=2.56u w=2u l=1u
X1085 a_41654_5867# vbn a_41364_6447# VSS nfet_03v3 ad=0.56p pd=2.56u as=0.56p ps=2.56u w=2u l=1u
X1086 a_36688_5287# vbn a_36978_4707# VSS nfet_03v3 ad=0.56p pd=2.56u as=0.56p ps=2.56u w=2u l=1u
X1087 a_36688_2967# vbn a_36978_2387# VSS nfet_03v3 ad=0.56p pd=2.56u as=0.56p ps=2.56u w=2u l=1u
X1088 a_36688_5287# vbn a_36978_5867# VSS nfet_03v3 ad=0.9p pd=4.9u as=0.56p ps=2.56u w=2u l=1u
X1089 a_36666_9481# vbn a_36978_8187# VSS nfet_03v3 ad=0.56p pd=2.56u as=0.56p ps=2.56u w=2u l=1u
X1090 a_41364_2967# vbn a_41654_3547# VSS nfet_03v3 ad=0.56p pd=2.56u as=0.56p ps=2.56u w=2u l=1u
X1091 a_452_6633# a0 VDD VDD pfet_03v3 ad=2.25p pd=10.9u as=2.25p ps=10.9u w=5u l=0.28u
X1092 a_36688_7607# vbn a_36978_7027# VSS nfet_03v3 ad=0.56p pd=2.56u as=0.56p ps=2.56u w=2u l=1u
X1093 a_36978_8187# vbn a_36666_9481# VSS nfet_03v3 ad=0.56p pd=2.56u as=0.56p ps=2.56u w=2u l=1u
X1094 w_36626_300# vbn a_36978_1227# VSS nfet_03v3 ad=0.56p pd=2.56u as=0.56p ps=2.56u w=2u l=1u
X1095 a_36688_1807# vbn a_36978_2387# VSS nfet_03v3 ad=0.9p pd=4.9u as=0.56p ps=2.56u w=2u l=1u
X1096 a_36978_8187# vbn a_36666_9481# VSS nfet_03v3 ad=0.56p pd=2.56u as=0.9p ps=4.9u w=2u l=1u
X1097 a_36978_3547# vbn a_36688_4127# VSS nfet_03v3 ad=0.56p pd=2.56u as=0.56p ps=2.56u w=2u l=1u
X1098 a_36978_2387# vbn a_36688_2967# VSS nfet_03v3 ad=0.56p pd=2.56u as=0.56p ps=2.56u w=2u l=1u
X1099 a_41364_6447# vbn a_41654_7027# VSS nfet_03v3 ad=0.56p pd=2.56u as=0.56p ps=2.56u w=2u l=1u
X1100 a_36688_6447# vbn a_36978_5867# VSS nfet_03v3 ad=0.56p pd=2.56u as=0.56p ps=2.56u w=2u l=1u
X1101 a_36978_4707# vbn a_36688_5287# VSS nfet_03v3 ad=0.56p pd=2.56u as=0.56p ps=2.56u w=2u l=1u
X1102 a_36978_5867# vbn a_36688_5287# VSS nfet_03v3 ad=0.56p pd=2.56u as=0.56p ps=2.56u w=2u l=1u
X1103 VSS VDD_LS VSS VSS nfet_03v3 ad=13.7592p pd=49.7u as=0 ps=0 w=49.14u l=10u
X1104 a_36688_2967# vbn a_36978_2387# VSS nfet_03v3 ad=0.56p pd=2.56u as=0.56p ps=2.56u w=2u l=1u
X1105 a_41364_2967# vbn a_41654_3547# VSS nfet_03v3 ad=0.56p pd=2.56u as=0.56p ps=2.56u w=2u l=1u
X1106 w_36626_300# vbn a_36978_1227# VSS nfet_03v3 ad=0.56p pd=2.56u as=0.56p ps=2.56u w=2u l=1u
X1107 a_36978_1227# vbn a_36688_1807# VSS nfet_03v3 ad=0.56p pd=2.56u as=0.56p ps=2.56u w=2u l=1u
X1108 a_36978_4707# vbn a_36688_4127# VSS nfet_03v3 ad=0.56p pd=2.56u as=0.56p ps=2.56u w=2u l=1u
X1109 a_36978_2387# vbn a_36688_2967# VSS nfet_03v3 ad=0.56p pd=2.56u as=0.56p ps=2.56u w=2u l=1u
X1110 a_36688_7607# vbn a_36978_7027# VSS nfet_03v3 ad=0.56p pd=2.56u as=0.56p ps=2.56u w=2u l=1u
C0 VDD bit2 0.39961f
C1 a_41654_4707# a_36978_4707# 4.03621f
C2 a_n4810_7514# VDD_LS 0.23085f
C3 vbn a_36978_1227# 12.5272f
C4 a_41654_5867# a_36978_7027# 0.00115f
C5 VDD a_452_6633# 1.2f
C6 vbn a_41364_2967# 3.48625f
C7 a_41364_7607# a_36666_9481# 0
C8 vbnf bit3 0.19848f
C9 a_41654_5867# a_41654_4707# 0.05596f
C10 a_n5128_6451# a_n5549_6703# 0.07726f
C11 a_n7872_8894# ls 0.33461f
C12 a_41364_2967# a_36978_3547# 2.88648f
C13 a_n2245_6719# VDD_LS 0.33992f
C14 a_6156_6633# bitb0 0.21396f
C15 a_41654_1227# a_36688_1807# 2.91652f
C16 a_36978_5867# a_36978_4707# 0.01838f
C17 a_36688_6447# a_41654_7027# 0.03482f
C18 a_36978_8187# a_41654_8187# 4.07037f
C19 VDD a_6156_6633# 0.25281f
C20 a_36688_6447# a_41364_5287# 0.00177f
C21 VDD bitb3 0.69649f
C22 a_6006_14# bitb1 0
C23 a_36978_2387# a_36688_1807# 10.222f
C24 a_n3101_6703# a_n5234_7514# 0
C25 VDD_LS ck 0.92368f
C26 bitb0 bit0 0.79928f
C27 a_41364_4127# a_36978_4707# 2.88648f
C28 a_36978_8187# a_60350_8387# 0.0117f
C29 a_n2245_6719# a_n3607_6703# 0.00588f
C30 a_6006_896# bitb1 0
C31 a_41654_5867# a_36978_5867# 4.03621f
C32 VDD bit0 0.40892f
C33 a_41364_7607# a_41654_7027# 2.37431f
C34 a0 a_n7872_8894# 0.00459f
C35 a_996_6587# a0 0.1634f
C36 vbn a_36666_9481# 53.2906f
C37 a_36978_2387# a_36688_4127# 0
C38 VDD a0 1.58578f
C39 a_n8217_6703# a_n6694_7514# 0
C40 a_41654_7027# a_41364_6447# 2.37452f
C41 vbn vctrl 1.86478f
C42 a_41364_6447# a_41364_5287# 0.05596f
C43 a_36978_2387# a_36688_2967# 10.9859f
C44 q1 VDD_LS 0.47949f
C45 a_n3101_6703# a_n7872_8894# 0.00642f
C46 a_n6436_6531# q1 0.00604f
C47 a_6006_14# bit2 0
C48 a_36688_6447# a_41364_6447# 4.1149f
C49 vbnf bitb0 0.0727f
C50 a_n8217_6703# a_n7286_7514# 0.00738f
C51 VDD vbnf 5.31387f
C52 a_n6862_7514# a_n6694_7514# 0.08507f
C53 w_36626_300# w_37791_300# 0.09601f
C54 a_6006_896# bit2 0.01215f
C55 VDD a_36978_8187# 0.00193f
C56 a_41654_3547# a_36688_4127# 2.91652f
C57 a_n7286_7514# a_n6862_7514# 0.00388f
C58 a_36978_3547# vctrl 0.01256f
C59 a_n4642_7514# VDD_LS 0.26831f
C60 a_1632_6633# a_452_6633# 0.1528f
C61 a_36688_1807# a_36978_1227# 10.9861f
C62 a_41654_3547# a_36688_2967# 0.03482f
C63 a_41364_1807# a_41654_1227# 2.37431f
C64 a_452_6633# VDD_LS 0
C65 VDD bit3 0.39972f
C66 a_41364_7607# a_41364_6447# 0.05596f
C67 vbn a_41654_7027# 3.49334f
C68 VDD a_41654_8187# 0.00481f
C69 a_6896_6633# vg 3.92746f
C70 vbn a_41364_5287# 3.48625f
C71 a_n5234_7514# a_n7601_6703# 0
C72 a_6156_6633# a_6006_14# 0.21414f
C73 a_41654_2387# a_41654_1227# 0.05596f
C74 vbn a_36688_6447# 13.2616f
C75 a_41364_1807# a_36978_2387# 0.72603f
C76 a_n4384_6451# a_n5549_6703# 0.0061f
C77 a_6006_14# bitb3 0
C78 a_n5234_7514# a_n7872_8894# 0
C79 a_n4642_7514# a_n3607_6703# 0.08987f
C80 a_36688_4127# a_41364_2967# 0.00177f
C81 a_6156_6633# a_6006_896# 3.25671f
C82 a_6896_6633# bitb2 0.00121f
C83 a_6006_4704# vg 2.53379f
C84 VDD a_60350_8387# 0.05007f
C85 a_36978_2387# a_41654_2387# 3.97376f
C86 VDD_LS ls 1.22951f
C87 a_6006_896# bitb3 0.21489f
C88 a_996_6587# a_1867_7085# 0.34397f
C89 a_41364_2967# a_36688_2967# 4.1149f
C90 a_6006_14# bit0 0
C91 VDD a_1867_7085# 1.30092f
C92 a_n7601_6703# a_n7872_8894# 0.00167f
C93 vbn a_41364_7607# 3.54873f
C94 a_6006_4704# bitb2 0.21396f
C95 a_6006_896# bit0 0.00331f
C96 a_6896_6633# vctrl 0.04912f
C97 a_n7180_6531# a_n7286_7514# 0.00757f
C98 vbn a_41364_6447# 3.48625f
C99 a_41654_3547# a_41654_2387# 0.05596f
C100 a_n3607_6703# ls 0.96168f
C101 VDD a_n7872_8894# 0.02233f
C102 VDD a_996_6587# 1.3832f
C103 a_1632_6633# a0 0.00356f
C104 vbnf a_6006_14# 9.72296f
C105 VDD bitb0 0.92265f
C106 a_6006_4704# vctrl 0.17004f
C107 VDD_LS a0 0.0349f
C108 vbnf bit4 0.71456f
C109 a_41364_1807# a_36978_1227# 0.03322f
C110 a_36688_1807# vctrl 2.4556f
C111 a_41364_1807# a_41364_2967# 0.05596f
C112 vbnf a_6006_896# 8.01765f
C113 a_n3101_6703# VDD_LS 0.28227f
C114 a_6006_14# bit3 0.00887f
C115 a_6896_6633# bit1 0.04998f
C116 bit4 bit3 0.02757f
C117 a_41364_2967# a_41654_2387# 2.37431f
C118 a_36666_9481# a_36688_7607# 0.17366f
C119 a_36688_4127# vctrl 0.00108f
C120 a_n5128_6451# ls 0.01045f
C121 a_6006_896# bit3 0.05328f
C122 a_36688_2967# vctrl 0.07604f
C123 a_6006_4704# bit1 0.00886f
C124 a_n8217_6703# ck 1.12832f
C125 bitb2 bitb1 0.01415f
C126 a_n3101_6703# a_n3607_6703# 1.04229f
C127 vbn a_36978_3547# 12.4223f
C128 a_41654_3547# a_41654_4707# 0.05596f
C129 a_n7286_7514# a_n6694_7514# 0.87554f
C130 VDD_LS a_n5234_7514# 0.51666f
C131 a_1632_6633# a_1867_7085# 0.37174f
C132 a_41654_7027# a_36688_7607# 2.91652f
C133 a_n8217_6703# q1 0.00656f
C134 a_41364_5287# a_36688_5287# 4.1149f
C135 a_452_6633# vg 0.52711f
C136 a_36688_6447# a_36688_7607# 0.18664f
C137 a_36688_6447# a_36688_5287# 0.18664f
C138 a_41364_1807# vctrl 4.74781f
C139 bitb0 a_6006_14# 0
C140 bitb2 bit2 0.79928f
C141 VDD_LS a_n7601_6703# 0.45003f
C142 a_n6436_6531# a_n7601_6703# 0.00463f
C143 q1 a_n6862_7514# 0.01095f
C144 VDD a_6006_14# 0.19338f
C145 a_1632_6633# a_996_6587# 0.37969f
C146 a_n4384_6451# a_n4642_7514# 0.00911f
C147 VDD bit4 0.46819f
C148 a_6006_896# bitb0 0
C149 a_41654_2387# vctrl 0.3277f
C150 a_n3607_6703# a_n5234_7514# 0.003f
C151 VDD_LS a_n7872_8894# 2.59119f
C152 a_996_6587# VDD_LS 0
C153 VDD a_6006_896# 0.19338f
C154 VDD a_1632_6633# 1.51352f
C155 a_n5549_6703# a_n6694_7514# 0.00175f
C156 VDD VDD_LS 0.03331f
C157 a_41364_7607# a_36688_7607# 4.1149f
C158 a_6156_6633# vg 1.03727f
C159 a_41654_3547# a_41364_4127# 2.37431f
C160 bit1 bitb1 0.79928f
C161 a_n7286_7514# a_n5549_6703# 0.00223f
C162 a_36688_7607# a_41364_6447# 0.00177f
C163 a_n3607_6703# a_n7872_8894# 0
C164 bitb2 bitb3 0.01415f
C165 a_n4384_6451# ls 0.01106f
C166 a_41654_3547# a_36978_4707# 0.00115f
C167 vbn a_36688_1807# 13.1706f
C168 a_n5128_6451# a_n5234_7514# 0.01134f
C169 a_41364_2967# a_41364_4127# 0.05596f
C170 a0 vg 0.40499f
C171 a_6156_6633# vctrl 3.22782f
C172 bit2 bit1 0.02757f
C173 a_n4810_7514# a_n7286_7514# 0
C174 a_n7180_6531# q1 0.00689f
C175 a_36978_3547# a_36688_1807# 0
C176 vbn a_36688_4127# 13.2616f
C177 vbnf vg 1.36982f
C178 vbn a_36688_7607# 13.2849f
C179 vbn a_36688_5287# 13.2616f
C180 vbn a_36688_2967# 13.2571f
C181 vbnf bitb2 0.1755f
C182 a_6006_14# bit4 0.05001f
C183 a_36688_4127# a_36978_3547# 10.9862f
C184 a_41654_7027# a_36978_7027# 4.03621f
C185 a_6006_896# a_6006_14# 8.81578f
C186 a_36978_3547# a_36688_5287# 0
C187 a_6006_4704# bitb4 0
C188 a_n4384_6451# a_n3101_6703# 0
C189 a_36688_6447# a_36978_7027# 11.0476f
C190 a_36978_3547# a_36688_2967# 11.0476f
C191 a_6006_896# bit4 0.00331f
C192 a_n6694_7514# ck 0
C193 a_n4810_7514# a_n5549_6703# 0.01794f
C194 vbnf vctrl 3.18603f
C195 a_36978_8187# a_36666_9481# 9.66738f
C196 a_41364_5287# a_41654_4707# 2.37431f
C197 a_6006_4704# a_6896_6633# 3.99805f
C198 a_n7286_7514# ck 0
C199 bit0 bit1 0.02757f
C200 vbn a_41364_1807# 3.27202f
C201 a_n6436_6531# VDD_LS 0.00406f
C202 a_41364_7607# a_36978_7027# 0.03322f
C203 w_36626_300# a_41654_1227# 0.05949f
C204 a_36666_9481# a_41654_8187# 1.20914f
C205 a_1867_7085# vg 0.52938f
C206 vbn a_41654_2387# 3.49251f
C207 q1 a_n6694_7514# 0.67113f
C208 a_41364_6447# a_36978_7027# 2.88648f
C209 a_36978_2387# w_36626_300# 0.00101f
C210 a_n4384_6451# a_n5234_7514# 0.07136f
C211 q1 a_n7286_7514# 1.29375f
C212 a_41364_5287# a_36978_5867# 2.88648f
C213 vbnf bit1 0.19681f
C214 a_36666_9481# a_60350_8387# 0.14595f
C215 a_n3607_6703# VDD_LS 0.39275f
C216 a_36688_6447# a_36978_5867# 10.9862f
C217 a_996_6587# vg 0.45933f
C218 a_36978_8187# a_41654_7027# 0.00115f
C219 a_36978_3547# a_41654_2387# 0.00115f
C220 a_n4642_7514# a_n6694_7514# 0.00248f
C221 VDD vg 0.42199f
C222 a_36688_6447# a_36978_8187# 0
C223 vbn w_37791_300# 0.00346f
C224 a_n8217_6703# a_n7601_6703# 0.7483f
C225 a_41364_5287# a_41364_4127# 0.05596f
C226 a_41654_7027# a_41654_8187# 0.05596f
C227 VDD bitb2 0.69643f
C228 a_n8217_6703# a_n7872_8894# 0
C229 a_36688_2967# a_36688_1807# 0.17041f
C230 vbn a_36978_7027# 12.4252f
C231 a_n6862_7514# a_n7601_6703# 0.01101f
C232 a_n5128_6451# VDD_LS 0.00198f
C233 a_6896_6633# bitb1 0.21396f
C234 q1 a_n5549_6703# 0.74328f
C235 a_41364_5287# a_36978_4707# 0.03322f
C236 a_n6862_7514# a_n7872_8894# 0
C237 a_41364_7607# a_36978_8187# 2.88648f
C238 VDD a_36666_9481# 28.8396f
C239 a_41364_6447# a_36978_5867# 0.03322f
C240 a_n6694_7514# ls 0
C241 a_36688_6447# a_36978_4707# 0
C242 w_36626_300# a_36978_1227# 12.307f
C243 vbn a_41654_4707# 3.49251f
C244 a_36688_4127# a_36688_5287# 0.18664f
C245 a_36688_4127# a_36688_2967# 0.18664f
C246 a_36978_2387# a_41654_1227# 0
C247 a_6006_4704# bitb1 0
C248 a_n4642_7514# a_n5549_6703# 0.70987f
C249 a_41364_7607# a_41654_8187# 2.37452f
C250 a_41654_5867# a_41654_7027# 0.05596f
C251 a_41654_5867# a_41364_5287# 2.37452f
C252 a_41654_5867# a_36688_6447# 2.91652f
C253 a_41364_1807# a_36688_1807# 4.00658f
C254 vbn a_36978_5867# 12.4223f
C255 vbn vbnf 0.01083f
C256 a_41654_2387# a_36688_1807# 0.0269f
C257 VDD bit1 0.39958f
C258 a_6006_4704# bit2 0.04998f
C259 vbn a_36978_8187# 12.6636f
C260 a_n7180_6531# a_n7601_6703# 0.04749f
C261 a_6006_14# vg 5.82374f
C262 a_n5549_6703# ls 1.56506f
C263 bitb4 bitb3 0.01415f
C264 a_n4642_7514# a_n4810_7514# 0.14135f
C265 vbn a_41364_4127# 3.48625f
C266 a_41364_1807# a_36688_2967# 0.00177f
C267 a_41654_1227# a_36978_1227# 4.04491f
C268 a_41654_5867# a_41364_6447# 2.37431f
C269 a_6006_896# vg 3.0381f
C270 a_1632_6633# vg 0.41376f
C271 a_6156_6633# a_6896_6633# 0.51329f
C272 a_6006_14# bitb2 0
C273 vbn a_41654_8187# 6.27374f
C274 a_41654_2387# a_36688_2967# 2.91652f
C275 a_6006_896# bitb2 0.00104f
C276 a_36978_2387# a_36978_1227# 0
C277 w_36626_300# vctrl 0.07808f
C278 vbn a_36978_4707# 12.4223f
C279 a_36978_3547# a_41364_4127# 0.03322f
C280 a_36978_2387# a_41364_2967# 0.03322f
C281 a_6006_4704# a_6156_6633# 0.20544f
C282 q1 ck 0
C283 a_6896_6633# bit0 0.00884f
C284 vctrl a_6006_14# 0.19159f
C285 vbn a_60350_8387# 0.27863f
C286 a_6006_4704# bitb3 0.00123f
C287 a_n4384_6451# VDD_LS 0.00409f
C288 a_n4810_7514# ls 0.02307f
C289 a_n8217_6703# VDD_LS 0.37512f
C290 vbnf bitb4 0.17851f
C291 a_6006_896# vctrl 0.30122f
C292 a_n6694_7514# a_n5234_7514# 0
C293 a_36978_3547# a_36978_4707# 0.01838f
C294 vbn a_41654_5867# 3.49251f
C295 a_n3101_6703# a_n5549_6703# 0
C296 VDD_LS a_n6862_7514# 0.14459f
C297 a_6006_4704# bit0 0
C298 a_41654_3547# a_41364_2967# 2.37452f
C299 a_n7286_7514# a_n5234_7514# 0.00334f
C300 a_36688_7607# a_36978_7027# 10.9862f
C301 a_36978_7027# a_36688_5287# 0
C302 a_41364_1807# a_41654_2387# 2.34764f
C303 vbnf a_6896_6633# 4.66746f
C304 bit3 bitb4 1.85602f
C305 a_n2245_6719# ls 0
C306 a_n6694_7514# a_n7601_6703# 0.70254f
C307 a_36688_4127# a_41654_4707# 0.03482f
C308 a_6006_14# bit1 0
C309 a_n7286_7514# a_n7601_6703# 0.71835f
C310 a_n6694_7514# a_n7872_8894# 0
C311 vbn VDD 0.61636f
C312 a_n4642_7514# q1 0
C313 a_41654_4707# a_36688_5287# 2.91652f
C314 a_6006_4704# vbnf 11.0435f
C315 a_6006_896# bit1 0.00331f
C316 a_41654_1227# vctrl 0.00174f
C317 a_n7286_7514# a_n7872_8894# 0
C318 a_n5549_6703# a_n5234_7514# 0.74379f
C319 a_36978_2387# vctrl 8.43974f
C320 a_6156_6633# bitb1 0.00121f
C321 a_n2245_6719# a0 1.9857f
C322 a_6006_4704# bit3 0
C323 a_36688_4127# a_36978_5867# 0
C324 a_36688_7607# a_36978_5867# 0
C325 a_36978_5867# a_36688_5287# 11.0476f
C326 q1 ls 0.00995f
C327 a_n7180_6531# VDD_LS 0.00222f
C328 a_n5549_6703# a_n7601_6703# 0.0098f
C329 a_n3101_6703# a_n2245_6719# 0.20859f
C330 bit0 bitb1 1.85602f
C331 a_36978_8187# a_36688_7607# 11.0477f
C332 a_36688_4127# a_41364_4127# 4.1149f
C333 a_n5549_6703# a_n7872_8894# 0.00156f
C334 VDD bitb4 0.69669f
C335 a_36688_5287# a_41364_4127# 0.00177f
C336 a_n4642_7514# ls 0.63671f
C337 a_n4810_7514# a_n5234_7514# 0.00509f
C338 bit2 bitb3 1.85602f
C339 a_36688_7607# a_41654_8187# 0.03482f
C340 a_6896_6633# bitb0 0
C341 a_36688_4127# a_36978_4707# 11.0476f
C342 vbn w_36626_300# 6.10627f
C343 VDD a_6896_6633# 0.19338f
C344 vbnf bitb1 0.1755f
C345 vctrl a_36978_1227# 0.06613f
C346 a_36688_5287# a_36978_4707# 10.9862f
C347 a_36688_2967# a_36978_4707# 0
C348 a_41364_2967# vctrl 0
C349 a_36688_7607# a_60350_8387# 0.01558f
C350 a_6006_4704# bitb0 0
C351 a_n4810_7514# a_n7872_8894# 0
C352 a_6006_4704# VDD 0.19338f
C353 a_41654_5867# a_36688_5287# 0.03482f
C354 a_452_6633# a0 0.60056f
C355 VDD_LS a_n6694_7514# 0.21816f
C356 a_n6436_6531# a_n6694_7514# 0.00564f
C357 vbnf bit2 0.19681f
C358 a_n4642_7514# a_n3101_6703# 0
C359 vctrl vg 1.00676f
C360 a_n7286_7514# VDD_LS 0.40251f
C361 a_n2245_6719# a_n7872_8894# 0.22692f
C362 a_6156_6633# bit0 0.04998f
C363 a_n6436_6531# a_n7286_7514# 0.04322f
C364 vbn a_41654_1227# 3.47973f
C365 bit3 bit2 0.02757f
C366 a_n7601_6703# ck 0.00938f
C367 a_6006_14# bitb4 0.21399f
C368 q1 a_n5234_7514# 0.00721f
C369 a_36978_7027# a_36978_5867# 0.01838f
C370 a_n7872_8894# ck 0
C371 bit4 bitb4 0.79928f
C372 vbn a_36978_2387# 11.9387f
C373 a_6156_6633# vbnf 1.13433f
C374 a_6006_896# bitb4 0.00214f
C375 a_n3101_6703# ls 0.12117f
C376 a_36978_8187# a_36978_7027# 0.01838f
C377 vbnf bitb3 0.17647f
C378 vg bit1 0
C379 a_6896_6633# a_6006_14# 1.30715f
C380 bitb0 bitb1 0.01415f
C381 a_36978_5867# a_41654_4707# 0.00115f
C382 q1 a_n7601_6703# 1.57175f
C383 a_n4642_7514# a_n5234_7514# 0.88042f
C384 VDD_LS a_n5549_6703# 0.58961f
C385 VDD bitb1 0.69643f
C386 a_36978_2387# a_36978_3547# 0.01838f
C387 a_6896_6633# a_6006_896# 0.6087f
C388 bitb2 bit1 1.85602f
C389 q1 a_n7872_8894# 0.00168f
C390 vbnf bit0 0.19018f
C391 w_36626_300# a_36688_1807# 0.1968f
C392 vbn a_41654_3547# 3.49251f
C393 bit3 bitb3 0.79928f
C394 a_452_6633# a_1867_7085# 0.02066f
C395 a_6006_4704# a_6006_14# 7.70065f
C396 a_41654_4707# a_41364_4127# 2.37452f
C397 a_6006_4704# bit4 0
C398 a_6006_4704# a_6006_896# 4.47742f
C399 a_n3607_6703# a_n5549_6703# 0.02485f
C400 a_41654_3547# a_36978_3547# 4.03621f
C401 a_996_6587# a_452_6633# 0.39821f
C402 a_n5234_7514# ls 1.35416f
C403 vctrl VSS 18.5068f
C404 vg VSS 33.02f
C405 bit4 VSS 1.23217f
C406 bit3 VSS 0.58471f
C407 bit2 VSS 0.58471f
C408 bit1 VSS 0.58508f
C409 bit0 VSS 0.60511f
C410 bitb4 VSS 0.64743f
C411 bitb3 VSS 0.63156f
C412 bitb2 VSS 0.63112f
C413 bitb1 VSS 0.63112f
C414 bitb0 VSS 1.34619f
C415 a0 VSS 1.04806f
C416 ck VSS 2.66052f
C417 ls VSS 2.96798f
C418 vbn VSS 0.18984p
C419 VDD_LS VSS 72.7694f
C420 VDD VSS 0.33528p
C421 a_41654_1227# VSS 3.93442f
C422 a_41364_1807# VSS 1.69719f
C423 a_41654_2387# VSS 1.65655f
C424 a_41364_2967# VSS 1.65198f
C425 a_41654_3547# VSS 1.65655f
C426 a_41364_4127# VSS 1.65198f
C427 a_41654_4707# VSS 1.65655f
C428 a_41364_5287# VSS 1.65198f
C429 a_41654_5867# VSS 1.65655f
C430 a_41364_6447# VSS 1.65198f
C431 a_41654_7027# VSS 1.65655f
C432 a_41364_7607# VSS 1.65198f
C433 a_41654_8187# VSS 2.25067f
C434 a_36978_1227# VSS 1.91496f
C435 a_36688_1807# VSS 3.9691f
C436 a_36978_2387# VSS 1.31364f
C437 a_36688_2967# VSS 3.9634f
C438 a_36978_3547# VSS 1.34623f
C439 a_36688_4127# VSS 3.96359f
C440 a_36978_4707# VSS 1.34623f
C441 a_36688_5287# VSS 3.96359f
C442 a_36978_5867# VSS 1.34623f
C443 a_36688_6447# VSS 3.96359f
C444 a_36978_7027# VSS 1.34623f
C445 a_36688_7607# VSS 3.95929f
C446 a_36978_8187# VSS 1.67149f
C447 a_60350_8387# VSS 0.65251f
C448 a_6006_14# VSS 24.4863f
C449 a_6006_896# VSS 15.2643f
C450 a_6006_4704# VSS 7.95248f
C451 a_6896_6633# VSS 3.8085f
C452 a_6156_6633# VSS 2.5291f
C453 a_1632_6633# VSS 0.27347f
C454 a_1867_7085# VSS 0.42674f
C455 a_452_6633# VSS 0.36118f
C456 a_996_6587# VSS 0.28482f
C457 a_n4384_6451# VSS 0.14599f
C458 a_n5128_6451# VSS 0.14869f
C459 a_n6436_6531# VSS 0.09609f
C460 a_n7180_6531# VSS 0.09795f
C461 a_n2245_6719# VSS 1.45122f
C462 a_n3101_6703# VSS 0.65272f
C463 a_n4642_7514# VSS 0.56414f
C464 a_n4810_7514# VSS 0.01195f
C465 a_n6694_7514# VSS 0.47458f
C466 a_n6862_7514# VSS 0.01275f
C467 a_n7286_7514# VSS 0.51067f
C468 q1 VSS 0.88857f
C469 a_n7601_6703# VSS 1.00618f
C470 a_n5234_7514# VSS 0.52691f
C471 a_n5549_6703# VSS 1.00806f
C472 a_n8217_6703# VSS 0.82236f
C473 a_n3607_6703# VSS 0.69051f
C474 vbnf VSS 0.11539p
C475 a_36666_9481# VSS 12.6032f
C476 a_n7872_8894# VSS 7.24156f
C477 w_37791_300# VSS 0.66986f
C478 w_36626_300# VSS 11.6672f
.ends
