* vco_top: magic R+C extraction of layout/vco_top.gds (layout/gen/pex.sh)
* extracted 2026-11-12T17:49:18+01:00 with magic 8.3.642, mode c, from vco_top.gds
.subckt vco_top VDD VDD_LS VSS vctrl bit0 bit1 bit2 bit3 bit4 bitb0 bitb1 bitb2 bitb3 bitb4 ck a0 vbn vg ls vbnf
X0 a_36888_1807# vbn a_37178_2387# VSS nfet_03v3 ad=0.9p pd=4.9u as=0.56p ps=2.56u w=2u l=1u
X1 a_37178_4707# vbn a_36888_4127# VSS nfet_03v3 ad=0.56p pd=2.56u as=0.56p ps=2.56u w=2u l=1u
X2 a_36888_7607# vbn a_37178_8187# VSS nfet_03v3 ad=0.56p pd=2.56u as=0.56p ps=2.56u w=2u l=1u
X3 vg a_6206_14# VSS VSS nfet_03v3 ad=0.336p pd=1.76u as=0.336p ps=1.76u w=1.2u l=5.335u
X4 a_37178_3547# vbn a_36888_2967# VSS nfet_03v3 ad=0.56p pd=2.56u as=0.56p ps=2.56u w=2u l=1u
X5 a_37178_8187# vbn a_36888_7607# VSS nfet_03v3 ad=0.56p pd=2.56u as=0.56p ps=2.56u w=2u l=1u
X6 a_36888_7607# vbn a_37178_7027# VSS nfet_03v3 ad=0.56p pd=2.56u as=0.56p ps=2.56u w=2u l=1u
X7 a_41564_2967# vbn a_41854_3547# VSS nfet_03v3 ad=0.56p pd=2.56u as=0.56p ps=2.56u w=2u l=1u
X8 a_41854_5867# vbn a_41564_6447# VSS nfet_03v3 ad=0.9p pd=4.9u as=0.56p ps=2.56u w=2u l=1u
X9 a_36866_9481# vbn a_37178_8187# VSS nfet_03v3 ad=0.56p pd=2.56u as=0.56p ps=2.56u w=2u l=1u
X10 a_37178_3547# vbn a_36888_4127# VSS nfet_03v3 ad=0.56p pd=2.56u as=0.56p ps=2.56u w=2u l=1u
X11 a_37178_2387# vbn a_36888_1807# VSS nfet_03v3 ad=0.56p pd=2.56u as=0.56p ps=2.56u w=2u l=1u
X12 a_37178_4707# vbn a_36888_5287# VSS nfet_03v3 ad=0.56p pd=2.56u as=0.56p ps=2.56u w=2u l=1u
X13 a_36888_1807# vbn a_37178_1227# VSS nfet_03v3 ad=0.56p pd=2.56u as=0.56p ps=2.56u w=2u l=1u
X14 a_36888_7607# vbn a_37178_8187# VSS nfet_03v3 ad=0.56p pd=2.56u as=0.56p ps=2.56u w=2u l=1u
X15 a_6356_6633# bitb0 VSS VSS nfet_03v3 ad=0.45p pd=2.9u as=0.45p ps=2.9u w=1u l=0.28u
X16 a_41564_2967# vbn a_41854_2387# VSS nfet_03v3 ad=0.56p pd=2.56u as=0.56p ps=2.56u w=2u l=1u
X17 a_37178_1227# vbn a_36888_1807# VSS nfet_03v3 ad=0.56p pd=2.56u as=0.56p ps=2.56u w=2u l=1u
X18 a_37178_4707# vbn a_36888_4127# VSS nfet_03v3 ad=0.56p pd=2.56u as=0.56p ps=2.56u w=2u l=1u
X19 a_36888_7607# vbn a_37178_7027# VSS nfet_03v3 ad=0.56p pd=2.56u as=0.56p ps=2.56u w=2u l=1u
X20 a_37178_7027# vbn a_36888_6447# VSS nfet_03v3 ad=0.56p pd=2.56u as=0.56p ps=2.56u w=2u l=1u
X21 a_41564_6447# vbn a_41854_7027# VSS nfet_03v3 ad=0.56p pd=2.56u as=0.56p ps=2.56u w=2u l=1u
X22 a_37178_8187# vbn a_36866_9481# VSS nfet_03v3 ad=0.56p pd=2.56u as=0.56p ps=2.56u w=2u l=1u
X23 a_36888_4127# vbn a_37178_3547# VSS nfet_03v3 ad=0.56p pd=2.56u as=0.56p ps=2.56u w=2u l=1u
X24 a_36888_1807# vbn a_37178_2387# VSS nfet_03v3 ad=0.56p pd=2.56u as=0.56p ps=2.56u w=2u l=1u
X25 vg a_6206_896# VSS VSS nfet_03v3 ad=0.336p pd=1.76u as=0.336p ps=1.76u w=1.2u l=5.335u
X26 VDD a_36866_9481# a_36866_9481# VDD pfet_03v3 ad=3.92p pd=14.56u as=3.92p ps=14.56u w=14u l=14u
X27 a_36888_4127# vbn a_37178_4707# VSS nfet_03v3 ad=0.56p pd=2.56u as=0.56p ps=2.56u w=2u l=1u
X28 a_37178_8187# vbn a_36888_7607# VSS nfet_03v3 ad=0.56p pd=2.56u as=0.56p ps=2.56u w=2u l=1u
X29 a_36888_5287# vbn a_37178_5867# VSS nfet_03v3 ad=0.56p pd=2.56u as=0.56p ps=2.56u w=2u l=1u
X30 a_37178_7027# vbn a_36888_7607# VSS nfet_03v3 ad=0.56p pd=2.56u as=0.9p ps=4.9u w=2u l=1u
X31 a_41854_3547# vbn a_41564_2967# VSS nfet_03v3 ad=0.56p pd=2.56u as=0.56p ps=2.56u w=2u l=1u
X32 a_41564_6447# vbn a_41854_5867# VSS nfet_03v3 ad=0.56p pd=2.56u as=0.56p ps=2.56u w=2u l=1u
X33 w_36826_300# vbn a_37178_1227# VSS nfet_03v3 ad=0.56p pd=2.56u as=0.56p ps=2.56u w=2u l=1u
X34 a_37178_4707# vbn a_36888_4127# VSS nfet_03v3 ad=0.56p pd=2.56u as=0.56p ps=2.56u w=2u l=1u
X35 a_36888_4127# vbn a_37178_3547# VSS nfet_03v3 ad=0.56p pd=2.56u as=0.56p ps=2.56u w=2u l=1u
X36 a_36888_1807# vbn a_37178_1227# VSS nfet_03v3 ad=0.56p pd=2.56u as=0.56p ps=2.56u w=2u l=1u
X37 a_37178_5867# vbn a_36888_5287# VSS nfet_03v3 ad=0.56p pd=2.56u as=0.56p ps=2.56u w=2u l=1u
X38 a_37178_8187# vbn a_36866_9481# VSS nfet_03v3 ad=0.56p pd=2.56u as=0.56p ps=2.56u w=2u l=1u
X39 a_37178_2387# vbn a_36888_2967# VSS nfet_03v3 ad=0.56p pd=2.56u as=0.56p ps=2.56u w=2u l=1u
X40 a_36888_7607# vbn a_37178_8187# VSS nfet_03v3 ad=0.56p pd=2.56u as=0.56p ps=2.56u w=2u l=1u
X41 VSS a_n5549_6703# q1 VSS nfet_03v3 ad=0.27p pd=2.1u as=0.6p ps=3.2u w=0.6u l=0.28u
X42 a_36888_4127# vbn a_37178_4707# VSS nfet_03v3 ad=0.56p pd=2.56u as=0.56p ps=2.56u w=2u l=1u
X43 a_36866_9481# vbn a_37178_8187# VSS nfet_03v3 ad=0.56p pd=2.56u as=0.56p ps=2.56u w=2u l=1u
X44 a_37178_7027# vbn a_36888_7607# VSS nfet_03v3 ad=0.56p pd=2.56u as=0.56p ps=2.56u w=2u l=1u
X45 a_36888_4127# vbn a_37178_3547# VSS nfet_03v3 ad=0.56p pd=2.56u as=0.56p ps=2.56u w=2u l=1u
X46 a_41854_7027# vbn a_41564_6447# VSS nfet_03v3 ad=0.56p pd=2.56u as=0.56p ps=2.56u w=2u l=1u
X47 a_37178_1227# vbn w_36826_300# VSS nfet_03v3 ad=0.56p pd=2.56u as=0.56p ps=2.56u w=2u l=1u
X48 a_36888_5287# vbn a_37178_4707# VSS nfet_03v3 ad=0.56p pd=2.56u as=0.56p ps=2.56u w=2u l=1u
X49 a_36888_5287# vbn a_37178_5867# VSS nfet_03v3 ad=0.56p pd=2.56u as=0.56p ps=2.56u w=2u l=1u
X50 a_36888_7607# vbn a_37178_8187# VSS nfet_03v3 ad=0.56p pd=2.56u as=0.56p ps=2.56u w=2u l=1u
X51 a_37178_8187# vbn a_36866_9481# VSS nfet_03v3 ad=0.56p pd=2.56u as=0.56p ps=2.56u w=2u l=1u
X52 VDD vg VDD VDD pfet_03v3 ad=8.3496p pd=30.38u as=0.15793n ps=0.62644m w=29.82u l=4.12u
X53 a_37178_5867# vbn a_36888_6447# VSS nfet_03v3 ad=0.56p pd=2.56u as=0.56p ps=2.56u w=2u l=1u
X54 a_36888_2967# vbn a_37178_2387# VSS nfet_03v3 ad=0.56p pd=2.56u as=0.56p ps=2.56u w=2u l=1u
X55 a_36888_4127# vbn a_37178_3547# VSS nfet_03v3 ad=0.56p pd=2.56u as=0.56p ps=2.56u w=2u l=1u
X56 a_37178_1227# vbn w_36826_300# VSS nfet_03v3 ad=0.56p pd=2.56u as=0.56p ps=2.56u w=2u l=1u
X57 a_36866_9481# vbn a_37178_8187# VSS nfet_03v3 ad=0.56p pd=2.56u as=0.56p ps=2.56u w=2u l=1u
X58 a_37178_4707# vbn a_36888_5287# VSS nfet_03v3 ad=0.56p pd=2.56u as=0.56p ps=2.56u w=2u l=1u
X59 a_36888_7607# vbn a_37178_8187# VSS nfet_03v3 ad=0.56p pd=2.56u as=0.56p ps=2.56u w=2u l=1u
X60 w_36826_300# vbn a_37178_1227# VSS nfet_03v3 ad=0.56p pd=2.56u as=0.56p ps=2.56u w=2u l=1u
X61 a_37178_3547# vbn a_36888_4127# VSS nfet_03v3 ad=0.56p pd=2.56u as=0.9p ps=4.9u w=2u l=1u
X62 a_41854_7027# vbn a_41564_7607# VSS nfet_03v3 ad=0.56p pd=2.56u as=0.56p ps=2.56u w=2u l=1u
X63 a_37178_1227# vbn a_36888_1807# VSS nfet_03v3 ad=0.56p pd=2.56u as=0.56p ps=2.56u w=2u l=1u
X64 a_36888_1807# vbn a_37178_2387# VSS nfet_03v3 ad=0.56p pd=2.56u as=0.56p ps=2.56u w=2u l=1u
X65 a_36888_6447# vbn a_37178_5867# VSS nfet_03v3 ad=0.56p pd=2.56u as=0.56p ps=2.56u w=2u l=1u
X66 a_37178_2387# vbn a_36888_2967# VSS nfet_03v3 ad=0.56p pd=2.56u as=0.56p ps=2.56u w=2u l=1u
X67 a_37178_1227# vbn w_36826_300# VSS nfet_03v3 ad=0.56p pd=2.56u as=0.56p ps=2.56u w=2u l=1u
X68 a_n4384_6451# a_n4642_7514# a_n5234_7514# VSS nfet_03v3 ad=0.28p pd=1.56u as=1p ps=4u w=1u l=0.28u
X69 a_37178_2387# vbn a_36888_1807# VSS nfet_03v3 ad=0.56p pd=2.56u as=0.56p ps=2.56u w=2u l=1u
X70 a_37178_4707# vbn a_36888_5287# VSS nfet_03v3 ad=0.56p pd=2.56u as=0.56p ps=2.56u w=2u l=1u
X71 a_37178_1227# vbn a_36888_1807# VSS nfet_03v3 ad=0.56p pd=2.56u as=0.56p ps=2.56u w=2u l=1u
X72 a_36888_7607# vbn a_37178_8187# VSS nfet_03v3 ad=0.56p pd=2.56u as=0.56p ps=2.56u w=2u l=1u
X73 a_41564_4127# vbn a_41854_4707# VSS nfet_03v3 ad=0.56p pd=2.56u as=0.56p ps=2.56u w=2u l=1u
X74 a_37178_3547# vbn a_36888_4127# VSS nfet_03v3 ad=0.56p pd=2.56u as=0.56p ps=2.56u w=2u l=1u
X75 a_37178_1227# vbn a_36888_1807# VSS nfet_03v3 ad=0.56p pd=2.56u as=0.56p ps=2.56u w=2u l=1u
X76 w_36826_300# vbn a_37178_1227# VSS nfet_03v3 ad=0.56p pd=2.56u as=0.56p ps=2.56u w=2u l=1u
X77 a_36888_5287# vbn a_37178_4707# VSS nfet_03v3 ad=0.56p pd=2.56u as=0.56p ps=2.56u w=2u l=1u
X78 a_36888_2967# vbn a_37178_3547# VSS nfet_03v3 ad=0.9p pd=4.9u as=0.56p ps=2.56u w=2u l=1u
X79 a_36888_7607# vbn a_37178_7027# VSS nfet_03v3 ad=0.56p pd=2.56u as=0.56p ps=2.56u w=2u l=1u
X80 a_37178_5867# vbn a_36888_6447# VSS nfet_03v3 ad=0.56p pd=2.56u as=0.56p ps=2.56u w=2u l=1u
X81 a_37178_5867# vbn a_36888_5287# VSS nfet_03v3 ad=0.56p pd=2.56u as=0.56p ps=2.56u w=2u l=1u
X82 a_37178_8187# vbn a_36888_7607# VSS nfet_03v3 ad=0.56p pd=2.56u as=0.9p ps=4.9u w=2u l=1u
X83 a_36888_1807# vbn a_37178_2387# VSS nfet_03v3 ad=0.56p pd=2.56u as=0.56p ps=2.56u w=2u l=1u
X84 a_41564_4127# vbn a_41854_4707# VSS nfet_03v3 ad=0.56p pd=2.56u as=0.56p ps=2.56u w=2u l=1u
X85 a_41854_1227# vbn a_41564_1807# VSS nfet_03v3 ad=0.56p pd=2.56u as=0.56p ps=2.56u w=2u l=1u
X86 a_37178_4707# vbn a_36888_5287# VSS nfet_03v3 ad=0.56p pd=2.56u as=0.56p ps=2.56u w=2u l=1u
X87 a_36888_1807# vbn a_37178_1227# VSS nfet_03v3 ad=0.56p pd=2.56u as=0.56p ps=2.56u w=2u l=1u
X88 a_37178_5867# vbn a_36888_5287# VSS nfet_03v3 ad=0.56p pd=2.56u as=0.56p ps=2.56u w=2u l=1u
X89 a_36888_2967# vbn a_37178_2387# VSS nfet_03v3 ad=0.56p pd=2.56u as=0.56p ps=2.56u w=2u l=1u
X90 vbn vbn a_41854_8187# VSS nfet_03v3 ad=0.56p pd=2.56u as=0.56p ps=2.56u w=2u l=1u
X91 a_36888_6447# vbn a_37178_7027# VSS nfet_03v3 ad=0.9p pd=4.9u as=0.56p ps=2.56u w=2u l=1u
X92 a_37178_5867# vbn a_36888_5287# VSS nfet_03v3 ad=0.56p pd=2.56u as=0.56p ps=2.56u w=2u l=1u
X93 a_36888_5287# vbn a_37178_4707# VSS nfet_03v3 ad=0.56p pd=2.56u as=0.56p ps=2.56u w=2u l=1u
X94 a_37178_7027# vbn a_36888_7607# VSS nfet_03v3 ad=0.56p pd=2.56u as=0.56p ps=2.56u w=2u l=1u
X95 a_37178_8187# vbn a_36888_7607# VSS nfet_03v3 ad=0.56p pd=2.56u as=0.56p ps=2.56u w=2u l=1u
X96 a_36888_7607# vbn a_37178_7027# VSS nfet_03v3 ad=0.56p pd=2.56u as=0.56p ps=2.56u w=2u l=1u
X97 a_41854_4707# vbn a_41564_4127# VSS nfet_03v3 ad=0.56p pd=2.56u as=0.9p ps=4.9u w=2u l=1u
X98 a_37178_3547# vbn a_36888_2967# VSS nfet_03v3 ad=0.56p pd=2.56u as=0.56p ps=2.56u w=2u l=1u
X99 a_37178_2387# vbn a_36888_2967# VSS nfet_03v3 ad=0.56p pd=2.56u as=0.56p ps=2.56u w=2u l=1u
X100 a_36888_1807# vbn a_37178_1227# VSS nfet_03v3 ad=0.56p pd=2.56u as=0.56p ps=2.56u w=2u l=1u
X101 a_41854_5867# vbn a_41564_5287# VSS nfet_03v3 ad=0.56p pd=2.56u as=0.56p ps=2.56u w=2u l=1u
X102 vbn vbn a_41854_8187# VSS nfet_03v3 ad=0.56p pd=2.56u as=0.56p ps=2.56u w=2u l=1u
X103 a_37178_7027# vbn a_36888_7607# VSS nfet_03v3 ad=0.56p pd=2.56u as=0.56p ps=2.56u w=2u l=1u
X104 a_36888_6447# vbn a_37178_5867# VSS nfet_03v3 ad=0.56p pd=2.56u as=0.56p ps=2.56u w=2u l=1u
X105 a_36888_5287# vbn a_37178_5867# VSS nfet_03v3 ad=0.56p pd=2.56u as=0.56p ps=2.56u w=2u l=1u
X106 a_41854_3547# vbn a_41564_4127# VSS nfet_03v3 ad=0.56p pd=2.56u as=0.56p ps=2.56u w=2u l=1u
X107 a_1867_7085# a_1632_6633# VDD VDD pfet_03v3 ad=2.25p pd=10.9u as=2.25p ps=10.9u w=5u l=0.28u
X108 a_36888_2967# vbn a_37178_3547# VSS nfet_03v3 ad=0.9p pd=4.9u as=0.56p ps=2.56u w=2u l=1u
X109 VSS a_n7601_6703# a_n8217_6703# VSS nfet_03v3 ad=0.27p pd=2.1u as=0.6p ps=3.2u w=0.6u l=0.28u
X110 a_36888_1807# vbn a_37178_1227# VSS nfet_03v3 ad=0.56p pd=2.56u as=0.56p ps=2.56u w=2u l=1u
X111 VSS vbn a_41854_1227# VSS nfet_03v3 ad=0.56p pd=2.56u as=0.56p ps=2.56u w=2u l=1u
X112 VDD_LS a_n5549_6703# q1 VDD_LS pfet_03v3 ad=0.675p pd=3.9u as=1.5p ps=5u w=1.5u l=0.28u
X113 a_37178_1227# vbn a_36888_1807# VSS nfet_03v3 ad=0.56p pd=2.56u as=0.9p ps=4.9u w=2u l=1u
X114 a_41854_8187# vbn vbn VSS nfet_03v3 ad=0.56p pd=2.56u as=0.9p ps=4.9u w=2u l=1u
X115 a_37178_7027# vbn a_36888_6447# VSS nfet_03v3 ad=0.56p pd=2.56u as=0.56p ps=2.56u w=2u l=1u
X116 a_37178_5867# vbn a_36888_6447# VSS nfet_03v3 ad=0.56p pd=2.56u as=0.56p ps=2.56u w=2u l=1u
X117 a_36888_5287# vbn a_37178_5867# VSS nfet_03v3 ad=0.56p pd=2.56u as=0.56p ps=2.56u w=2u l=1u
X118 a_36888_7607# vbn a_37178_7027# VSS nfet_03v3 ad=0.56p pd=2.56u as=0.56p ps=2.56u w=2u l=1u
X119 a_36866_9481# a_36866_9481# VDD VDD pfet_03v3 ad=3.92p pd=14.56u as=3.92p ps=14.56u w=14u l=14u
X120 a_36888_4127# vbn a_37178_3547# VSS nfet_03v3 ad=0.56p pd=2.56u as=0.56p ps=2.56u w=2u l=1u
X121 a_41854_8187# vbn a_41564_7607# VSS nfet_03v3 ad=0.56p pd=2.56u as=0.56p ps=2.56u w=2u l=1u
X122 a_37178_2387# vbn a_36888_1807# VSS nfet_03v3 ad=0.56p pd=2.56u as=0.56p ps=2.56u w=2u l=1u
X123 VSS vbn a_41854_1227# VSS nfet_03v3 ad=0.56p pd=2.56u as=0.56p ps=2.56u w=2u l=1u
X124 a_36888_6447# vbn a_37178_7027# VSS nfet_03v3 ad=0.9p pd=4.9u as=0.56p ps=2.56u w=2u l=1u
X125 vbnf bit2 a_6206_4704# VSS nfet_03v3 ad=0.9p pd=4.9u as=0.9p ps=4.9u w=2u l=0.28u
X126 a_37178_1227# vbn a_36888_1807# VSS nfet_03v3 ad=0.56p pd=2.56u as=0.9p ps=4.9u w=2u l=1u
X127 VDD vg VDD VDD pfet_03v3 ad=8.3496p pd=30.38u as=0 ps=0 w=29.82u l=4.12u
X128 a_37178_2387# vbn a_36888_2967# VSS nfet_03v3 ad=0.56p pd=2.56u as=0.56p ps=2.56u w=2u l=1u
X129 a_37178_2387# vbn a_36888_1807# VSS nfet_03v3 ad=0.56p pd=2.56u as=0.56p ps=2.56u w=2u l=1u
X130 a_36888_5287# vbn a_37178_5867# VSS nfet_03v3 ad=0.56p pd=2.56u as=0.56p ps=2.56u w=2u l=1u
X131 a_37178_5867# vbn a_36888_5287# VSS nfet_03v3 ad=0.56p pd=2.56u as=0.9p ps=4.9u w=2u l=1u
X132 a_41564_5287# vbn a_41854_4707# VSS nfet_03v3 ad=0.56p pd=2.56u as=0.56p ps=2.56u w=2u l=1u
X133 a_37178_3547# vbn a_36888_4127# VSS nfet_03v3 ad=0.56p pd=2.56u as=0.56p ps=2.56u w=2u l=1u
X134 VSS vbn a_60550_8387# VSS nfet_03v3 ad=0.9p pd=4.9u as=2.36p ps=6.36u w=2u l=0.28u
X135 a_37178_2387# vbn a_36888_1807# VSS nfet_03v3 ad=0.56p pd=2.56u as=0.56p ps=2.56u w=2u l=1u
X136 a_37178_1227# vbn a_36888_1807# VSS nfet_03v3 ad=0.56p pd=2.56u as=0.56p ps=2.56u w=2u l=1u
X137 a_36888_4127# vbn a_37178_3547# VSS nfet_03v3 ad=0.56p pd=2.56u as=0.56p ps=2.56u w=2u l=1u
X138 a_41854_1227# vbn VSS VSS nfet_03v3 ad=0.56p pd=2.56u as=0.9p ps=4.9u w=2u l=1u
X139 a_36888_7607# vbn a_37178_8187# VSS nfet_03v3 ad=0.56p pd=2.56u as=0.56p ps=2.56u w=2u l=1u
X140 a_36888_4127# vbn a_37178_4707# VSS nfet_03v3 ad=0.56p pd=2.56u as=0.56p ps=2.56u w=2u l=1u
X141 a_37178_7027# vbn a_36888_7607# VSS nfet_03v3 ad=0.56p pd=2.56u as=0.56p ps=2.56u w=2u l=1u
X142 a_41564_5287# vbn a_41854_4707# VSS nfet_03v3 ad=0.56p pd=2.56u as=0.56p ps=2.56u w=2u l=1u
X143 a_41854_2387# vbn a_41564_1807# VSS nfet_03v3 ad=0.56p pd=2.56u as=0.56p ps=2.56u w=2u l=1u
X144 a_41854_7027# vbn a_41564_7607# VSS nfet_03v3 ad=0.56p pd=2.56u as=0.9p ps=4.9u w=2u l=1u
X145 a_37178_1227# vbn a_36888_1807# VSS nfet_03v3 ad=0.56p pd=2.56u as=0.56p ps=2.56u w=2u l=1u
X146 a_37178_3547# vbn a_36888_4127# VSS nfet_03v3 ad=0.56p pd=2.56u as=0.56p ps=2.56u w=2u l=1u
X147 a_37178_3547# vbn a_36888_2967# VSS nfet_03v3 ad=0.56p pd=2.56u as=0.56p ps=2.56u w=2u l=1u
X148 a_36888_1807# vbn a_37178_2387# VSS nfet_03v3 ad=0.56p pd=2.56u as=0.56p ps=2.56u w=2u l=1u
X149 a_37178_5867# vbn a_36888_5287# VSS nfet_03v3 ad=0.56p pd=2.56u as=0.9p ps=4.9u w=2u l=1u
X150 a_37178_5867# vbn a_36888_6447# VSS nfet_03v3 ad=0.56p pd=2.56u as=0.56p ps=2.56u w=2u l=1u
X151 a_41564_4127# vbn a_41854_4707# VSS nfet_03v3 ad=0.56p pd=2.56u as=0.56p ps=2.56u w=2u l=1u
X152 a_37178_8187# vbn a_36888_7607# VSS nfet_03v3 ad=0.56p pd=2.56u as=0.56p ps=2.56u w=2u l=1u
X153 a_36888_7607# vbn a_37178_7027# VSS nfet_03v3 ad=0.56p pd=2.56u as=0.56p ps=2.56u w=2u l=1u
X154 a_36888_7607# vbn a_37178_8187# VSS nfet_03v3 ad=0.56p pd=2.56u as=0.56p ps=2.56u w=2u l=1u
X155 a_37178_5867# vbn a_36888_5287# VSS nfet_03v3 ad=0.56p pd=2.56u as=0.56p ps=2.56u w=2u l=1u
X156 a_41854_4707# vbn a_41564_5287# VSS nfet_03v3 ad=0.56p pd=2.56u as=0.9p ps=4.9u w=2u l=1u
X157 a_36866_9481# vbn a_37178_8187# VSS nfet_03v3 ad=0.56p pd=2.56u as=0.56p ps=2.56u w=2u l=1u
X158 a_36888_4127# vbn a_37178_3547# VSS nfet_03v3 ad=0.56p pd=2.56u as=0.56p ps=2.56u w=2u l=1u
X159 a_n4810_7514# a_n5549_6703# VDD_LS VDD_LS pfet_03v3 ad=0.56p pd=2.56u as=0.56p ps=2.56u w=2u l=0.28u
X160 a_36888_1807# vbn a_37178_2387# VSS nfet_03v3 ad=0.56p pd=2.56u as=0.56p ps=2.56u w=2u l=1u
X161 a_37178_1227# vbn a_36888_1807# VSS nfet_03v3 ad=0.56p pd=2.56u as=0.56p ps=2.56u w=2u l=1u
X162 a_37178_7027# vbn a_36888_6447# VSS nfet_03v3 ad=0.56p pd=2.56u as=0.56p ps=2.56u w=2u l=1u
X163 a_36888_4127# vbn a_37178_4707# VSS nfet_03v3 ad=0.9p pd=4.9u as=0.56p ps=2.56u w=2u l=1u
X164 a_41854_1227# vbn a_41564_1807# VSS nfet_03v3 ad=0.56p pd=2.56u as=0.56p ps=2.56u w=2u l=1u
X165 a_37178_8187# vbn a_36888_7607# VSS nfet_03v3 ad=0.56p pd=2.56u as=0.56p ps=2.56u w=2u l=1u
X166 a_37178_5867# vbn a_36888_5287# VSS nfet_03v3 ad=0.56p pd=2.56u as=0.56p ps=2.56u w=2u l=1u
X167 a_41854_2387# vbn a_41564_2967# VSS nfet_03v3 ad=0.9p pd=4.9u as=0.56p ps=2.56u w=2u l=1u
X168 a_36888_1807# vbn a_37178_1227# VSS nfet_03v3 ad=0.56p pd=2.56u as=0.56p ps=2.56u w=2u l=1u
X169 a_37178_4707# vbn a_36888_4127# VSS nfet_03v3 ad=0.56p pd=2.56u as=0.56p ps=2.56u w=2u l=1u
X170 vbn vbn a_41854_8187# VSS nfet_03v3 ad=0.56p pd=2.56u as=0.56p ps=2.56u w=2u l=1u
X171 a_36888_1807# vbn a_37178_2387# VSS nfet_03v3 ad=0.56p pd=2.56u as=0.56p ps=2.56u w=2u l=1u
X172 a_37178_7027# vbn a_36888_7607# VSS nfet_03v3 ad=0.56p pd=2.56u as=0.56p ps=2.56u w=2u l=1u
X173 a_37178_2387# vbn a_36888_1807# VSS nfet_03v3 ad=0.56p pd=2.56u as=0.9p ps=4.9u w=2u l=1u
X174 a_36888_2967# vbn a_37178_3547# VSS nfet_03v3 ad=0.56p pd=2.56u as=0.56p ps=2.56u w=2u l=1u
X175 a_996_6587# a_1867_7085# VDD VDD pfet_03v3 ad=2.25p pd=10.9u as=2.25p ps=10.9u w=5u l=0.28u
X176 a_36888_7607# vbn a_37178_8187# VSS nfet_03v3 ad=0.56p pd=2.56u as=0.56p ps=2.56u w=2u l=1u
X177 a_36866_9481# vbn a_37178_8187# VSS nfet_03v3 ad=0.9p pd=4.9u as=0.56p ps=2.56u w=2u l=1u
X178 a_37178_5867# vbn a_36888_5287# VSS nfet_03v3 ad=0.56p pd=2.56u as=0.56p ps=2.56u w=2u l=1u
X179 a_36888_1807# vbn a_37178_1227# VSS nfet_03v3 ad=0.56p pd=2.56u as=0.56p ps=2.56u w=2u l=1u
X180 a_41564_2967# vbn a_41854_2387# VSS nfet_03v3 ad=0.56p pd=2.56u as=0.56p ps=2.56u w=2u l=1u
X181 a_37178_3547# vbn a_36888_4127# VSS nfet_03v3 ad=0.56p pd=2.56u as=0.56p ps=2.56u w=2u l=1u
X182 w_36826_300# vbn a_37178_1227# VSS nfet_03v3 ad=0.56p pd=2.56u as=0.56p ps=2.56u w=2u l=1u
X183 a_41854_5867# vbn a_41564_6447# VSS nfet_03v3 ad=0.9p pd=4.9u as=0.56p ps=2.56u w=2u l=1u
X184 a_41854_5867# vbn a_41564_5287# VSS nfet_03v3 ad=0.56p pd=2.56u as=0.56p ps=2.56u w=2u l=1u
X185 a_36888_4127# vbn a_37178_4707# VSS nfet_03v3 ad=0.56p pd=2.56u as=0.56p ps=2.56u w=2u l=1u
X186 a_41854_3547# vbn a_41564_4127# VSS nfet_03v3 ad=0.56p pd=2.56u as=0.9p ps=4.9u w=2u l=1u
X187 a_37178_8187# vbn a_36866_9481# VSS nfet_03v3 ad=0.56p pd=2.56u as=0.56p ps=2.56u w=2u l=1u
X188 a_36888_5287# vbn a_37178_5867# VSS nfet_03v3 ad=0.56p pd=2.56u as=0.56p ps=2.56u w=2u l=1u
X189 a_36888_2967# vbn a_37178_3547# VSS nfet_03v3 ad=0.56p pd=2.56u as=0.56p ps=2.56u w=2u l=1u
X190 a_37178_2387# vbn a_36888_1807# VSS nfet_03v3 ad=0.56p pd=2.56u as=0.9p ps=4.9u w=2u l=1u
X191 a_37178_3547# vbn a_36888_2967# VSS nfet_03v3 ad=0.56p pd=2.56u as=0.56p ps=2.56u w=2u l=1u
X192 a_36888_6447# vbn a_37178_7027# VSS nfet_03v3 ad=0.56p pd=2.56u as=0.56p ps=2.56u w=2u l=1u
X193 VSS vbn a_41854_1227# VSS nfet_03v3 ad=0.56p pd=2.56u as=0.56p ps=2.56u w=2u l=1u
X194 a_41854_1227# vbn a_41564_1807# VSS nfet_03v3 ad=0.9p pd=4.9u as=0.56p ps=2.56u w=2u l=1u
X195 a_41564_6447# vbn a_41854_5867# VSS nfet_03v3 ad=0.56p pd=2.56u as=0.56p ps=2.56u w=2u l=1u
X196 a_36888_4127# vbn a_37178_3547# VSS nfet_03v3 ad=0.56p pd=2.56u as=0.56p ps=2.56u w=2u l=1u
X197 a_36888_2967# vbn a_37178_3547# VSS nfet_03v3 ad=0.56p pd=2.56u as=0.56p ps=2.56u w=2u l=1u
X198 a_37178_2387# vbn a_36888_1807# VSS nfet_03v3 ad=0.56p pd=2.56u as=0.56p ps=2.56u w=2u l=1u
X199 a_36866_9481# a_36866_9481# VDD VDD pfet_03v3 ad=3.92p pd=14.56u as=3.92p ps=14.56u w=14u l=14u
X200 a_36888_5287# vbn a_37178_4707# VSS nfet_03v3 ad=0.56p pd=2.56u as=0.56p ps=2.56u w=2u l=1u
X201 a_36888_5287# vbn a_37178_5867# VSS nfet_03v3 ad=0.56p pd=2.56u as=0.56p ps=2.56u w=2u l=1u
X202 a_37178_8187# vbn a_36888_7607# VSS nfet_03v3 ad=0.56p pd=2.56u as=0.56p ps=2.56u w=2u l=1u
X203 a_6206_14# bitb4 VSS VSS nfet_03v3 ad=0.45p pd=2.9u as=0.45p ps=2.9u w=1u l=0.28u
X204 w_36826_300# vbn a_37178_1227# VSS nfet_03v3 ad=0.9p pd=4.9u as=0.56p ps=2.56u w=2u l=1u
X205 a_36866_9481# vbn a_37178_8187# VSS nfet_03v3 ad=0.56p pd=2.56u as=0.56p ps=2.56u w=2u l=1u
X206 a_36888_6447# vbn a_37178_7027# VSS nfet_03v3 ad=0.56p pd=2.56u as=0.56p ps=2.56u w=2u l=1u
X207 a_41854_8187# vbn a_41564_7607# VSS nfet_03v3 ad=0.56p pd=2.56u as=0.9p ps=4.9u w=2u l=1u
X208 a_37178_2387# vbn a_36888_1807# VSS nfet_03v3 ad=0.56p pd=2.56u as=0.56p ps=2.56u w=2u l=1u
X209 a_37178_7027# vbn a_36888_6447# VSS nfet_03v3 ad=0.56p pd=2.56u as=0.56p ps=2.56u w=2u l=1u
X210 a_37178_2387# vbn a_36888_2967# VSS nfet_03v3 ad=0.56p pd=2.56u as=0.56p ps=2.56u w=2u l=1u
X211 a_36888_7607# vbn a_37178_7027# VSS nfet_03v3 ad=0.56p pd=2.56u as=0.56p ps=2.56u w=2u l=1u
X212 a_41564_2967# vbn a_41854_2387# VSS nfet_03v3 ad=0.56p pd=2.56u as=0.56p ps=2.56u w=2u l=1u
X213 a_41564_5287# vbn a_41854_4707# VSS nfet_03v3 ad=0.56p pd=2.56u as=0.56p ps=2.56u w=2u l=1u
X214 a_41854_5867# vbn a_41564_5287# VSS nfet_03v3 ad=0.9p pd=4.9u as=0.56p ps=2.56u w=2u l=1u
X215 a_37178_1227# vbn w_36826_300# VSS nfet_03v3 ad=0.56p pd=2.56u as=0.56p ps=2.56u w=2u l=1u
X216 a_37178_3547# vbn a_36888_4127# VSS nfet_03v3 ad=0.56p pd=2.56u as=0.56p ps=2.56u w=2u l=1u
X217 a_37178_3547# vbn a_36888_2967# VSS nfet_03v3 ad=0.56p pd=2.56u as=0.56p ps=2.56u w=2u l=1u
X218 a_36888_7607# vbn a_37178_8187# VSS nfet_03v3 ad=0.56p pd=2.56u as=0.56p ps=2.56u w=2u l=1u
X219 a_36888_6447# vbn a_37178_7027# VSS nfet_03v3 ad=0.56p pd=2.56u as=0.56p ps=2.56u w=2u l=1u
X220 a_41564_1807# vbn a_41854_1227# VSS nfet_03v3 ad=0.56p pd=2.56u as=0.56p ps=2.56u w=2u l=1u
X221 a_37178_2387# vbn a_36888_1807# VSS nfet_03v3 ad=0.56p pd=2.56u as=0.56p ps=2.56u w=2u l=1u
X222 a_36888_5287# vbn a_37178_4707# VSS nfet_03v3 ad=0.9p pd=4.9u as=0.56p ps=2.56u w=2u l=1u
X223 a_41854_2387# vbn a_41564_1807# VSS nfet_03v3 ad=0.56p pd=2.56u as=0.56p ps=2.56u w=2u l=1u
X224 VSS vbnf vg VSS nfet_03v3 ad=0.336p pd=1.76u as=0.336p ps=1.76u w=1.2u l=5.335u
X225 a_37178_5867# vbn a_36888_6447# VSS nfet_03v3 ad=0.56p pd=2.56u as=0.56p ps=2.56u w=2u l=1u
X226 a_37178_7027# vbn a_36888_7607# VSS nfet_03v3 ad=0.56p pd=2.56u as=0.56p ps=2.56u w=2u l=1u
X227 a_41564_6447# vbn a_41854_5867# VSS nfet_03v3 ad=0.56p pd=2.56u as=0.56p ps=2.56u w=2u l=1u
X228 w_36826_300# vbn a_37178_1227# VSS nfet_03v3 ad=0.56p pd=2.56u as=0.56p ps=2.56u w=2u l=1u
X229 a_36888_2967# vbn a_37178_3547# VSS nfet_03v3 ad=0.56p pd=2.56u as=0.56p ps=2.56u w=2u l=1u
X230 a_37178_7027# vbn a_36888_6447# VSS nfet_03v3 ad=0.56p pd=2.56u as=0.56p ps=2.56u w=2u l=1u
X231 a_36888_1807# vbn a_37178_2387# VSS nfet_03v3 ad=0.56p pd=2.56u as=0.56p ps=2.56u w=2u l=1u
X232 a_37178_4707# vbn a_36888_5287# VSS nfet_03v3 ad=0.56p pd=2.56u as=0.56p ps=2.56u w=2u l=1u
X233 a_36888_4127# vbn a_37178_4707# VSS nfet_03v3 ad=0.56p pd=2.56u as=0.56p ps=2.56u w=2u l=1u
X234 a_37178_8187# vbn a_36888_7607# VSS nfet_03v3 ad=0.56p pd=2.56u as=0.56p ps=2.56u w=2u l=1u
X235 VSS VDD_LS VSS VSS nfet_03v3 ad=22.113p pd=99.18u as=0.49273n ps=1.93302m w=49.14u l=10u
X236 a_41854_2387# vbn a_41564_2967# VSS nfet_03v3 ad=0.56p pd=2.56u as=0.56p ps=2.56u w=2u l=1u
X237 a_41564_5287# vbn a_41854_5867# VSS nfet_03v3 ad=0.56p pd=2.56u as=0.56p ps=2.56u w=2u l=1u
X238 a_37178_4707# vbn a_36888_4127# VSS nfet_03v3 ad=0.56p pd=2.56u as=0.56p ps=2.56u w=2u l=1u
X239 a_36888_2967# vbn a_37178_3547# VSS nfet_03v3 ad=0.56p pd=2.56u as=0.56p ps=2.56u w=2u l=1u
X240 a_37178_7027# vbn a_36888_7607# VSS nfet_03v3 ad=0.56p pd=2.56u as=0.56p ps=2.56u w=2u l=1u
X241 a_36888_1807# vbn a_37178_2387# VSS nfet_03v3 ad=0.56p pd=2.56u as=0.56p ps=2.56u w=2u l=1u
X242 VDD_LS q1 a_n7286_7514# VDD_LS pfet_03v3 ad=0.336p pd=1.76u as=1.2p ps=4.4u w=1.2u l=0.28u
X243 a_37178_1227# vbn a_36888_1807# VSS nfet_03v3 ad=0.56p pd=2.56u as=0.56p ps=2.56u w=2u l=1u
X244 a_36888_5287# vbn a_37178_4707# VSS nfet_03v3 ad=0.56p pd=2.56u as=0.56p ps=2.56u w=2u l=1u
X245 a_36888_6447# vbn a_37178_7027# VSS nfet_03v3 ad=0.56p pd=2.56u as=0.56p ps=2.56u w=2u l=1u
X246 a_36888_7607# vbn a_37178_7027# VSS nfet_03v3 ad=0.56p pd=2.56u as=0.56p ps=2.56u w=2u l=1u
X247 a_n4642_7514# ls a_n4810_7514# VDD_LS pfet_03v3 ad=2p pd=6u as=0.56p ps=2.56u w=2u l=0.28u
X248 a_n4642_7514# a_n5549_6703# VSS VSS nfet_03v3 ad=1p pd=4u as=0.28p ps=1.56u w=1u l=0.28u
X249 VDD a_36866_9481# a_36866_9481# VDD pfet_03v3 ad=3.92p pd=14.56u as=3.92p ps=14.56u w=14u l=14u
X250 a_36866_9481# vbn a_37178_8187# VSS nfet_03v3 ad=0.56p pd=2.56u as=0.56p ps=2.56u w=2u l=1u
X251 a_36888_4127# vbn a_37178_3547# VSS nfet_03v3 ad=0.56p pd=2.56u as=0.56p ps=2.56u w=2u l=1u
X252 a_36888_2967# vbn a_37178_3547# VSS nfet_03v3 ad=0.56p pd=2.56u as=0.56p ps=2.56u w=2u l=1u
X253 a_41854_5867# vbn a_41564_6447# VSS nfet_03v3 ad=0.56p pd=2.56u as=0.56p ps=2.56u w=2u l=1u
X254 a_36888_4127# vbn a_37178_4707# VSS nfet_03v3 ad=0.56p pd=2.56u as=0.56p ps=2.56u w=2u l=1u
X255 a_36888_6447# vbn a_37178_7027# VSS nfet_03v3 ad=0.56p pd=2.56u as=0.56p ps=2.56u w=2u l=1u
X256 a_37178_7027# vbn a_36888_7607# VSS nfet_03v3 ad=0.56p pd=2.56u as=0.56p ps=2.56u w=2u l=1u
X257 a_41854_2387# vbn a_41564_1807# VSS nfet_03v3 ad=0.9p pd=4.9u as=0.56p ps=2.56u w=2u l=1u
X258 a_37178_8187# vbn a_36866_9481# VSS nfet_03v3 ad=0.56p pd=2.56u as=0.56p ps=2.56u w=2u l=1u
X259 a_36888_1807# vbn a_37178_1227# VSS nfet_03v3 ad=0.56p pd=2.56u as=0.56p ps=2.56u w=2u l=1u
X260 vbnf bit0 a_6356_6633# VSS nfet_03v3 ad=0.9p pd=4.9u as=0.9p ps=4.9u w=2u l=0.28u
X261 a_37178_5867# vbn a_36888_5287# VSS nfet_03v3 ad=0.56p pd=2.56u as=0.56p ps=2.56u w=2u l=1u
X262 vg a_996_6587# a0 VSS nfet_03v3 ad=0.9p pd=4.9u as=0.9p ps=4.9u w=2u l=0.28u
X263 a_36888_7607# vbn a_37178_7027# VSS nfet_03v3 ad=0.56p pd=2.56u as=0.56p ps=2.56u w=2u l=1u
X264 a_36888_2967# vbn a_37178_3547# VSS nfet_03v3 ad=0.56p pd=2.56u as=0.56p ps=2.56u w=2u l=1u
X265 a_36888_6447# vbn a_37178_7027# VSS nfet_03v3 ad=0.56p pd=2.56u as=0.56p ps=2.56u w=2u l=1u
X266 a_37178_3547# vbn a_36888_4127# VSS nfet_03v3 ad=0.56p pd=2.56u as=0.56p ps=2.56u w=2u l=1u
X267 VSS a_6206_14# vg VSS nfet_03v3 ad=0.336p pd=1.76u as=0.336p ps=1.76u w=1.2u l=5.335u
X268 a_36888_7607# vbn a_37178_8187# VSS nfet_03v3 ad=0.56p pd=2.56u as=0.56p ps=2.56u w=2u l=1u
X269 a_36866_9481# vbn a_37178_8187# VSS nfet_03v3 ad=0.56p pd=2.56u as=0.56p ps=2.56u w=2u l=1u
X270 w_36826_300# vbn a_37178_1227# VSS nfet_03v3 ad=0.56p pd=2.56u as=0.56p ps=2.56u w=2u l=1u
X271 a_37178_3547# vbn a_36888_2967# VSS nfet_03v3 ad=0.56p pd=2.56u as=0.9p ps=4.9u w=2u l=1u
X272 a_37178_1227# vbn a_36888_1807# VSS nfet_03v3 ad=0.56p pd=2.56u as=0.56p ps=2.56u w=2u l=1u
X273 VSS a_6206_14# vg VSS nfet_03v3 ad=0.336p pd=1.76u as=0.336p ps=1.76u w=1.2u l=5.335u
X274 a_41564_1807# vbn a_41854_2387# VSS nfet_03v3 ad=0.56p pd=2.56u as=0.56p ps=2.56u w=2u l=1u
X275 a_36888_5287# vbn a_37178_5867# VSS nfet_03v3 ad=0.56p pd=2.56u as=0.56p ps=2.56u w=2u l=1u
X276 a_37178_1227# vbn w_36826_300# VSS nfet_03v3 ad=0.56p pd=2.56u as=0.56p ps=2.56u w=2u l=1u
X277 a_37178_3547# vbn a_36888_4127# VSS nfet_03v3 ad=0.56p pd=2.56u as=0.56p ps=2.56u w=2u l=1u
X278 a_36888_6447# vbn a_37178_7027# VSS nfet_03v3 ad=0.56p pd=2.56u as=0.56p ps=2.56u w=2u l=1u
X279 a_37178_8187# vbn a_36888_7607# VSS nfet_03v3 ad=0.56p pd=2.56u as=0.56p ps=2.56u w=2u l=1u
X280 vbnf bitb3 a_6206_896# VDD pfet_03v3 ad=2.25p pd=10.9u as=2.25p ps=10.9u w=5u l=0.28u
X281 a_36888_4127# vbn a_37178_3547# VSS nfet_03v3 ad=0.56p pd=2.56u as=0.56p ps=2.56u w=2u l=1u
X282 a_37178_3547# vbn a_36888_2967# VSS nfet_03v3 ad=0.56p pd=2.56u as=0.56p ps=2.56u w=2u l=1u
X283 a_37178_7027# vbn a_36888_6447# VSS nfet_03v3 ad=0.56p pd=2.56u as=0.9p ps=4.9u w=2u l=1u
X284 a_36888_5287# vbn a_37178_4707# VSS nfet_03v3 ad=0.56p pd=2.56u as=0.56p ps=2.56u w=2u l=1u
X285 a_37178_4707# vbn a_36888_4127# VSS nfet_03v3 ad=0.56p pd=2.56u as=0.56p ps=2.56u w=2u l=1u
X286 a_36888_2967# vbn a_37178_2387# VSS nfet_03v3 ad=0.9p pd=4.9u as=0.56p ps=2.56u w=2u l=1u
X287 a_37178_5867# vbn a_36888_5287# VSS nfet_03v3 ad=0.56p pd=2.56u as=0.56p ps=2.56u w=2u l=1u
X288 w_36826_300# vbn a_37178_1227# VSS nfet_03v3 ad=0.56p pd=2.56u as=0.56p ps=2.56u w=2u l=1u
X289 VSS VDD_LS VSS VSS nfet_03v3 ad=13.7592p pd=49.7u as=0 ps=0 w=49.14u l=10u
X290 VSS q1 a_n6436_6531# VSS nfet_03v3 ad=0.168p pd=1.16u as=0.168p ps=1.16u w=0.6u l=0.28u
X291 a_37178_3547# vbn a_36888_4127# VSS nfet_03v3 ad=0.56p pd=2.56u as=0.56p ps=2.56u w=2u l=1u
X292 a_37178_4707# vbn a_36888_5287# VSS nfet_03v3 ad=0.56p pd=2.56u as=0.56p ps=2.56u w=2u l=1u
X293 a_37178_4707# vbn a_36888_4127# VSS nfet_03v3 ad=0.56p pd=2.56u as=0.56p ps=2.56u w=2u l=1u
X294 a_36888_1807# vbn a_37178_1227# VSS nfet_03v3 ad=0.56p pd=2.56u as=0.56p ps=2.56u w=2u l=1u
X295 a_37178_8187# vbn a_36888_7607# VSS nfet_03v3 ad=0.56p pd=2.56u as=0.56p ps=2.56u w=2u l=1u
X296 a_37178_2387# vbn a_36888_1807# VSS nfet_03v3 ad=0.56p pd=2.56u as=0.56p ps=2.56u w=2u l=1u
X297 a_41564_7607# vbn a_41854_7027# VSS nfet_03v3 ad=0.56p pd=2.56u as=0.56p ps=2.56u w=2u l=1u
X298 a_37178_4707# vbn a_36888_4127# VSS nfet_03v3 ad=0.56p pd=2.56u as=0.56p ps=2.56u w=2u l=1u
X299 a_36888_4127# vbn a_37178_3547# VSS nfet_03v3 ad=0.56p pd=2.56u as=0.56p ps=2.56u w=2u l=1u
X300 a_36888_7607# vbn a_37178_8187# VSS nfet_03v3 ad=0.56p pd=2.56u as=0.56p ps=2.56u w=2u l=1u
X301 a_36888_6447# vbn a_37178_5867# VSS nfet_03v3 ad=0.9p pd=4.9u as=0.56p ps=2.56u w=2u l=1u
X302 a_37178_7027# vbn a_36888_6447# VSS nfet_03v3 ad=0.56p pd=2.56u as=0.56p ps=2.56u w=2u l=1u
X303 a_37178_8187# vbn a_36866_9481# VSS nfet_03v3 ad=0.56p pd=2.56u as=0.56p ps=2.56u w=2u l=1u
X304 a_37178_1227# vbn a_36888_1807# VSS nfet_03v3 ad=0.56p pd=2.56u as=0.56p ps=2.56u w=2u l=1u
X305 a_41564_7607# vbn a_41854_7027# VSS nfet_03v3 ad=0.56p pd=2.56u as=0.56p ps=2.56u w=2u l=1u
X306 a_41854_4707# vbn a_41564_4127# VSS nfet_03v3 ad=0.56p pd=2.56u as=0.56p ps=2.56u w=2u l=1u
X307 a_36888_5287# vbn a_37178_4707# VSS nfet_03v3 ad=0.56p pd=2.56u as=0.56p ps=2.56u w=2u l=1u
X308 a_37178_8187# vbn a_36888_7607# VSS nfet_03v3 ad=0.56p pd=2.56u as=0.56p ps=2.56u w=2u l=1u
X309 a_36888_4127# vbn a_37178_4707# VSS nfet_03v3 ad=0.56p pd=2.56u as=0.56p ps=2.56u w=2u l=1u
X310 a_37178_2387# vbn a_36888_2967# VSS nfet_03v3 ad=0.56p pd=2.56u as=0.56p ps=2.56u w=2u l=1u
X311 VSS vctrl vg VSS nfet_03v3 ad=0.54p pd=3.3u as=0.336p ps=1.76u w=1.2u l=21.335u
X312 a_36888_5287# vbn a_37178_5867# VSS nfet_03v3 ad=0.56p pd=2.56u as=0.56p ps=2.56u w=2u l=1u
X313 a_41854_3547# vbn a_41564_2967# VSS nfet_03v3 ad=0.56p pd=2.56u as=0.56p ps=2.56u w=2u l=1u
X314 a_37178_8187# vbn a_36866_9481# VSS nfet_03v3 ad=0.56p pd=2.56u as=0.56p ps=2.56u w=2u l=1u
X315 a_36888_1807# vbn a_37178_2387# VSS nfet_03v3 ad=0.56p pd=2.56u as=0.56p ps=2.56u w=2u l=1u
X316 a_36888_2967# vbn a_37178_2387# VSS nfet_03v3 ad=0.9p pd=4.9u as=0.56p ps=2.56u w=2u l=1u
X317 a_37178_8187# vbn a_36866_9481# VSS nfet_03v3 ad=0.56p pd=2.56u as=0.56p ps=2.56u w=2u l=1u
X318 a_36888_7607# vbn a_37178_8187# VSS nfet_03v3 ad=0.56p pd=2.56u as=0.56p ps=2.56u w=2u l=1u
X319 a_41854_7027# vbn a_41564_7607# VSS nfet_03v3 ad=0.56p pd=2.56u as=0.9p ps=4.9u w=2u l=1u
X320 a_36888_4127# vbn a_37178_4707# VSS nfet_03v3 ad=0.56p pd=2.56u as=0.56p ps=2.56u w=2u l=1u
X321 a_41854_8187# vbn vbn VSS nfet_03v3 ad=0.56p pd=2.56u as=0.56p ps=2.56u w=2u l=1u
X322 a_37178_5867# vbn a_36888_6447# VSS nfet_03v3 ad=0.56p pd=2.56u as=0.56p ps=2.56u w=2u l=1u
X323 a_37178_5867# vbn a_36888_5287# VSS nfet_03v3 ad=0.56p pd=2.56u as=0.56p ps=2.56u w=2u l=1u
X324 a_37178_1227# vbn w_36826_300# VSS nfet_03v3 ad=0.56p pd=2.56u as=0.56p ps=2.56u w=2u l=1u
X325 a_36866_9481# vbn a_37178_8187# VSS nfet_03v3 ad=0.56p pd=2.56u as=0.56p ps=2.56u w=2u l=1u
X326 a_41854_7027# vbn a_41564_6447# VSS nfet_03v3 ad=0.56p pd=2.56u as=0.56p ps=2.56u w=2u l=1u
X327 a_36888_2967# vbn a_37178_3547# VSS nfet_03v3 ad=0.56p pd=2.56u as=0.56p ps=2.56u w=2u l=1u
X328 a_37178_2387# vbn a_36888_1807# VSS nfet_03v3 ad=0.56p pd=2.56u as=0.56p ps=2.56u w=2u l=1u
X329 a_36888_6447# vbn a_37178_5867# VSS nfet_03v3 ad=0.9p pd=4.9u as=0.56p ps=2.56u w=2u l=1u
X330 a_37178_1227# vbn a_36888_1807# VSS nfet_03v3 ad=0.56p pd=2.56u as=0.56p ps=2.56u w=2u l=1u
X331 a_37178_1227# vbn w_36826_300# VSS nfet_03v3 ad=0.56p pd=2.56u as=0.56p ps=2.56u w=2u l=1u
X332 a_36888_4127# vbn a_37178_4707# VSS nfet_03v3 ad=0.56p pd=2.56u as=0.56p ps=2.56u w=2u l=1u
X333 a_n3607_6703# a_n3101_6703# VDD_LS VDD_LS pfet_03v3 ad=1.5p pd=5u as=0.675p ps=3.9u w=1.5u l=0.28u
X334 a_37178_4707# vbn a_36888_4127# VSS nfet_03v3 ad=0.56p pd=2.56u as=0.9p ps=4.9u w=2u l=1u
X335 a_41564_4127# vbn a_41854_3547# VSS nfet_03v3 ad=0.56p pd=2.56u as=0.56p ps=2.56u w=2u l=1u
X336 a_37178_1227# vbn w_36826_300# VSS nfet_03v3 ad=0.56p pd=2.56u as=0.56p ps=2.56u w=2u l=1u
X337 a_36866_9481# vbn a_37178_8187# VSS nfet_03v3 ad=0.56p pd=2.56u as=0.56p ps=2.56u w=2u l=1u
X338 a_36888_6447# vbn a_37178_7027# VSS nfet_03v3 ad=0.56p pd=2.56u as=0.56p ps=2.56u w=2u l=1u
X339 a_37178_4707# vbn a_36888_5287# VSS nfet_03v3 ad=0.56p pd=2.56u as=0.56p ps=2.56u w=2u l=1u
X340 a_37178_3547# vbn a_36888_2967# VSS nfet_03v3 ad=0.56p pd=2.56u as=0.56p ps=2.56u w=2u l=1u
X341 a_36888_2967# vbn a_37178_3547# VSS nfet_03v3 ad=0.56p pd=2.56u as=0.56p ps=2.56u w=2u l=1u
X342 a_41854_1227# vbn VSS VSS nfet_03v3 ad=0.56p pd=2.56u as=0.56p ps=2.56u w=2u l=1u
X343 a_41564_4127# vbn a_41854_3547# VSS nfet_03v3 ad=0.56p pd=2.56u as=0.56p ps=2.56u w=2u l=1u
X344 w_36826_300# vbn a_37178_1227# VSS nfet_03v3 ad=0.56p pd=2.56u as=0.56p ps=2.56u w=2u l=1u
X345 a_37178_4707# vbn a_36888_4127# VSS nfet_03v3 ad=0.56p pd=2.56u as=0.9p ps=4.9u w=2u l=1u
X346 VSS vbnf VSS VSS nfet_03v3 ad=13.7592p pd=49.7u as=0 ps=0 w=49.14u l=10u
X347 a_37178_4707# vbn a_36888_5287# VSS nfet_03v3 ad=0.56p pd=2.56u as=0.56p ps=2.56u w=2u l=1u
X348 a_37178_3547# vbn a_36888_2967# VSS nfet_03v3 ad=0.56p pd=2.56u as=0.56p ps=2.56u w=2u l=1u
X349 a_37178_2387# vbn a_36888_2967# VSS nfet_03v3 ad=0.56p pd=2.56u as=0.56p ps=2.56u w=2u l=1u
X350 a_36888_1807# vbn a_37178_2387# VSS nfet_03v3 ad=0.56p pd=2.56u as=0.56p ps=2.56u w=2u l=1u
X351 a_37178_5867# vbn a_36888_5287# VSS nfet_03v3 ad=0.56p pd=2.56u as=0.56p ps=2.56u w=2u l=1u
X352 a_36866_9481# vbn a_37178_8187# VSS nfet_03v3 ad=0.56p pd=2.56u as=0.56p ps=2.56u w=2u l=1u
X353 VSS vbnf VSS VSS nfet_03v3 ad=22.113p pd=99.18u as=0 ps=0 w=49.14u l=10u
X354 a_37178_8187# vbn a_36866_9481# VSS nfet_03v3 ad=0.56p pd=2.56u as=0.9p ps=4.9u w=2u l=1u
X355 a_41564_7607# vbn a_41854_8187# VSS nfet_03v3 ad=0.56p pd=2.56u as=0.56p ps=2.56u w=2u l=1u
X356 a_37178_4707# vbn a_36888_5287# VSS nfet_03v3 ad=0.56p pd=2.56u as=0.56p ps=2.56u w=2u l=1u
X357 a_37178_7027# vbn a_36888_6447# VSS nfet_03v3 ad=0.56p pd=2.56u as=0.56p ps=2.56u w=2u l=1u
X358 a_36888_6447# vbn a_37178_7027# VSS nfet_03v3 ad=0.56p pd=2.56u as=0.56p ps=2.56u w=2u l=1u
X359 a_41854_3547# vbn a_41564_4127# VSS nfet_03v3 ad=0.56p pd=2.56u as=0.9p ps=4.9u w=2u l=1u
X360 a_37178_4707# vbn a_36888_4127# VSS nfet_03v3 ad=0.56p pd=2.56u as=0.56p ps=2.56u w=2u l=1u
X361 w_36826_300# vbn a_37178_1227# VSS nfet_03v3 ad=0.56p pd=2.56u as=0.56p ps=2.56u w=2u l=1u
X362 a_36888_7607# vbn a_37178_7027# VSS nfet_03v3 ad=0.56p pd=2.56u as=0.56p ps=2.56u w=2u l=1u
X363 a_37178_2387# vbn a_36888_1807# VSS nfet_03v3 ad=0.56p pd=2.56u as=0.56p ps=2.56u w=2u l=1u
X364 a_41564_7607# vbn a_41854_8187# VSS nfet_03v3 ad=0.56p pd=2.56u as=0.56p ps=2.56u w=2u l=1u
X365 a_41854_4707# vbn a_41564_5287# VSS nfet_03v3 ad=0.56p pd=2.56u as=0.56p ps=2.56u w=2u l=1u
X366 a_36888_2967# vbn a_37178_3547# VSS nfet_03v3 ad=0.56p pd=2.56u as=0.56p ps=2.56u w=2u l=1u
X367 a_37178_7027# vbn a_36888_6447# VSS nfet_03v3 ad=0.56p pd=2.56u as=0.56p ps=2.56u w=2u l=1u
X368 a_37178_5867# vbn a_36888_6447# VSS nfet_03v3 ad=0.56p pd=2.56u as=0.56p ps=2.56u w=2u l=1u
X369 a_36888_5287# vbn a_37178_4707# VSS nfet_03v3 ad=0.56p pd=2.56u as=0.56p ps=2.56u w=2u l=1u
X370 a_37178_4707# vbn a_36888_4127# VSS nfet_03v3 ad=0.56p pd=2.56u as=0.56p ps=2.56u w=2u l=1u
X371 a_n7601_6703# a_n7286_7514# VDD_LS VDD_LS pfet_03v3 ad=1.2p pd=4.4u as=0.54p ps=3.3u w=1.2u l=0.28u
X372 a_41854_1227# vbn a_41564_1807# VSS nfet_03v3 ad=0.9p pd=4.9u as=0.56p ps=2.56u w=2u l=1u
X373 a_37178_8187# vbn a_36866_9481# VSS nfet_03v3 ad=0.56p pd=2.56u as=0.9p ps=4.9u w=2u l=1u
X374 a_41564_7607# vbn a_41854_7027# VSS nfet_03v3 ad=0.56p pd=2.56u as=0.56p ps=2.56u w=2u l=1u
X375 a_n6694_7514# a_n7601_6703# VSS VSS nfet_03v3 ad=0.6p pd=3.2u as=0.168p ps=1.16u w=0.6u l=0.28u
X376 w_36826_300# vbn a_37178_1227# VSS nfet_03v3 ad=0.56p pd=2.56u as=0.56p ps=2.56u w=2u l=1u
X377 a_37178_1227# vbn w_36826_300# VSS nfet_03v3 ad=0.56p pd=2.56u as=0.9p ps=4.9u w=2u l=1u
X378 a_37178_8187# vbn a_36866_9481# VSS nfet_03v3 ad=0.56p pd=2.56u as=0.56p ps=2.56u w=2u l=1u
X379 a_41854_8187# vbn a_41564_7607# VSS nfet_03v3 ad=0.56p pd=2.56u as=0.9p ps=4.9u w=2u l=1u
X380 a_36888_5287# vbn a_37178_4707# VSS nfet_03v3 ad=0.56p pd=2.56u as=0.56p ps=2.56u w=2u l=1u
X381 a_36888_2967# vbn a_37178_2387# VSS nfet_03v3 ad=0.56p pd=2.56u as=0.56p ps=2.56u w=2u l=1u
X382 a_36888_6447# vbn a_37178_7027# VSS nfet_03v3 ad=0.56p pd=2.56u as=0.56p ps=2.56u w=2u l=1u
X383 a_1632_6633# a_452_6633# vg VSS nfet_03v3 ad=0.9p pd=4.9u as=0.9p ps=4.9u w=2u l=0.28u
X384 VSS vbnf VSS VSS nfet_03v3 ad=13.7592p pd=49.7u as=0 ps=0 w=49.14u l=10u
X385 a_36888_7607# vbn a_37178_7027# VSS nfet_03v3 ad=0.9p pd=4.9u as=0.56p ps=2.56u w=2u l=1u
X386 a_37178_4707# vbn a_36888_4127# VSS nfet_03v3 ad=0.56p pd=2.56u as=0.56p ps=2.56u w=2u l=1u
X387 a_41564_1807# vbn a_41854_1227# VSS nfet_03v3 ad=0.56p pd=2.56u as=0.56p ps=2.56u w=2u l=1u
X388 a_37178_8187# vbn a_36866_9481# VSS nfet_03v3 ad=0.56p pd=2.56u as=0.56p ps=2.56u w=2u l=1u
X389 a_41854_4707# vbn a_41564_4127# VSS nfet_03v3 ad=0.56p pd=2.56u as=0.56p ps=2.56u w=2u l=1u
X390 a_37178_3547# vbn a_36888_2967# VSS nfet_03v3 ad=0.56p pd=2.56u as=0.56p ps=2.56u w=2u l=1u
X391 a_41854_5867# vbn a_41564_5287# VSS nfet_03v3 ad=0.9p pd=4.9u as=0.56p ps=2.56u w=2u l=1u
X392 a_41854_3547# vbn a_41564_2967# VSS nfet_03v3 ad=0.56p pd=2.56u as=0.9p ps=4.9u w=2u l=1u
X393 a_37178_7027# vbn a_36888_7607# VSS nfet_03v3 ad=0.56p pd=2.56u as=0.56p ps=2.56u w=2u l=1u
X394 a_36888_4127# vbn a_37178_4707# VSS nfet_03v3 ad=0.56p pd=2.56u as=0.56p ps=2.56u w=2u l=1u
X395 a_37178_1227# vbn w_36826_300# VSS nfet_03v3 ad=0.56p pd=2.56u as=0.9p ps=4.9u w=2u l=1u
X396 VSS vbnf vg VSS nfet_03v3 ad=0.336p pd=1.76u as=0.336p ps=1.76u w=1.2u l=5.335u
X397 a_36888_2967# vbn a_37178_2387# VSS nfet_03v3 ad=0.56p pd=2.56u as=0.56p ps=2.56u w=2u l=1u
X398 a_37178_2387# vbn a_36888_1807# VSS nfet_03v3 ad=0.56p pd=2.56u as=0.56p ps=2.56u w=2u l=1u
X399 a_37178_2387# vbn a_36888_2967# VSS nfet_03v3 ad=0.56p pd=2.56u as=0.56p ps=2.56u w=2u l=1u
X400 a_36888_5287# vbn a_37178_4707# VSS nfet_03v3 ad=0.56p pd=2.56u as=0.56p ps=2.56u w=2u l=1u
X401 a_36888_6447# vbn a_37178_5867# VSS nfet_03v3 ad=0.56p pd=2.56u as=0.56p ps=2.56u w=2u l=1u
X402 a_37178_4707# vbn a_36888_5287# VSS nfet_03v3 ad=0.56p pd=2.56u as=0.9p ps=4.9u w=2u l=1u
X403 a_37178_1227# vbn w_36826_300# VSS nfet_03v3 ad=0.56p pd=2.56u as=0.56p ps=2.56u w=2u l=1u
X404 a_37178_8187# vbn a_36866_9481# VSS nfet_03v3 ad=0.56p pd=2.56u as=0.56p ps=2.56u w=2u l=1u
X405 a_37178_7027# vbn a_36888_6447# VSS nfet_03v3 ad=0.56p pd=2.56u as=0.56p ps=2.56u w=2u l=1u
X406 a_36888_4127# vbn a_37178_3547# VSS nfet_03v3 ad=0.56p pd=2.56u as=0.56p ps=2.56u w=2u l=1u
X407 a_36888_2967# vbn a_37178_3547# VSS nfet_03v3 ad=0.56p pd=2.56u as=0.56p ps=2.56u w=2u l=1u
X408 a_36888_2967# vbn a_37178_2387# VSS nfet_03v3 ad=0.56p pd=2.56u as=0.56p ps=2.56u w=2u l=1u
X409 a_36888_4127# vbn a_37178_4707# VSS nfet_03v3 ad=0.56p pd=2.56u as=0.56p ps=2.56u w=2u l=1u
X410 a_41854_8187# vbn vbn VSS nfet_03v3 ad=0.56p pd=2.56u as=0.56p ps=2.56u w=2u l=1u
X411 a_41564_5287# vbn a_41854_5867# VSS nfet_03v3 ad=0.56p pd=2.56u as=0.56p ps=2.56u w=2u l=1u
X412 a_41854_7027# vbn a_41564_6447# VSS nfet_03v3 ad=0.56p pd=2.56u as=0.9p ps=4.9u w=2u l=1u
X413 a_36888_7607# vbn a_37178_7027# VSS nfet_03v3 ad=0.56p pd=2.56u as=0.56p ps=2.56u w=2u l=1u
X414 a_37178_1227# vbn w_36826_300# VSS nfet_03v3 ad=0.56p pd=2.56u as=0.56p ps=2.56u w=2u l=1u
X415 a_36866_9481# vbn a_37178_8187# VSS nfet_03v3 ad=0.56p pd=2.56u as=0.56p ps=2.56u w=2u l=1u
X416 a_37178_4707# vbn a_36888_5287# VSS nfet_03v3 ad=0.56p pd=2.56u as=0.9p ps=4.9u w=2u l=1u
X417 a_36888_6447# vbn a_37178_5867# VSS nfet_03v3 ad=0.56p pd=2.56u as=0.56p ps=2.56u w=2u l=1u
X418 a_37178_1227# vbn a_36888_1807# VSS nfet_03v3 ad=0.56p pd=2.56u as=0.56p ps=2.56u w=2u l=1u
X419 a_37178_5867# vbn a_36888_6447# VSS nfet_03v3 ad=0.56p pd=2.56u as=0.56p ps=2.56u w=2u l=1u
X420 a_41564_1807# vbn a_41854_1227# VSS nfet_03v3 ad=0.56p pd=2.56u as=0.56p ps=2.56u w=2u l=1u
X421 a_41564_4127# vbn a_41854_3547# VSS nfet_03v3 ad=0.56p pd=2.56u as=0.56p ps=2.56u w=2u l=1u
X422 a_41854_4707# vbn a_41564_4127# VSS nfet_03v3 ad=0.9p pd=4.9u as=0.56p ps=2.56u w=2u l=1u
X423 VSS a_n7872_8894# VSS VSS nfet_03v3 ad=7.2p pd=32.9u as=0 ps=0 w=16u l=16u
X424 VSS a_6206_14# vg VSS nfet_03v3 ad=0.336p pd=1.76u as=0.336p ps=1.76u w=1.2u l=5.335u
X425 a_36888_6447# vbn a_37178_7027# VSS nfet_03v3 ad=0.56p pd=2.56u as=0.56p ps=2.56u w=2u l=1u
X426 a_37178_3547# vbn a_36888_2967# VSS nfet_03v3 ad=0.56p pd=2.56u as=0.56p ps=2.56u w=2u l=1u
X427 a_37178_2387# vbn a_36888_2967# VSS nfet_03v3 ad=0.56p pd=2.56u as=0.56p ps=2.56u w=2u l=1u
X428 a_36888_7607# vbn a_37178_8187# VSS nfet_03v3 ad=0.56p pd=2.56u as=0.56p ps=2.56u w=2u l=1u
X429 a_37178_4707# vbn a_36888_5287# VSS nfet_03v3 ad=0.56p pd=2.56u as=0.56p ps=2.56u w=2u l=1u
X430 a_36888_6447# vbn a_37178_5867# VSS nfet_03v3 ad=0.56p pd=2.56u as=0.56p ps=2.56u w=2u l=1u
X431 a_36866_9481# vbn a_37178_8187# VSS nfet_03v3 ad=0.56p pd=2.56u as=0.56p ps=2.56u w=2u l=1u
X432 vbn a_36866_9481# VDD VDD pfet_03v3 ad=3.92p pd=14.56u as=3.92p ps=14.56u w=14u l=14u
X433 a_36888_4127# vbn a_37178_3547# VSS nfet_03v3 ad=0.9p pd=4.9u as=0.56p ps=2.56u w=2u l=1u
X434 a_37178_1227# vbn w_36826_300# VSS nfet_03v3 ad=0.56p pd=2.56u as=0.56p ps=2.56u w=2u l=1u
X435 a_37178_4707# vbn a_36888_5287# VSS nfet_03v3 ad=0.56p pd=2.56u as=0.56p ps=2.56u w=2u l=1u
X436 a_41854_1227# vbn VSS VSS nfet_03v3 ad=0.56p pd=2.56u as=0.56p ps=2.56u w=2u l=1u
X437 a_41854_2387# vbn a_41564_1807# VSS nfet_03v3 ad=0.9p pd=4.9u as=0.56p ps=2.56u w=2u l=1u
X438 a_37178_5867# vbn a_36888_5287# VSS nfet_03v3 ad=0.56p pd=2.56u as=0.56p ps=2.56u w=2u l=1u
X439 a_37178_3547# vbn a_36888_4127# VSS nfet_03v3 ad=0.56p pd=2.56u as=0.56p ps=2.56u w=2u l=1u
X440 a_41564_5287# vbn a_41854_5867# VSS nfet_03v3 ad=0.56p pd=2.56u as=0.56p ps=2.56u w=2u l=1u
X441 w_36826_300# vbn a_37178_1227# VSS nfet_03v3 ad=0.56p pd=2.56u as=0.56p ps=2.56u w=2u l=1u
X442 a_36888_2967# vbn a_37178_2387# VSS nfet_03v3 ad=0.56p pd=2.56u as=0.56p ps=2.56u w=2u l=1u
X443 a_37178_5867# vbn a_36888_6447# VSS nfet_03v3 ad=0.56p pd=2.56u as=0.56p ps=2.56u w=2u l=1u
X444 a_37178_7027# vbn a_36888_6447# VSS nfet_03v3 ad=0.56p pd=2.56u as=0.56p ps=2.56u w=2u l=1u
X445 a_41564_7607# vbn a_41854_8187# VSS nfet_03v3 ad=0.56p pd=2.56u as=0.56p ps=2.56u w=2u l=1u
X446 a_41854_8187# vbn vbn VSS nfet_03v3 ad=0.9p pd=4.9u as=0.56p ps=2.56u w=2u l=1u
X447 a_41854_1227# vbn a_41564_1807# VSS nfet_03v3 ad=0.56p pd=2.56u as=0.56p ps=2.56u w=2u l=1u
X448 a_41564_4127# vbn a_41854_4707# VSS nfet_03v3 ad=0.56p pd=2.56u as=0.56p ps=2.56u w=2u l=1u
X449 VSS ls a_n4384_6451# VSS nfet_03v3 ad=0.28p pd=1.56u as=0.28p ps=1.56u w=1u l=0.28u
X450 a_37178_4707# vbn a_36888_5287# VSS nfet_03v3 ad=0.56p pd=2.56u as=0.56p ps=2.56u w=2u l=1u
X451 a_36888_2967# vbn a_37178_2387# VSS nfet_03v3 ad=0.56p pd=2.56u as=0.56p ps=2.56u w=2u l=1u
X452 a_36888_7607# vbn a_37178_8187# VSS nfet_03v3 ad=0.9p pd=4.9u as=0.56p ps=2.56u w=2u l=1u
X453 w_36826_300# vbn a_37178_1227# VSS nfet_03v3 ad=0.56p pd=2.56u as=0.56p ps=2.56u w=2u l=1u
X454 a_41854_4707# vbn a_41564_5287# VSS nfet_03v3 ad=0.56p pd=2.56u as=0.56p ps=2.56u w=2u l=1u
X455 a_41564_1807# vbn a_41854_2387# VSS nfet_03v3 ad=0.56p pd=2.56u as=0.56p ps=2.56u w=2u l=1u
X456 vbnf bitb2 a_6206_4704# VDD pfet_03v3 ad=2.25p pd=10.9u as=2.25p ps=10.9u w=5u l=0.28u
X457 a_36888_4127# vbn a_37178_3547# VSS nfet_03v3 ad=0.56p pd=2.56u as=0.56p ps=2.56u w=2u l=1u
X458 a_36888_5287# vbn a_37178_4707# VSS nfet_03v3 ad=0.56p pd=2.56u as=0.56p ps=2.56u w=2u l=1u
X459 a_36888_6447# vbn a_37178_5867# VSS nfet_03v3 ad=0.56p pd=2.56u as=0.56p ps=2.56u w=2u l=1u
X460 vbnf bit4 a_6206_14# VSS nfet_03v3 ad=0.9p pd=4.9u as=0.9p ps=4.9u w=2u l=0.28u
X461 a_37178_8187# vbn a_36888_7607# VSS nfet_03v3 ad=0.56p pd=2.56u as=0.56p ps=2.56u w=2u l=1u
X462 a_36888_7607# vbn a_37178_7027# VSS nfet_03v3 ad=0.56p pd=2.56u as=0.56p ps=2.56u w=2u l=1u
X463 VDD_LS ls a_n5234_7514# VDD_LS pfet_03v3 ad=0.56p pd=2.56u as=2p ps=6u w=2u l=0.28u
X464 a_36888_2967# vbn a_37178_3547# VSS nfet_03v3 ad=0.56p pd=2.56u as=0.56p ps=2.56u w=2u l=1u
X465 a_36888_2967# vbn a_37178_2387# VSS nfet_03v3 ad=0.56p pd=2.56u as=0.56p ps=2.56u w=2u l=1u
X466 a_41854_1227# vbn VSS VSS nfet_03v3 ad=0.9p pd=4.9u as=0.56p ps=2.56u w=2u l=1u
X467 a_41854_5867# vbn a_41564_5287# VSS nfet_03v3 ad=0.56p pd=2.56u as=0.56p ps=2.56u w=2u l=1u
X468 a_36888_6447# vbn a_37178_5867# VSS nfet_03v3 ad=0.56p pd=2.56u as=0.56p ps=2.56u w=2u l=1u
X469 a_37178_7027# vbn a_36888_7607# VSS nfet_03v3 ad=0.56p pd=2.56u as=0.56p ps=2.56u w=2u l=1u
X470 vbn vbn a_41854_8187# VSS nfet_03v3 ad=0.56p pd=2.56u as=0.56p ps=2.56u w=2u l=1u
X471 a_36888_5287# vbn a_37178_4707# VSS nfet_03v3 ad=0.56p pd=2.56u as=0.56p ps=2.56u w=2u l=1u
X472 a_37178_4707# vbn a_36888_4127# VSS nfet_03v3 ad=0.56p pd=2.56u as=0.56p ps=2.56u w=2u l=1u
X473 a_36888_7607# vbn a_37178_8187# VSS nfet_03v3 ad=0.56p pd=2.56u as=0.56p ps=2.56u w=2u l=1u
X474 a_36888_2967# vbn a_37178_2387# VSS nfet_03v3 ad=0.56p pd=2.56u as=0.56p ps=2.56u w=2u l=1u
X475 a_37178_2387# vbn a_36888_1807# VSS nfet_03v3 ad=0.56p pd=2.56u as=0.56p ps=2.56u w=2u l=1u
X476 a_37178_3547# vbn a_36888_2967# VSS nfet_03v3 ad=0.56p pd=2.56u as=0.56p ps=2.56u w=2u l=1u
X477 a_36888_6447# vbn a_37178_7027# VSS nfet_03v3 ad=0.56p pd=2.56u as=0.56p ps=2.56u w=2u l=1u
X478 a_36888_6447# vbn a_37178_5867# VSS nfet_03v3 ad=0.56p pd=2.56u as=0.56p ps=2.56u w=2u l=1u
X479 a_36888_7607# vbn a_37178_7027# VSS nfet_03v3 ad=0.56p pd=2.56u as=0.56p ps=2.56u w=2u l=1u
X480 a_41564_1807# vbn a_41854_2387# VSS nfet_03v3 ad=0.56p pd=2.56u as=0.56p ps=2.56u w=2u l=1u
X481 a_41854_4707# vbn a_41564_5287# VSS nfet_03v3 ad=0.9p pd=4.9u as=0.56p ps=2.56u w=2u l=1u
X482 a_36888_4127# vbn a_37178_4707# VSS nfet_03v3 ad=0.56p pd=2.56u as=0.56p ps=2.56u w=2u l=1u
X483 a_37178_2387# vbn a_36888_2967# VSS nfet_03v3 ad=0.56p pd=2.56u as=0.9p ps=4.9u w=2u l=1u
X484 VSS vbn a_41854_1227# VSS nfet_03v3 ad=0.56p pd=2.56u as=0.56p ps=2.56u w=2u l=1u
X485 w_36826_300# w_37991_300# VSS nwell r_width=2u r_length=5.025u
X486 a_n6436_6531# a_n6694_7514# a_n7286_7514# VSS nfet_03v3 ad=0.168p pd=1.16u as=0.6p ps=3.2u w=0.6u l=0.28u
X487 a_37178_8187# vbn a_36866_9481# VSS nfet_03v3 ad=0.56p pd=2.56u as=0.56p ps=2.56u w=2u l=1u
X488 a_37178_3547# vbn a_36888_2967# VSS nfet_03v3 ad=0.56p pd=2.56u as=0.56p ps=2.56u w=2u l=1u
X489 a_37178_7027# vbn a_36888_6447# VSS nfet_03v3 ad=0.56p pd=2.56u as=0.56p ps=2.56u w=2u l=1u
X490 a_36888_6447# vbn a_37178_5867# VSS nfet_03v3 ad=0.56p pd=2.56u as=0.56p ps=2.56u w=2u l=1u
X491 a_36888_1807# vbn a_37178_1227# VSS nfet_03v3 ad=0.9p pd=4.9u as=0.56p ps=2.56u w=2u l=1u
X492 a_36888_4127# vbn a_37178_3547# VSS nfet_03v3 ad=0.56p pd=2.56u as=0.56p ps=2.56u w=2u l=1u
X493 a_36888_2967# vbn a_37178_3547# VSS nfet_03v3 ad=0.56p pd=2.56u as=0.56p ps=2.56u w=2u l=1u
X494 a_37178_2387# vbn a_36888_2967# VSS nfet_03v3 ad=0.56p pd=2.56u as=0.56p ps=2.56u w=2u l=1u
X495 a_37178_5867# vbn a_36888_6447# VSS nfet_03v3 ad=0.56p pd=2.56u as=0.9p ps=4.9u w=2u l=1u
X496 a_37178_4707# vbn a_36888_4127# VSS nfet_03v3 ad=0.56p pd=2.56u as=0.56p ps=2.56u w=2u l=1u
X497 a_41854_2387# vbn a_41564_1807# VSS nfet_03v3 ad=0.56p pd=2.56u as=0.56p ps=2.56u w=2u l=1u
X498 a_41564_5287# vbn a_41854_4707# VSS nfet_03v3 ad=0.56p pd=2.56u as=0.56p ps=2.56u w=2u l=1u
X499 a_7096_6633# bitb1 VSS VSS nfet_03v3 ad=0.45p pd=2.9u as=0.45p ps=2.9u w=1u l=0.28u
X500 a_36866_9481# vbn a_37178_8187# VSS nfet_03v3 ad=0.56p pd=2.56u as=0.56p ps=2.56u w=2u l=1u
X501 a_37178_3547# vbn a_36888_4127# VSS nfet_03v3 ad=0.56p pd=2.56u as=0.56p ps=2.56u w=2u l=1u
X502 a_37178_3547# vbn a_36888_2967# VSS nfet_03v3 ad=0.56p pd=2.56u as=0.56p ps=2.56u w=2u l=1u
X503 a_37178_7027# vbn a_36888_6447# VSS nfet_03v3 ad=0.56p pd=2.56u as=0.56p ps=2.56u w=2u l=1u
X504 vg a_6206_14# VSS VSS nfet_03v3 ad=0.336p pd=1.76u as=0.336p ps=1.76u w=1.2u l=5.335u
X505 a_37178_1227# vbn w_36826_300# VSS nfet_03v3 ad=0.56p pd=2.56u as=0.56p ps=2.56u w=2u l=1u
X506 VSS vbnf VSS VSS nfet_03v3 ad=13.7592p pd=49.7u as=0 ps=0 w=49.14u l=10u
X507 a_36888_6447# vbn a_37178_7027# VSS nfet_03v3 ad=0.56p pd=2.56u as=0.56p ps=2.56u w=2u l=1u
X508 VSS a_6206_896# vg VSS nfet_03v3 ad=0.54p pd=3.3u as=0.336p ps=1.76u w=1.2u l=5.335u
X509 a_36888_2967# vbn a_37178_3547# VSS nfet_03v3 ad=0.56p pd=2.56u as=0.56p ps=2.56u w=2u l=1u
X510 a_36888_7607# vbn a_37178_8187# VSS nfet_03v3 ad=0.56p pd=2.56u as=0.56p ps=2.56u w=2u l=1u
X511 a_37178_7027# vbn a_36888_7607# VSS nfet_03v3 ad=0.56p pd=2.56u as=0.56p ps=2.56u w=2u l=1u
X512 a_36888_5287# vbn a_37178_5867# VSS nfet_03v3 ad=0.9p pd=4.9u as=0.56p ps=2.56u w=2u l=1u
X513 a_37178_5867# vbn a_36888_6447# VSS nfet_03v3 ad=0.56p pd=2.56u as=0.56p ps=2.56u w=2u l=1u
X514 a_37178_8187# vbn a_36866_9481# VSS nfet_03v3 ad=0.56p pd=2.56u as=0.56p ps=2.56u w=2u l=1u
X515 a_36888_4127# vbn a_37178_3547# VSS nfet_03v3 ad=0.56p pd=2.56u as=0.56p ps=2.56u w=2u l=1u
X516 a_37178_7027# vbn a_36888_6447# VSS nfet_03v3 ad=0.56p pd=2.56u as=0.56p ps=2.56u w=2u l=1u
X517 a_37178_1227# vbn a_36888_1807# VSS nfet_03v3 ad=0.56p pd=2.56u as=0.56p ps=2.56u w=2u l=1u
X518 a_37178_8187# vbn a_36888_7607# VSS nfet_03v3 ad=0.56p pd=2.56u as=0.56p ps=2.56u w=2u l=1u
X519 a_36888_4127# vbn a_37178_4707# VSS nfet_03v3 ad=0.56p pd=2.56u as=0.56p ps=2.56u w=2u l=1u
X520 a_37178_7027# vbn a_36888_7607# VSS nfet_03v3 ad=0.56p pd=2.56u as=0.56p ps=2.56u w=2u l=1u
X521 a_36888_1807# vbn a_37178_1227# VSS nfet_03v3 ad=0.9p pd=4.9u as=0.56p ps=2.56u w=2u l=1u
X522 a_41854_2387# vbn a_41564_2967# VSS nfet_03v3 ad=0.56p pd=2.56u as=0.56p ps=2.56u w=2u l=1u
X523 w_36826_300# vbn a_37178_1227# VSS nfet_03v3 ad=0.56p pd=2.56u as=0.56p ps=2.56u w=2u l=1u
X524 a_37178_4707# vbn a_36888_5287# VSS nfet_03v3 ad=0.56p pd=2.56u as=0.56p ps=2.56u w=2u l=1u
X525 a_37178_7027# vbn a_36888_7607# VSS nfet_03v3 ad=0.56p pd=2.56u as=0.56p ps=2.56u w=2u l=1u
X526 a_36888_6447# vbn a_37178_7027# VSS nfet_03v3 ad=0.56p pd=2.56u as=0.56p ps=2.56u w=2u l=1u
X527 vg a_6206_4704# VSS VSS nfet_03v3 ad=0.336p pd=1.76u as=0.336p ps=1.76u w=1.2u l=5.335u
X528 a_41854_7027# vbn a_41564_7607# VSS nfet_03v3 ad=0.56p pd=2.56u as=0.56p ps=2.56u w=2u l=1u
X529 a_37178_4707# vbn a_36888_4127# VSS nfet_03v3 ad=0.56p pd=2.56u as=0.56p ps=2.56u w=2u l=1u
X530 a_36888_7607# vbn a_37178_8187# VSS nfet_03v3 ad=0.56p pd=2.56u as=0.56p ps=2.56u w=2u l=1u
X531 a_36888_7607# vbn a_37178_7027# VSS nfet_03v3 ad=0.56p pd=2.56u as=0.56p ps=2.56u w=2u l=1u
X532 a_37178_5867# vbn a_36888_5287# VSS nfet_03v3 ad=0.56p pd=2.56u as=0.56p ps=2.56u w=2u l=1u
X533 a_37178_1227# vbn w_36826_300# VSS nfet_03v3 ad=0.56p pd=2.56u as=0.56p ps=2.56u w=2u l=1u
X534 a_41854_5867# vbn a_41564_6447# VSS nfet_03v3 ad=0.56p pd=2.56u as=0.56p ps=2.56u w=2u l=1u
X535 VSS vbnf VSS VSS nfet_03v3 ad=13.7592p pd=49.7u as=0 ps=0 w=49.14u l=10u
X536 a_36866_9481# vbn a_37178_8187# VSS nfet_03v3 ad=0.56p pd=2.56u as=0.56p ps=2.56u w=2u l=1u
X537 a_36888_5287# vbn a_37178_4707# VSS nfet_03v3 ad=0.56p pd=2.56u as=0.56p ps=2.56u w=2u l=1u
X538 a_36888_2967# vbn a_37178_2387# VSS nfet_03v3 ad=0.56p pd=2.56u as=0.56p ps=2.56u w=2u l=1u
X539 a_36888_5287# vbn a_37178_5867# VSS nfet_03v3 ad=0.9p pd=4.9u as=0.56p ps=2.56u w=2u l=1u
X540 a_36888_7607# vbn a_37178_7027# VSS nfet_03v3 ad=0.56p pd=2.56u as=0.56p ps=2.56u w=2u l=1u
X541 a_41564_2967# vbn a_41854_3547# VSS nfet_03v3 ad=0.56p pd=2.56u as=0.56p ps=2.56u w=2u l=1u
X542 a_37178_8187# vbn a_36866_9481# VSS nfet_03v3 ad=0.56p pd=2.56u as=0.56p ps=2.56u w=2u l=1u
X543 a_36888_1807# vbn a_37178_2387# VSS nfet_03v3 ad=0.9p pd=4.9u as=0.56p ps=2.56u w=2u l=1u
X544 a_37178_3547# vbn a_36888_4127# VSS nfet_03v3 ad=0.56p pd=2.56u as=0.56p ps=2.56u w=2u l=1u
X545 a_36888_6447# vbn a_37178_5867# VSS nfet_03v3 ad=0.56p pd=2.56u as=0.56p ps=2.56u w=2u l=1u
X546 a_37178_4707# vbn a_36888_5287# VSS nfet_03v3 ad=0.56p pd=2.56u as=0.56p ps=2.56u w=2u l=1u
X547 a_37178_2387# vbn a_36888_2967# VSS nfet_03v3 ad=0.56p pd=2.56u as=0.56p ps=2.56u w=2u l=1u
X548 VSS a_6206_14# vg VSS nfet_03v3 ad=0.54p pd=3.3u as=0.336p ps=1.76u w=1.2u l=5.335u
X549 VSS vbnf vg VSS nfet_03v3 ad=0.336p pd=1.76u as=0.336p ps=1.76u w=1.2u l=5.335u
X550 a_36888_2967# vbn a_37178_2387# VSS nfet_03v3 ad=0.56p pd=2.56u as=0.56p ps=2.56u w=2u l=1u
X551 a_41564_2967# vbn a_41854_3547# VSS nfet_03v3 ad=0.56p pd=2.56u as=0.56p ps=2.56u w=2u l=1u
X552 w_36826_300# vbn a_37178_1227# VSS nfet_03v3 ad=0.56p pd=2.56u as=0.56p ps=2.56u w=2u l=1u
X553 VSS a_6206_14# vg VSS nfet_03v3 ad=0.54p pd=3.3u as=0.336p ps=1.76u w=1.2u l=5.335u
X554 a_37178_3547# vbn a_36888_4127# VSS nfet_03v3 ad=0.56p pd=2.56u as=0.56p ps=2.56u w=2u l=1u
X555 a_37178_1227# vbn a_36888_1807# VSS nfet_03v3 ad=0.56p pd=2.56u as=0.56p ps=2.56u w=2u l=1u
X556 a_37178_2387# vbn a_36888_2967# VSS nfet_03v3 ad=0.56p pd=2.56u as=0.56p ps=2.56u w=2u l=1u
X557 a_37178_4707# vbn a_36888_4127# VSS nfet_03v3 ad=0.56p pd=2.56u as=0.56p ps=2.56u w=2u l=1u
X558 a_36888_7607# vbn a_37178_7027# VSS nfet_03v3 ad=0.56p pd=2.56u as=0.56p ps=2.56u w=2u l=1u
X559 a_37178_7027# vbn a_36888_7607# VSS nfet_03v3 ad=0.56p pd=2.56u as=0.9p ps=4.9u w=2u l=1u
X560 a_41564_6447# vbn a_41854_7027# VSS nfet_03v3 ad=0.56p pd=2.56u as=0.56p ps=2.56u w=2u l=1u
X561 a_n7872_8894# ls VSS ppolyf_u_1k r_width=1u r_length=0.15912m
X562 VDD VSS a_60550_8387# VDD pfet_03v3 ad=0.225p pd=1.9u as=0.225p ps=1.9u w=0.5u l=10u
X563 a_37178_3547# vbn a_36888_4127# VSS nfet_03v3 ad=0.56p pd=2.56u as=0.56p ps=2.56u w=2u l=1u
X564 a_37178_8187# vbn a_36888_7607# VSS nfet_03v3 ad=0.56p pd=2.56u as=0.56p ps=2.56u w=2u l=1u
X565 a_37178_5867# vbn a_36888_6447# VSS nfet_03v3 ad=0.56p pd=2.56u as=0.56p ps=2.56u w=2u l=1u
X566 a_36888_6447# vbn a_37178_5867# VSS nfet_03v3 ad=0.56p pd=2.56u as=0.56p ps=2.56u w=2u l=1u
X567 a_37178_1227# vbn w_36826_300# VSS nfet_03v3 ad=0.56p pd=2.56u as=0.56p ps=2.56u w=2u l=1u
X568 a_41564_6447# vbn a_41854_7027# VSS nfet_03v3 ad=0.56p pd=2.56u as=0.56p ps=2.56u w=2u l=1u
X569 a_41854_3547# vbn a_41564_4127# VSS nfet_03v3 ad=0.56p pd=2.56u as=0.56p ps=2.56u w=2u l=1u
X570 a_41854_3547# vbn a_41564_2967# VSS nfet_03v3 ad=0.56p pd=2.56u as=0.9p ps=4.9u w=2u l=1u
X571 a_37178_2387# vbn a_36888_1807# VSS nfet_03v3 ad=0.56p pd=2.56u as=0.56p ps=2.56u w=2u l=1u
X572 vg a_7096_6633# VSS VSS nfet_03v3 ad=0.336p pd=1.76u as=0.336p ps=1.76u w=1.2u l=5.335u
X573 a_36888_4127# vbn a_37178_3547# VSS nfet_03v3 ad=0.56p pd=2.56u as=0.56p ps=2.56u w=2u l=1u
X574 vbnf bitb0 a_6356_6633# VDD pfet_03v3 ad=2.25p pd=10.9u as=2.25p ps=10.9u w=5u l=0.28u
X575 a_37178_8187# vbn a_36888_7607# VSS nfet_03v3 ad=0.56p pd=2.56u as=0.56p ps=2.56u w=2u l=1u
X576 a_37178_5867# vbn a_36888_6447# VSS nfet_03v3 ad=0.56p pd=2.56u as=0.56p ps=2.56u w=2u l=1u
X577 a_37178_5867# vbn a_36888_5287# VSS nfet_03v3 ad=0.56p pd=2.56u as=0.56p ps=2.56u w=2u l=1u
X578 a_36888_5287# vbn a_37178_4707# VSS nfet_03v3 ad=0.56p pd=2.56u as=0.56p ps=2.56u w=2u l=1u
X579 a_36888_2967# vbn a_37178_2387# VSS nfet_03v3 ad=0.56p pd=2.56u as=0.56p ps=2.56u w=2u l=1u
X580 a_37178_7027# vbn a_36888_7607# VSS nfet_03v3 ad=0.56p pd=2.56u as=0.9p ps=4.9u w=2u l=1u
X581 VDD a_996_6587# a0 VDD pfet_03v3 ad=2.25p pd=10.9u as=2.25p ps=10.9u w=5u l=0.28u
X582 a_36888_1807# vbn a_37178_2387# VSS nfet_03v3 ad=0.9p pd=4.9u as=0.56p ps=2.56u w=2u l=1u
X583 a_37178_8187# vbn a_36866_9481# VSS nfet_03v3 ad=0.56p pd=2.56u as=0.56p ps=2.56u w=2u l=1u
X584 ck a_n8217_6703# VDD_LS VDD_LS pfet_03v3 ad=2.5p pd=7u as=1.125p ps=5.9u w=2.5u l=0.28u
X585 a_n5549_6703# a_n5234_7514# VDD_LS VDD_LS pfet_03v3 ad=2p pd=6u as=0.9p ps=4.9u w=2u l=0.28u
X586 VDD vg VDD VDD pfet_03v3 ad=13.419p pd=60.54u as=0 ps=0 w=29.82u l=4.12u
X587 vg a_6206_896# VSS VSS nfet_03v3 ad=0.336p pd=1.76u as=0.336p ps=1.76u w=1.2u l=5.335u
X588 a_37178_8187# vbn a_36888_7607# VSS nfet_03v3 ad=0.56p pd=2.56u as=0.56p ps=2.56u w=2u l=1u
X589 a_37178_7027# vbn a_36888_7607# VSS nfet_03v3 ad=0.56p pd=2.56u as=0.56p ps=2.56u w=2u l=1u
X590 a_36888_1807# vbn a_37178_1227# VSS nfet_03v3 ad=0.56p pd=2.56u as=0.56p ps=2.56u w=2u l=1u
X591 a_41854_7027# vbn a_41564_6447# VSS nfet_03v3 ad=0.56p pd=2.56u as=0.9p ps=4.9u w=2u l=1u
X592 a_37178_4707# vbn a_36888_5287# VSS nfet_03v3 ad=0.56p pd=2.56u as=0.56p ps=2.56u w=2u l=1u
X593 a_36888_4127# vbn a_37178_3547# VSS nfet_03v3 ad=0.56p pd=2.56u as=0.56p ps=2.56u w=2u l=1u
X594 a_41854_8187# vbn a_41564_7607# VSS nfet_03v3 ad=0.56p pd=2.56u as=0.56p ps=2.56u w=2u l=1u
X595 a_36888_7607# vbn a_37178_8187# VSS nfet_03v3 ad=0.56p pd=2.56u as=0.56p ps=2.56u w=2u l=1u
X596 a_37178_7027# vbn a_36888_7607# VSS nfet_03v3 ad=0.56p pd=2.56u as=0.56p ps=2.56u w=2u l=1u
X597 a_36888_6447# vbn a_37178_5867# VSS nfet_03v3 ad=0.56p pd=2.56u as=0.56p ps=2.56u w=2u l=1u
X598 a_41854_4707# vbn a_41564_4127# VSS nfet_03v3 ad=0.9p pd=4.9u as=0.56p ps=2.56u w=2u l=1u
X599 a_37178_2387# vbn a_36888_2967# VSS nfet_03v3 ad=0.56p pd=2.56u as=0.56p ps=2.56u w=2u l=1u
X600 a_41854_2387# vbn a_41564_2967# VSS nfet_03v3 ad=0.56p pd=2.56u as=0.9p ps=4.9u w=2u l=1u
X601 a_36888_4127# vbn a_37178_3547# VSS nfet_03v3 ad=0.56p pd=2.56u as=0.56p ps=2.56u w=2u l=1u
X602 a_36888_1807# vbn a_37178_1227# VSS nfet_03v3 ad=0.56p pd=2.56u as=0.56p ps=2.56u w=2u l=1u
X603 a_37178_1227# vbn w_36826_300# VSS nfet_03v3 ad=0.56p pd=2.56u as=0.56p ps=2.56u w=2u l=1u
X604 a_37178_1227# vbn a_36888_1807# VSS nfet_03v3 ad=0.56p pd=2.56u as=0.56p ps=2.56u w=2u l=1u
X605 a_37178_3547# vbn a_36888_4127# VSS nfet_03v3 ad=0.56p pd=2.56u as=0.9p ps=4.9u w=2u l=1u
X606 a_36888_7607# vbn a_37178_8187# VSS nfet_03v3 ad=0.56p pd=2.56u as=0.56p ps=2.56u w=2u l=1u
X607 a_36888_5287# vbn a_37178_5867# VSS nfet_03v3 ad=0.56p pd=2.56u as=0.56p ps=2.56u w=2u l=1u
X608 a_37178_7027# vbn a_36888_7607# VSS nfet_03v3 ad=0.56p pd=2.56u as=0.56p ps=2.56u w=2u l=1u
X609 a_41564_4127# vbn a_41854_4707# VSS nfet_03v3 ad=0.56p pd=2.56u as=0.56p ps=2.56u w=2u l=1u
X610 a_36888_1807# vbn a_37178_1227# VSS nfet_03v3 ad=0.56p pd=2.56u as=0.56p ps=2.56u w=2u l=1u
X611 a_6206_4704# bitb2 VSS VSS nfet_03v3 ad=0.45p pd=2.9u as=0.45p ps=2.9u w=1u l=0.28u
X612 a_41854_7027# vbn a_41564_7607# VSS nfet_03v3 ad=0.56p pd=2.56u as=0.56p ps=2.56u w=2u l=1u
X613 a_36888_2967# vbn a_37178_3547# VSS nfet_03v3 ad=0.56p pd=2.56u as=0.56p ps=2.56u w=2u l=1u
X614 a_36888_2967# vbn a_37178_2387# VSS nfet_03v3 ad=0.56p pd=2.56u as=0.56p ps=2.56u w=2u l=1u
X615 a_41854_8187# vbn vbn VSS nfet_03v3 ad=0.9p pd=4.9u as=0.56p ps=2.56u w=2u l=1u
X616 a_37178_5867# vbn a_36888_6447# VSS nfet_03v3 ad=0.56p pd=2.56u as=0.56p ps=2.56u w=2u l=1u
X617 a_36888_7607# vbn a_37178_7027# VSS nfet_03v3 ad=0.56p pd=2.56u as=0.56p ps=2.56u w=2u l=1u
X618 a_37178_3547# vbn a_36888_4127# VSS nfet_03v3 ad=0.56p pd=2.56u as=0.9p ps=4.9u w=2u l=1u
X619 a_41854_5867# vbn a_41564_6447# VSS nfet_03v3 ad=0.56p pd=2.56u as=0.9p ps=4.9u w=2u l=1u
X620 a_37178_2387# vbn a_36888_1807# VSS nfet_03v3 ad=0.56p pd=2.56u as=0.56p ps=2.56u w=2u l=1u
X621 ls a_n3607_6703# VDD_LS VDD_LS pfet_03v3 ad=3p pd=8u as=1.35p ps=6.9u w=3u l=0.28u
X622 a_37178_4707# vbn a_36888_5287# VSS nfet_03v3 ad=0.56p pd=2.56u as=0.56p ps=2.56u w=2u l=1u
X623 a_36888_5287# vbn a_37178_5867# VSS nfet_03v3 ad=0.56p pd=2.56u as=0.56p ps=2.56u w=2u l=1u
X624 a_36888_7607# vbn a_37178_8187# VSS nfet_03v3 ad=0.56p pd=2.56u as=0.56p ps=2.56u w=2u l=1u
X625 a_37178_8187# vbn a_36888_7607# VSS nfet_03v3 ad=0.56p pd=2.56u as=0.9p ps=4.9u w=2u l=1u
X626 a_37178_5867# vbn a_36888_5287# VSS nfet_03v3 ad=0.56p pd=2.56u as=0.56p ps=2.56u w=2u l=1u
X627 a_41564_2967# vbn a_41854_3547# VSS nfet_03v3 ad=0.56p pd=2.56u as=0.56p ps=2.56u w=2u l=1u
X628 a_37178_3547# vbn a_36888_4127# VSS nfet_03v3 ad=0.56p pd=2.56u as=0.56p ps=2.56u w=2u l=1u
X629 a_37178_1227# vbn a_36888_1807# VSS nfet_03v3 ad=0.56p pd=2.56u as=0.56p ps=2.56u w=2u l=1u
X630 a_n5549_6703# ls a_n5128_6451# VSS nfet_03v3 ad=1p pd=4u as=0.28p ps=1.56u w=1u l=0.28u
X631 a_36888_6447# vbn a_37178_7027# VSS nfet_03v3 ad=0.56p pd=2.56u as=0.56p ps=2.56u w=2u l=1u
X632 a_36888_6447# vbn a_37178_5867# VSS nfet_03v3 ad=0.56p pd=2.56u as=0.56p ps=2.56u w=2u l=1u
X633 a_37178_2387# vbn a_36888_2967# VSS nfet_03v3 ad=0.56p pd=2.56u as=0.56p ps=2.56u w=2u l=1u
X634 a_36888_7607# vbn a_37178_7027# VSS nfet_03v3 ad=0.56p pd=2.56u as=0.56p ps=2.56u w=2u l=1u
X635 vbn vbn a_41854_8187# VSS nfet_03v3 ad=0.56p pd=2.56u as=0.56p ps=2.56u w=2u l=1u
X636 a_36888_5287# vbn a_37178_5867# VSS nfet_03v3 ad=0.56p pd=2.56u as=0.56p ps=2.56u w=2u l=1u
X637 a_37178_3547# vbn a_36888_4127# VSS nfet_03v3 ad=0.56p pd=2.56u as=0.56p ps=2.56u w=2u l=1u
X638 a_36888_2967# vbn a_37178_3547# VSS nfet_03v3 ad=0.9p pd=4.9u as=0.56p ps=2.56u w=2u l=1u
X639 a_41854_1227# vbn VSS VSS nfet_03v3 ad=0.9p pd=4.9u as=0.56p ps=2.56u w=2u l=1u
X640 a_37178_8187# vbn a_36888_7607# VSS nfet_03v3 ad=0.56p pd=2.56u as=0.9p ps=4.9u w=2u l=1u
X641 a_37178_4707# vbn a_36888_4127# VSS nfet_03v3 ad=0.56p pd=2.56u as=0.56p ps=2.56u w=2u l=1u
X642 a_41564_4127# vbn a_41854_4707# VSS nfet_03v3 ad=0.56p pd=2.56u as=0.56p ps=2.56u w=2u l=1u
X643 a_37178_3547# vbn a_36888_2967# VSS nfet_03v3 ad=0.56p pd=2.56u as=0.56p ps=2.56u w=2u l=1u
X644 a_36888_1807# vbn a_37178_1227# VSS nfet_03v3 ad=0.56p pd=2.56u as=0.56p ps=2.56u w=2u l=1u
X645 a_41564_6447# vbn a_41854_7027# VSS nfet_03v3 ad=0.56p pd=2.56u as=0.56p ps=2.56u w=2u l=1u
X646 a_41854_7027# vbn a_41564_7607# VSS nfet_03v3 ad=0.9p pd=4.9u as=0.56p ps=2.56u w=2u l=1u
X647 VSS VDD_LS VSS VSS nfet_03v3 ad=13.7592p pd=49.7u as=0 ps=0 w=49.14u l=10u
X648 a_37178_5867# vbn a_36888_5287# VSS nfet_03v3 ad=0.56p pd=2.56u as=0.56p ps=2.56u w=2u l=1u
X649 VSS a_6206_4704# vg VSS nfet_03v3 ad=0.54p pd=3.3u as=0.336p ps=1.76u w=1.2u l=5.335u
X650 a_37178_5867# vbn a_36888_6447# VSS nfet_03v3 ad=0.56p pd=2.56u as=0.56p ps=2.56u w=2u l=1u
X651 a_37178_8187# vbn a_36888_7607# VSS nfet_03v3 ad=0.56p pd=2.56u as=0.56p ps=2.56u w=2u l=1u
X652 a_36888_1807# vbn a_37178_2387# VSS nfet_03v3 ad=0.56p pd=2.56u as=0.56p ps=2.56u w=2u l=1u
X653 a_37178_3547# vbn a_36888_4127# VSS nfet_03v3 ad=0.56p pd=2.56u as=0.56p ps=2.56u w=2u l=1u
X654 a_36888_1807# vbn a_37178_1227# VSS nfet_03v3 ad=0.56p pd=2.56u as=0.56p ps=2.56u w=2u l=1u
X655 a_36888_6447# vbn a_37178_7027# VSS nfet_03v3 ad=0.9p pd=4.9u as=0.56p ps=2.56u w=2u l=1u
X656 a_41854_3547# vbn a_41564_4127# VSS nfet_03v3 ad=0.56p pd=2.56u as=0.56p ps=2.56u w=2u l=1u
X657 VSS vbn a_41854_1227# VSS nfet_03v3 ad=0.56p pd=2.56u as=0.56p ps=2.56u w=2u l=1u
X658 a_37178_8187# vbn a_36888_7607# VSS nfet_03v3 ad=0.56p pd=2.56u as=0.56p ps=2.56u w=2u l=1u
X659 a_37178_8187# vbn a_36866_9481# VSS nfet_03v3 ad=0.56p pd=2.56u as=0.56p ps=2.56u w=2u l=1u
X660 a_41854_4707# vbn a_41564_5287# VSS nfet_03v3 ad=0.9p pd=4.9u as=0.56p ps=2.56u w=2u l=1u
X661 a_36888_4127# vbn a_37178_3547# VSS nfet_03v3 ad=0.56p pd=2.56u as=0.56p ps=2.56u w=2u l=1u
X662 a_36888_2967# vbn a_37178_3547# VSS nfet_03v3 ad=0.56p pd=2.56u as=0.56p ps=2.56u w=2u l=1u
X663 a_37178_7027# vbn a_36888_6447# VSS nfet_03v3 ad=0.56p pd=2.56u as=0.56p ps=2.56u w=2u l=1u
X664 a_36888_5287# vbn a_37178_5867# VSS nfet_03v3 ad=0.56p pd=2.56u as=0.56p ps=2.56u w=2u l=1u
X665 vbn vbn a_41854_8187# VSS nfet_03v3 ad=0.56p pd=2.56u as=0.56p ps=2.56u w=2u l=1u
X666 ck a_n8217_6703# VSS VSS nfet_03v3 ad=1p pd=4u as=0.45p ps=2.9u w=1u l=0.28u
X667 a_36888_1807# vbn a_37178_2387# VSS nfet_03v3 ad=0.56p pd=2.56u as=0.56p ps=2.56u w=2u l=1u
X668 a_41854_4707# vbn a_41564_4127# VSS nfet_03v3 ad=0.56p pd=2.56u as=0.56p ps=2.56u w=2u l=1u
X669 a_36888_1807# vbn a_37178_1227# VSS nfet_03v3 ad=0.56p pd=2.56u as=0.56p ps=2.56u w=2u l=1u
X670 a_37178_2387# vbn a_36888_1807# VSS nfet_03v3 ad=0.56p pd=2.56u as=0.56p ps=2.56u w=2u l=1u
X671 a_36888_2967# vbn a_37178_2387# VSS nfet_03v3 ad=0.56p pd=2.56u as=0.56p ps=2.56u w=2u l=1u
X672 a_41564_7607# vbn a_41854_7027# VSS nfet_03v3 ad=0.56p pd=2.56u as=0.56p ps=2.56u w=2u l=1u
X673 a_36888_5287# vbn a_37178_5867# VSS nfet_03v3 ad=0.56p pd=2.56u as=0.56p ps=2.56u w=2u l=1u
X674 a_37178_8187# vbn a_36888_7607# VSS nfet_03v3 ad=0.56p pd=2.56u as=0.56p ps=2.56u w=2u l=1u
X675 a_36888_4127# vbn a_37178_3547# VSS nfet_03v3 ad=0.56p pd=2.56u as=0.56p ps=2.56u w=2u l=1u
X676 a_41564_5287# vbn a_41854_4707# VSS nfet_03v3 ad=0.56p pd=2.56u as=0.56p ps=2.56u w=2u l=1u
X677 a_36888_1807# vbn a_37178_2387# VSS nfet_03v3 ad=0.56p pd=2.56u as=0.56p ps=2.56u w=2u l=1u
X678 a_n7180_6531# a_n7286_7514# VSS VSS nfet_03v3 ad=0.168p pd=1.16u as=0.27p ps=2.1u w=0.6u l=0.28u
X679 a_41854_8187# vbn a_41564_7607# VSS nfet_03v3 ad=0.56p pd=2.56u as=0.56p ps=2.56u w=2u l=1u
X680 a_36888_6447# vbn a_37178_7027# VSS nfet_03v3 ad=0.56p pd=2.56u as=0.56p ps=2.56u w=2u l=1u
X681 a_36888_7607# vbn a_37178_8187# VSS nfet_03v3 ad=0.56p pd=2.56u as=0.56p ps=2.56u w=2u l=1u
X682 a_36888_1807# vbn a_37178_1227# VSS nfet_03v3 ad=0.56p pd=2.56u as=0.56p ps=2.56u w=2u l=1u
X683 a_37178_1227# vbn w_36826_300# VSS nfet_03v3 ad=0.56p pd=2.56u as=0.56p ps=2.56u w=2u l=1u
X684 a_37178_2387# vbn a_36888_2967# VSS nfet_03v3 ad=0.56p pd=2.56u as=0.56p ps=2.56u w=2u l=1u
X685 VSS vbn a_41854_1227# VSS nfet_03v3 ad=0.56p pd=2.56u as=0.56p ps=2.56u w=2u l=1u
X686 a_41854_3547# vbn a_41564_4127# VSS nfet_03v3 ad=0.9p pd=4.9u as=0.56p ps=2.56u w=2u l=1u
X687 a_36888_6447# vbn a_37178_5867# VSS nfet_03v3 ad=0.56p pd=2.56u as=0.56p ps=2.56u w=2u l=1u
X688 a_36888_5287# vbn a_37178_5867# VSS nfet_03v3 ad=0.56p pd=2.56u as=0.56p ps=2.56u w=2u l=1u
X689 a_41854_8187# vbn vbn VSS nfet_03v3 ad=0.56p pd=2.56u as=0.56p ps=2.56u w=2u l=1u
X690 VSS a_6206_896# vg VSS nfet_03v3 ad=0.54p pd=3.3u as=0.336p ps=1.76u w=1.2u l=5.335u
X691 a_37178_2387# vbn a_36888_1807# VSS nfet_03v3 ad=0.56p pd=2.56u as=0.56p ps=2.56u w=2u l=1u
X692 a_37178_1227# vbn a_36888_1807# VSS nfet_03v3 ad=0.56p pd=2.56u as=0.9p ps=4.9u w=2u l=1u
X693 a_36888_7607# vbn a_37178_8187# VSS nfet_03v3 ad=0.56p pd=2.56u as=0.56p ps=2.56u w=2u l=1u
X694 a_37178_7027# vbn a_36888_7607# VSS nfet_03v3 ad=0.56p pd=2.56u as=0.56p ps=2.56u w=2u l=1u
X695 VDD vg VDD VDD pfet_03v3 ad=8.3496p pd=30.38u as=0 ps=0 w=29.82u l=4.12u
X696 a_37178_2387# vbn a_36888_2967# VSS nfet_03v3 ad=0.56p pd=2.56u as=0.56p ps=2.56u w=2u l=1u
X697 a_37178_5867# vbn a_36888_6447# VSS nfet_03v3 ad=0.56p pd=2.56u as=0.56p ps=2.56u w=2u l=1u
X698 a_36888_5287# vbn a_37178_5867# VSS nfet_03v3 ad=0.56p pd=2.56u as=0.56p ps=2.56u w=2u l=1u
X699 a_37178_4707# vbn a_36888_5287# VSS nfet_03v3 ad=0.56p pd=2.56u as=0.56p ps=2.56u w=2u l=1u
X700 a_41564_5287# vbn a_41854_4707# VSS nfet_03v3 ad=0.56p pd=2.56u as=0.56p ps=2.56u w=2u l=1u
X701 a_41854_8187# vbn a_41564_7607# VSS nfet_03v3 ad=0.9p pd=4.9u as=0.56p ps=2.56u w=2u l=1u
X702 a_36888_1807# vbn a_37178_2387# VSS nfet_03v3 ad=0.56p pd=2.56u as=0.56p ps=2.56u w=2u l=1u
X703 a_37178_1227# vbn a_36888_1807# VSS nfet_03v3 ad=0.56p pd=2.56u as=0.56p ps=2.56u w=2u l=1u
X704 a_36888_2967# vbn a_37178_3547# VSS nfet_03v3 ad=0.56p pd=2.56u as=0.56p ps=2.56u w=2u l=1u
X705 a_36888_2967# vbn a_37178_2387# VSS nfet_03v3 ad=0.56p pd=2.56u as=0.56p ps=2.56u w=2u l=1u
X706 a_41854_1227# vbn VSS VSS nfet_03v3 ad=0.56p pd=2.56u as=0.56p ps=2.56u w=2u l=1u
X707 VSS a_6206_14# vg VSS nfet_03v3 ad=0.54p pd=3.3u as=0.336p ps=1.76u w=1.2u l=5.335u
X708 vg a_6206_14# VSS VSS nfet_03v3 ad=0.336p pd=1.76u as=0.336p ps=1.76u w=1.2u l=5.335u
X709 vg a_6206_14# VSS VSS nfet_03v3 ad=0.336p pd=1.76u as=0.336p ps=1.76u w=1.2u l=5.335u
X710 VSS vbnf VSS VSS nfet_03v3 ad=13.7592p pd=49.7u as=0 ps=0 w=49.14u l=10u
X711 a_41564_4127# vbn a_41854_3547# VSS nfet_03v3 ad=0.56p pd=2.56u as=0.56p ps=2.56u w=2u l=1u
X712 a_1632_6633# a_452_6633# VDD VDD pfet_03v3 ad=2.25p pd=10.9u as=2.25p ps=10.9u w=5u l=0.28u
X713 a_36888_7607# vbn a_37178_7027# VSS nfet_03v3 ad=0.56p pd=2.56u as=0.56p ps=2.56u w=2u l=1u
X714 a_37178_5867# vbn a_36888_5287# VSS nfet_03v3 ad=0.56p pd=2.56u as=0.9p ps=4.9u w=2u l=1u
X715 a_37178_3547# vbn a_36888_2967# VSS nfet_03v3 ad=0.56p pd=2.56u as=0.56p ps=2.56u w=2u l=1u
X716 a_37178_2387# vbn a_36888_2967# VSS nfet_03v3 ad=0.56p pd=2.56u as=0.56p ps=2.56u w=2u l=1u
X717 a_36888_1807# vbn a_37178_2387# VSS nfet_03v3 ad=0.56p pd=2.56u as=0.56p ps=2.56u w=2u l=1u
X718 a_37178_5867# vbn a_36888_6447# VSS nfet_03v3 ad=0.56p pd=2.56u as=0.56p ps=2.56u w=2u l=1u
X719 vbn a_36866_9481# VDD VDD pfet_03v3 ad=3.92p pd=14.56u as=6.3p ps=28.9u w=14u l=14u
X720 a_36888_6447# vbn a_37178_7027# VSS nfet_03v3 ad=0.56p pd=2.56u as=0.56p ps=2.56u w=2u l=1u
X721 a_36888_6447# vbn a_37178_5867# VSS nfet_03v3 ad=0.56p pd=2.56u as=0.56p ps=2.56u w=2u l=1u
X722 a_36888_4127# vbn a_37178_4707# VSS nfet_03v3 ad=0.9p pd=4.9u as=0.56p ps=2.56u w=2u l=1u
X723 a_36888_2967# vbn a_37178_2387# VSS nfet_03v3 ad=0.56p pd=2.56u as=0.56p ps=2.56u w=2u l=1u
X724 a_37178_7027# vbn a_36888_7607# VSS nfet_03v3 ad=0.56p pd=2.56u as=0.56p ps=2.56u w=2u l=1u
X725 a_37178_5867# vbn a_36888_5287# VSS nfet_03v3 ad=0.56p pd=2.56u as=0.56p ps=2.56u w=2u l=1u
X726 a_41854_4707# vbn a_41564_5287# VSS nfet_03v3 ad=0.56p pd=2.56u as=0.56p ps=2.56u w=2u l=1u
X727 a_41564_7607# vbn a_41854_8187# VSS nfet_03v3 ad=0.56p pd=2.56u as=0.56p ps=2.56u w=2u l=1u
X728 a_36888_1807# vbn a_37178_2387# VSS nfet_03v3 ad=0.56p pd=2.56u as=0.56p ps=2.56u w=2u l=1u
X729 a_36888_2967# vbn a_37178_3547# VSS nfet_03v3 ad=0.56p pd=2.56u as=0.56p ps=2.56u w=2u l=1u
X730 a_37178_5867# vbn a_36888_6447# VSS nfet_03v3 ad=0.56p pd=2.56u as=0.56p ps=2.56u w=2u l=1u
X731 a_37178_7027# vbn a_36888_6447# VSS nfet_03v3 ad=0.56p pd=2.56u as=0.56p ps=2.56u w=2u l=1u
X732 vg vbnf VSS VSS nfet_03v3 ad=0.336p pd=1.76u as=0.336p ps=1.76u w=1.2u l=5.335u
X733 a_41854_1227# vbn a_41564_1807# VSS nfet_03v3 ad=0.56p pd=2.56u as=0.56p ps=2.56u w=2u l=1u
X734 a_37178_3547# vbn a_36888_4127# VSS nfet_03v3 ad=0.56p pd=2.56u as=0.56p ps=2.56u w=2u l=1u
X735 a_36888_6447# vbn a_37178_5867# VSS nfet_03v3 ad=0.56p pd=2.56u as=0.56p ps=2.56u w=2u l=1u
X736 a_36866_9481# vbn a_37178_8187# VSS nfet_03v3 ad=0.9p pd=4.9u as=0.56p ps=2.56u w=2u l=1u
X737 VSS vbnf VSS VSS nfet_03v3 ad=13.7592p pd=49.7u as=0 ps=0 w=49.14u l=10u
X738 a_36888_1807# vbn a_37178_2387# VSS nfet_03v3 ad=0.56p pd=2.56u as=0.56p ps=2.56u w=2u l=1u
X739 vg a_6356_6633# VSS VSS nfet_03v3 ad=0.336p pd=1.76u as=0.54p ps=3.3u w=1.2u l=5.335u
X740 a_36888_6447# vbn a_37178_7027# VSS nfet_03v3 ad=0.56p pd=2.56u as=0.56p ps=2.56u w=2u l=1u
X741 vbn vbnf VSS ppolyf_u_1k r_width=1u r_length=0.97023m
X742 a_37178_4707# vbn a_36888_4127# VSS nfet_03v3 ad=0.56p pd=2.56u as=0.56p ps=2.56u w=2u l=1u
X743 a_36888_7607# vbn a_37178_7027# VSS nfet_03v3 ad=0.56p pd=2.56u as=0.56p ps=2.56u w=2u l=1u
X744 a_36888_4127# vbn a_37178_3547# VSS nfet_03v3 ad=0.56p pd=2.56u as=0.56p ps=2.56u w=2u l=1u
X745 a_41854_5867# vbn a_41564_5287# VSS nfet_03v3 ad=0.56p pd=2.56u as=0.56p ps=2.56u w=2u l=1u
X746 a_36888_1807# vbn a_37178_1227# VSS nfet_03v3 ad=0.56p pd=2.56u as=0.56p ps=2.56u w=2u l=1u
X747 a_37178_2387# vbn a_36888_1807# VSS nfet_03v3 ad=0.56p pd=2.56u as=0.9p ps=4.9u w=2u l=1u
X748 vg a_6206_14# VSS VSS nfet_03v3 ad=0.336p pd=1.76u as=0.54p ps=3.3u w=1.2u l=5.335u
X749 a_37178_8187# vbn a_36888_7607# VSS nfet_03v3 ad=0.56p pd=2.56u as=0.56p ps=2.56u w=2u l=1u
X750 a_36888_4127# vbn a_37178_4707# VSS nfet_03v3 ad=0.9p pd=4.9u as=0.56p ps=2.56u w=2u l=1u
X751 vbnf bit1 a_7096_6633# VSS nfet_03v3 ad=0.9p pd=4.9u as=0.9p ps=4.9u w=2u l=0.28u
X752 a_n7601_6703# q1 a_n7180_6531# VSS nfet_03v3 ad=0.6p pd=3.2u as=0.168p ps=1.16u w=0.6u l=0.28u
X753 a_37178_7027# vbn a_36888_7607# VSS nfet_03v3 ad=0.56p pd=2.56u as=0.56p ps=2.56u w=2u l=1u
X754 w_36826_300# vbn a_37178_1227# VSS nfet_03v3 ad=0.9p pd=4.9u as=0.56p ps=2.56u w=2u l=1u
X755 VDD_LS a_n2245_6719# a_n3101_6703# VDD_LS pfet_03v3 ad=0.225p pd=1.9u as=1.1p ps=5.4u w=0.5u l=0.28u
X756 a_n3607_6703# a_n3101_6703# VSS VSS nfet_03v3 ad=0.6p pd=3.2u as=0.27p ps=2.1u w=0.6u l=0.28u
X757 a_41564_2967# vbn a_41854_2387# VSS nfet_03v3 ad=0.56p pd=2.56u as=0.56p ps=2.56u w=2u l=1u
X758 a_37178_8187# vbn a_36866_9481# VSS nfet_03v3 ad=0.56p pd=2.56u as=0.56p ps=2.56u w=2u l=1u
X759 a_37178_1227# vbn a_36888_1807# VSS nfet_03v3 ad=0.56p pd=2.56u as=0.56p ps=2.56u w=2u l=1u
X760 a_37178_2387# vbn a_36888_1807# VSS nfet_03v3 ad=0.56p pd=2.56u as=0.56p ps=2.56u w=2u l=1u
X761 a_37178_3547# vbn a_36888_4127# VSS nfet_03v3 ad=0.56p pd=2.56u as=0.56p ps=2.56u w=2u l=1u
X762 a_37178_3547# vbn a_36888_2967# VSS nfet_03v3 ad=0.56p pd=2.56u as=0.56p ps=2.56u w=2u l=1u
X763 a_36888_1807# vbn a_37178_1227# VSS nfet_03v3 ad=0.56p pd=2.56u as=0.56p ps=2.56u w=2u l=1u
X764 a_36888_5287# vbn a_37178_5867# VSS nfet_03v3 ad=0.56p pd=2.56u as=0.56p ps=2.56u w=2u l=1u
X765 VDD vg VDD VDD pfet_03v3 ad=8.3496p pd=30.38u as=0 ps=0 w=29.82u l=4.12u
X766 a_36888_7607# vbn a_37178_8187# VSS nfet_03v3 ad=0.56p pd=2.56u as=0.56p ps=2.56u w=2u l=1u
X767 a_36866_9481# vbn a_37178_8187# VSS nfet_03v3 ad=0.9p pd=4.9u as=0.56p ps=2.56u w=2u l=1u
X768 a_41564_2967# vbn a_41854_2387# VSS nfet_03v3 ad=0.56p pd=2.56u as=0.56p ps=2.56u w=2u l=1u
X769 a_452_6633# a0 vg VSS nfet_03v3 ad=0.9p pd=4.9u as=0.9p ps=4.9u w=2u l=0.28u
X770 a_37178_3547# vbn a_36888_2967# VSS nfet_03v3 ad=0.56p pd=2.56u as=0.56p ps=2.56u w=2u l=1u
X771 a_37178_1227# vbn a_36888_1807# VSS nfet_03v3 ad=0.56p pd=2.56u as=0.56p ps=2.56u w=2u l=1u
X772 vbnf bitb4 a_6206_14# VDD pfet_03v3 ad=2.25p pd=10.9u as=2.25p ps=10.9u w=5u l=0.28u
X773 a_41564_6447# vbn a_41854_5867# VSS nfet_03v3 ad=0.56p pd=2.56u as=0.56p ps=2.56u w=2u l=1u
X774 a_37178_3547# vbn a_36888_2967# VSS nfet_03v3 ad=0.56p pd=2.56u as=0.56p ps=2.56u w=2u l=1u
X775 a_37178_7027# vbn a_36888_6447# VSS nfet_03v3 ad=0.56p pd=2.56u as=0.56p ps=2.56u w=2u l=1u
X776 a_36888_5287# vbn a_37178_4707# VSS nfet_03v3 ad=0.9p pd=4.9u as=0.56p ps=2.56u w=2u l=1u
X777 a_37178_8187# vbn a_36888_7607# VSS nfet_03v3 ad=0.56p pd=2.56u as=0.56p ps=2.56u w=2u l=1u
X778 a_37178_5867# vbn a_36888_5287# VSS nfet_03v3 ad=0.56p pd=2.56u as=0.56p ps=2.56u w=2u l=1u
X779 a_36888_5287# vbn a_37178_5867# VSS nfet_03v3 ad=0.56p pd=2.56u as=0.56p ps=2.56u w=2u l=1u
X780 a_37178_1227# vbn w_36826_300# VSS nfet_03v3 ad=0.56p pd=2.56u as=0.56p ps=2.56u w=2u l=1u
X781 a_41564_6447# vbn a_41854_5867# VSS nfet_03v3 ad=0.56p pd=2.56u as=0.56p ps=2.56u w=2u l=1u
X782 a_41854_3547# vbn a_41564_2967# VSS nfet_03v3 ad=0.56p pd=2.56u as=0.56p ps=2.56u w=2u l=1u
X783 a_41854_2387# vbn a_41564_2967# VSS nfet_03v3 ad=0.56p pd=2.56u as=0.9p ps=4.9u w=2u l=1u
X784 a_36888_1807# vbn a_37178_1227# VSS nfet_03v3 ad=0.56p pd=2.56u as=0.56p ps=2.56u w=2u l=1u
X785 a_n6862_7514# a_n7601_6703# VDD_LS VDD_LS pfet_03v3 ad=0.336p pd=1.76u as=0.336p ps=1.76u w=1.2u l=0.28u
X786 a_37178_7027# vbn a_36888_6447# VSS nfet_03v3 ad=0.56p pd=2.56u as=0.56p ps=2.56u w=2u l=1u
X787 a_37178_4707# vbn a_36888_4127# VSS nfet_03v3 ad=0.56p pd=2.56u as=0.56p ps=2.56u w=2u l=1u
X788 a_36888_4127# vbn a_37178_3547# VSS nfet_03v3 ad=0.56p pd=2.56u as=0.56p ps=2.56u w=2u l=1u
X789 a_36888_2967# vbn a_37178_3547# VSS nfet_03v3 ad=0.56p pd=2.56u as=0.56p ps=2.56u w=2u l=1u
X790 a_41854_2387# vbn a_41564_1807# VSS nfet_03v3 ad=0.56p pd=2.56u as=0.56p ps=2.56u w=2u l=1u
X791 VSS a_n2245_6719# a_n3101_6703# VSS nfet_03v3 ad=0.1686p pd=1.74u as=0.5448p ps=5.16u w=0.22u l=0.28u
X792 a_37178_5867# vbn a_36888_5287# VSS nfet_03v3 ad=0.56p pd=2.56u as=0.56p ps=2.56u w=2u l=1u
X793 w_36826_300# vbn a_37178_1227# VSS nfet_03v3 ad=0.9p pd=4.9u as=0.56p ps=2.56u w=2u l=1u
X794 a_37178_7027# vbn a_36888_7607# VSS nfet_03v3 ad=0.56p pd=2.56u as=0.56p ps=2.56u w=2u l=1u
X795 a_37178_7027# vbn a_36888_6447# VSS nfet_03v3 ad=0.56p pd=2.56u as=0.56p ps=2.56u w=2u l=1u
X796 vg a_6206_896# VSS VSS nfet_03v3 ad=0.336p pd=1.76u as=0.54p ps=3.3u w=1.2u l=5.335u
X797 a_37178_3547# vbn a_36888_4127# VSS nfet_03v3 ad=0.56p pd=2.56u as=0.56p ps=2.56u w=2u l=1u
X798 vg a_6206_896# VSS VSS nfet_03v3 ad=0.336p pd=1.76u as=0.54p ps=3.3u w=1.2u l=5.335u
X799 a_41854_7027# vbn a_41564_6447# VSS nfet_03v3 ad=0.56p pd=2.56u as=0.56p ps=2.56u w=2u l=1u
X800 a_41854_5867# vbn a_41564_6447# VSS nfet_03v3 ad=0.56p pd=2.56u as=0.9p ps=4.9u w=2u l=1u
X801 a_36888_2967# vbn a_37178_3547# VSS nfet_03v3 ad=0.56p pd=2.56u as=0.56p ps=2.56u w=2u l=1u
X802 a_36888_6447# vbn a_37178_7027# VSS nfet_03v3 ad=0.56p pd=2.56u as=0.56p ps=2.56u w=2u l=1u
X803 a_37178_4707# vbn a_36888_5287# VSS nfet_03v3 ad=0.56p pd=2.56u as=0.56p ps=2.56u w=2u l=1u
X804 a_37178_8187# vbn a_36866_9481# VSS nfet_03v3 ad=0.56p pd=2.56u as=0.56p ps=2.56u w=2u l=1u
X805 a_36888_7607# vbn a_37178_8187# VSS nfet_03v3 ad=0.56p pd=2.56u as=0.56p ps=2.56u w=2u l=1u
X806 a_36888_5287# vbn a_37178_5867# VSS nfet_03v3 ad=0.56p pd=2.56u as=0.56p ps=2.56u w=2u l=1u
X807 a_37178_1227# vbn a_36888_1807# VSS nfet_03v3 ad=0.56p pd=2.56u as=0.56p ps=2.56u w=2u l=1u
X808 a_36888_1807# vbn a_37178_2387# VSS nfet_03v3 ad=0.56p pd=2.56u as=0.56p ps=2.56u w=2u l=1u
X809 a_36888_5287# vbn a_37178_4707# VSS nfet_03v3 ad=0.9p pd=4.9u as=0.56p ps=2.56u w=2u l=1u
X810 a_41854_1227# vbn a_41564_1807# VSS nfet_03v3 ad=0.56p pd=2.56u as=0.9p ps=4.9u w=2u l=1u
X811 a_36888_2967# vbn a_37178_3547# VSS nfet_03v3 ad=0.56p pd=2.56u as=0.56p ps=2.56u w=2u l=1u
X812 a_36888_6447# vbn a_37178_7027# VSS nfet_03v3 ad=0.56p pd=2.56u as=0.56p ps=2.56u w=2u l=1u
X813 a_36888_4127# vbn a_37178_4707# VSS nfet_03v3 ad=0.56p pd=2.56u as=0.56p ps=2.56u w=2u l=1u
X814 a_37178_3547# vbn a_36888_2967# VSS nfet_03v3 ad=0.56p pd=2.56u as=0.9p ps=4.9u w=2u l=1u
X815 a_37178_8187# vbn a_36888_7607# VSS nfet_03v3 ad=0.56p pd=2.56u as=0.56p ps=2.56u w=2u l=1u
X816 a_37178_2387# vbn a_36888_1807# VSS nfet_03v3 ad=0.56p pd=2.56u as=0.56p ps=2.56u w=2u l=1u
X817 a_36888_1807# vbn a_37178_1227# VSS nfet_03v3 ad=0.56p pd=2.56u as=0.56p ps=2.56u w=2u l=1u
X818 a_n5128_6451# a_n5234_7514# VSS VSS nfet_03v3 ad=0.28p pd=1.56u as=0.45p ps=2.9u w=1u l=0.28u
X819 a_36888_1807# vbn a_37178_2387# VSS nfet_03v3 ad=0.56p pd=2.56u as=0.56p ps=2.56u w=2u l=1u
X820 a_41854_7027# vbn a_41564_7607# VSS nfet_03v3 ad=0.9p pd=4.9u as=0.56p ps=2.56u w=2u l=1u
X821 a_36888_2967# vbn a_37178_2387# VSS nfet_03v3 ad=0.56p pd=2.56u as=0.56p ps=2.56u w=2u l=1u
X822 a_37178_5867# vbn a_36888_5287# VSS nfet_03v3 ad=0.56p pd=2.56u as=0.56p ps=2.56u w=2u l=1u
X823 a_37178_1227# vbn w_36826_300# VSS nfet_03v3 ad=0.56p pd=2.56u as=0.56p ps=2.56u w=2u l=1u
X824 a_6206_896# bitb3 VSS VSS nfet_03v3 ad=0.45p pd=2.9u as=0.45p ps=2.9u w=1u l=0.28u
X825 a_36888_4127# vbn a_37178_4707# VSS nfet_03v3 ad=0.56p pd=2.56u as=0.56p ps=2.56u w=2u l=1u
X826 a_37178_3547# vbn a_36888_4127# VSS nfet_03v3 ad=0.56p pd=2.56u as=0.56p ps=2.56u w=2u l=1u
X827 a_37178_3547# vbn a_36888_2967# VSS nfet_03v3 ad=0.56p pd=2.56u as=0.9p ps=4.9u w=2u l=1u
X828 a_41854_5867# vbn a_41564_5287# VSS nfet_03v3 ad=0.56p pd=2.56u as=0.9p ps=4.9u w=2u l=1u
X829 a_36888_6447# vbn a_37178_7027# VSS nfet_03v3 ad=0.56p pd=2.56u as=0.56p ps=2.56u w=2u l=1u
X830 a_37178_2387# vbn a_36888_1807# VSS nfet_03v3 ad=0.56p pd=2.56u as=0.56p ps=2.56u w=2u l=1u
X831 a_37178_7027# vbn a_36888_6447# VSS nfet_03v3 ad=0.56p pd=2.56u as=0.9p ps=4.9u w=2u l=1u
X832 a_37178_4707# vbn a_36888_4127# VSS nfet_03v3 ad=0.56p pd=2.56u as=0.56p ps=2.56u w=2u l=1u
X833 a_36866_9481# vbn a_37178_8187# VSS nfet_03v3 ad=0.56p pd=2.56u as=0.56p ps=2.56u w=2u l=1u
X834 a_41564_2967# vbn a_41854_2387# VSS nfet_03v3 ad=0.56p pd=2.56u as=0.56p ps=2.56u w=2u l=1u
X835 a_37178_3547# vbn a_36888_2967# VSS nfet_03v3 ad=0.56p pd=2.56u as=0.56p ps=2.56u w=2u l=1u
X836 a_37178_1227# vbn a_36888_1807# VSS nfet_03v3 ad=0.56p pd=2.56u as=0.56p ps=2.56u w=2u l=1u
X837 a_41564_7607# vbn a_41854_7027# VSS nfet_03v3 ad=0.56p pd=2.56u as=0.56p ps=2.56u w=2u l=1u
X838 a_36888_6447# vbn a_37178_5867# VSS nfet_03v3 ad=0.56p pd=2.56u as=0.56p ps=2.56u w=2u l=1u
X839 a_36888_5287# vbn a_37178_5867# VSS nfet_03v3 ad=0.56p pd=2.56u as=0.56p ps=2.56u w=2u l=1u
X840 a_36888_4127# vbn a_37178_4707# VSS nfet_03v3 ad=0.56p pd=2.56u as=0.56p ps=2.56u w=2u l=1u
X841 VSS a_6206_896# vg VSS nfet_03v3 ad=0.336p pd=1.76u as=0.336p ps=1.76u w=1.2u l=5.335u
X842 a_37178_3547# vbn a_36888_2967# VSS nfet_03v3 ad=0.56p pd=2.56u as=0.56p ps=2.56u w=2u l=1u
X843 a_37178_7027# vbn a_36888_6447# VSS nfet_03v3 ad=0.56p pd=2.56u as=0.9p ps=4.9u w=2u l=1u
X844 a_36888_1807# vbn a_37178_2387# VSS nfet_03v3 ad=0.56p pd=2.56u as=0.56p ps=2.56u w=2u l=1u
X845 a_37178_4707# vbn a_36888_5287# VSS nfet_03v3 ad=0.56p pd=2.56u as=0.56p ps=2.56u w=2u l=1u
X846 a_36888_2967# vbn a_37178_2387# VSS nfet_03v3 ad=0.9p pd=4.9u as=0.56p ps=2.56u w=2u l=1u
X847 a_37178_8187# vbn a_36888_7607# VSS nfet_03v3 ad=0.56p pd=2.56u as=0.56p ps=2.56u w=2u l=1u
X848 a_36866_9481# vbn a_37178_8187# VSS nfet_03v3 ad=0.56p pd=2.56u as=0.56p ps=2.56u w=2u l=1u
X849 a_37178_8187# vbn a_36866_9481# VSS nfet_03v3 ad=0.56p pd=2.56u as=0.56p ps=2.56u w=2u l=1u
X850 VSS a_6206_896# vg VSS nfet_03v3 ad=0.336p pd=1.76u as=0.336p ps=1.76u w=1.2u l=5.335u
X851 a_37178_4707# vbn a_36888_4127# VSS nfet_03v3 ad=0.56p pd=2.56u as=0.56p ps=2.56u w=2u l=1u
X852 a_41564_6447# vbn a_41854_5867# VSS nfet_03v3 ad=0.56p pd=2.56u as=0.56p ps=2.56u w=2u l=1u
X853 a_37178_2387# vbn a_36888_2967# VSS nfet_03v3 ad=0.56p pd=2.56u as=0.56p ps=2.56u w=2u l=1u
X854 a_37178_7027# vbn a_36888_6447# VSS nfet_03v3 ad=0.56p pd=2.56u as=0.56p ps=2.56u w=2u l=1u
X855 w_36826_300# vbn a_37178_1227# VSS nfet_03v3 ad=0.56p pd=2.56u as=0.56p ps=2.56u w=2u l=1u
X856 a_37178_5867# vbn a_36888_5287# VSS nfet_03v3 ad=0.56p pd=2.56u as=0.56p ps=2.56u w=2u l=1u
X857 a_36866_9481# vbn a_37178_8187# VSS nfet_03v3 ad=0.56p pd=2.56u as=0.56p ps=2.56u w=2u l=1u
X858 VSS vbnf VSS VSS nfet_03v3 ad=13.7592p pd=49.7u as=0 ps=0 w=49.14u l=10u
X859 a_37178_3547# vbn a_36888_2967# VSS nfet_03v3 ad=0.56p pd=2.56u as=0.56p ps=2.56u w=2u l=1u
X860 a_37178_7027# vbn a_36888_6447# VSS nfet_03v3 ad=0.56p pd=2.56u as=0.56p ps=2.56u w=2u l=1u
X861 a_36888_6447# vbn a_37178_5867# VSS nfet_03v3 ad=0.9p pd=4.9u as=0.56p ps=2.56u w=2u l=1u
X862 a_41854_3547# vbn a_41564_4127# VSS nfet_03v3 ad=0.9p pd=4.9u as=0.56p ps=2.56u w=2u l=1u
X863 a_41854_3547# vbn a_41564_2967# VSS nfet_03v3 ad=0.56p pd=2.56u as=0.56p ps=2.56u w=2u l=1u
X864 a_37178_7027# vbn a_36888_7607# VSS nfet_03v3 ad=0.56p pd=2.56u as=0.56p ps=2.56u w=2u l=1u
X865 a_41564_7607# vbn a_41854_7027# VSS nfet_03v3 ad=0.56p pd=2.56u as=0.56p ps=2.56u w=2u l=1u
X866 a_37178_2387# vbn a_36888_1807# VSS nfet_03v3 ad=0.56p pd=2.56u as=0.56p ps=2.56u w=2u l=1u
X867 a_36888_2967# vbn a_37178_3547# VSS nfet_03v3 ad=0.56p pd=2.56u as=0.56p ps=2.56u w=2u l=1u
X868 a_36888_2967# vbn a_37178_2387# VSS nfet_03v3 ad=0.56p pd=2.56u as=0.56p ps=2.56u w=2u l=1u
X869 a_36888_4127# vbn a_37178_4707# VSS nfet_03v3 ad=0.56p pd=2.56u as=0.56p ps=2.56u w=2u l=1u
X870 a_41854_2387# vbn a_41564_1807# VSS nfet_03v3 ad=0.56p pd=2.56u as=0.9p ps=4.9u w=2u l=1u
X871 a_37178_5867# vbn a_36888_6447# VSS nfet_03v3 ad=0.56p pd=2.56u as=0.56p ps=2.56u w=2u l=1u
X872 w_36826_300# vbn a_37178_1227# VSS nfet_03v3 ad=0.56p pd=2.56u as=0.56p ps=2.56u w=2u l=1u
X873 a_n6694_7514# q1 a_n6862_7514# VDD_LS pfet_03v3 ad=1.2p pd=4.4u as=0.336p ps=1.76u w=1.2u l=0.28u
X874 a_37178_8187# vbn a_36866_9481# VSS nfet_03v3 ad=0.56p pd=2.56u as=0.56p ps=2.56u w=2u l=1u
X875 a_37178_1227# vbn w_36826_300# VSS nfet_03v3 ad=0.56p pd=2.56u as=0.56p ps=2.56u w=2u l=1u
X876 a_36888_1807# vbn a_37178_1227# VSS nfet_03v3 ad=0.56p pd=2.56u as=0.56p ps=2.56u w=2u l=1u
X877 a_36888_5287# vbn a_37178_4707# VSS nfet_03v3 ad=0.56p pd=2.56u as=0.56p ps=2.56u w=2u l=1u
X878 a_36888_4127# vbn a_37178_4707# VSS nfet_03v3 ad=0.56p pd=2.56u as=0.56p ps=2.56u w=2u l=1u
X879 a_37178_7027# vbn a_36888_6447# VSS nfet_03v3 ad=0.56p pd=2.56u as=0.56p ps=2.56u w=2u l=1u
X880 a_41564_4127# vbn a_41854_3547# VSS nfet_03v3 ad=0.56p pd=2.56u as=0.56p ps=2.56u w=2u l=1u
X881 w_36826_300# vbn a_37178_1227# VSS nfet_03v3 ad=0.56p pd=2.56u as=0.56p ps=2.56u w=2u l=1u
X882 a_36888_2967# vbn a_37178_3547# VSS nfet_03v3 ad=0.56p pd=2.56u as=0.56p ps=2.56u w=2u l=1u
X883 a_41854_7027# vbn a_41564_6447# VSS nfet_03v3 ad=0.56p pd=2.56u as=0.56p ps=2.56u w=2u l=1u
X884 a_36888_1807# vbn a_37178_2387# VSS nfet_03v3 ad=0.56p pd=2.56u as=0.56p ps=2.56u w=2u l=1u
X885 a_41854_8187# vbn a_41564_7607# VSS nfet_03v3 ad=0.9p pd=4.9u as=0.56p ps=2.56u w=2u l=1u
X886 a_36888_6447# vbn a_37178_7027# VSS nfet_03v3 ad=0.56p pd=2.56u as=0.56p ps=2.56u w=2u l=1u
X887 a_36888_6447# vbn a_37178_5867# VSS nfet_03v3 ad=0.56p pd=2.56u as=0.56p ps=2.56u w=2u l=1u
X888 VSS a_6206_14# vg VSS nfet_03v3 ad=0.336p pd=1.76u as=0.336p ps=1.76u w=1.2u l=5.335u
X889 a_36888_5287# vbn a_37178_4707# VSS nfet_03v3 ad=0.56p pd=2.56u as=0.56p ps=2.56u w=2u l=1u
X890 a_36866_9481# vbn a_37178_8187# VSS nfet_03v3 ad=0.56p pd=2.56u as=0.56p ps=2.56u w=2u l=1u
X891 a_37178_4707# vbn a_36888_5287# VSS nfet_03v3 ad=0.56p pd=2.56u as=0.56p ps=2.56u w=2u l=1u
X892 a_36888_4127# vbn a_37178_4707# VSS nfet_03v3 ad=0.56p pd=2.56u as=0.56p ps=2.56u w=2u l=1u
X893 a_41854_7027# vbn a_41564_7607# VSS nfet_03v3 ad=0.56p pd=2.56u as=0.56p ps=2.56u w=2u l=1u
X894 a_37178_1227# vbn a_36888_1807# VSS nfet_03v3 ad=0.56p pd=2.56u as=0.56p ps=2.56u w=2u l=1u
X895 a_41854_3547# vbn a_41564_2967# VSS nfet_03v3 ad=0.9p pd=4.9u as=0.56p ps=2.56u w=2u l=1u
X896 VSS a_6206_4704# vg VSS nfet_03v3 ad=0.336p pd=1.76u as=0.336p ps=1.76u w=1.2u l=5.335u
X897 VSS vbnf VSS VSS nfet_03v3 ad=13.7592p pd=49.7u as=0 ps=0 w=49.14u l=10u
X898 VDD a_36866_9481# vbn VDD pfet_03v3 ad=6.3p pd=28.9u as=3.92p ps=14.56u w=14u l=14u
X899 a_36888_5287# vbn a_37178_5867# VSS nfet_03v3 ad=0.56p pd=2.56u as=0.56p ps=2.56u w=2u l=1u
X900 a_37178_1227# vbn w_36826_300# VSS nfet_03v3 ad=0.56p pd=2.56u as=0.56p ps=2.56u w=2u l=1u
X901 a_37178_2387# vbn a_36888_1807# VSS nfet_03v3 ad=0.56p pd=2.56u as=0.56p ps=2.56u w=2u l=1u
X902 a_36888_5287# vbn a_37178_4707# VSS nfet_03v3 ad=0.56p pd=2.56u as=0.56p ps=2.56u w=2u l=1u
X903 a_36866_9481# vbn a_37178_8187# VSS nfet_03v3 ad=0.56p pd=2.56u as=0.56p ps=2.56u w=2u l=1u
X904 VDD a_36866_9481# vbn VDD pfet_03v3 ad=3.92p pd=14.56u as=3.92p ps=14.56u w=14u l=14u
X905 a_36888_6447# vbn a_37178_7027# VSS nfet_03v3 ad=0.56p pd=2.56u as=0.56p ps=2.56u w=2u l=1u
X906 a_41564_7607# vbn a_41854_8187# VSS nfet_03v3 ad=0.56p pd=2.56u as=0.56p ps=2.56u w=2u l=1u
X907 a_1867_7085# a_1632_6633# vg VSS nfet_03v3 ad=0.9p pd=4.9u as=0.9p ps=4.9u w=2u l=0.28u
X908 a_37178_3547# vbn a_36888_4127# VSS nfet_03v3 ad=0.56p pd=2.56u as=0.56p ps=2.56u w=2u l=1u
X909 a_37178_1227# vbn a_36888_1807# VSS nfet_03v3 ad=0.56p pd=2.56u as=0.56p ps=2.56u w=2u l=1u
X910 a_36888_4127# vbn a_37178_4707# VSS nfet_03v3 ad=0.56p pd=2.56u as=0.56p ps=2.56u w=2u l=1u
X911 a_37178_5867# vbn a_36888_5287# VSS nfet_03v3 ad=0.56p pd=2.56u as=0.56p ps=2.56u w=2u l=1u
X912 w_36826_300# vbn a_37178_1227# VSS nfet_03v3 ad=0.56p pd=2.56u as=0.56p ps=2.56u w=2u l=1u
X913 a_41564_4127# vbn a_41854_3547# VSS nfet_03v3 ad=0.56p pd=2.56u as=0.56p ps=2.56u w=2u l=1u
X914 a_41854_7027# vbn a_41564_6447# VSS nfet_03v3 ad=0.9p pd=4.9u as=0.56p ps=2.56u w=2u l=1u
X915 a_36866_9481# vbn a_37178_8187# VSS nfet_03v3 ad=0.56p pd=2.56u as=0.56p ps=2.56u w=2u l=1u
X916 a_37178_4707# vbn a_36888_5287# VSS nfet_03v3 ad=0.56p pd=2.56u as=0.56p ps=2.56u w=2u l=1u
X917 a_36888_1807# vbn a_37178_1227# VSS nfet_03v3 ad=0.56p pd=2.56u as=0.56p ps=2.56u w=2u l=1u
X918 a_37178_4707# vbn a_36888_4127# VSS nfet_03v3 ad=0.56p pd=2.56u as=0.9p ps=4.9u w=2u l=1u
X919 a_36888_2967# vbn a_37178_2387# VSS nfet_03v3 ad=0.56p pd=2.56u as=0.56p ps=2.56u w=2u l=1u
X920 vbn a_60550_8387# a_36866_9481# VSS nfet_03v3 ad=0.45p pd=2.9u as=0.45p ps=2.9u w=1u l=0.28u
X921 a_41564_2967# vbn a_41854_3547# VSS nfet_03v3 ad=0.56p pd=2.56u as=0.56p ps=2.56u w=2u l=1u
X922 a_37178_1227# vbn a_36888_1807# VSS nfet_03v3 ad=0.56p pd=2.56u as=0.56p ps=2.56u w=2u l=1u
X923 w_36826_300# vbn a_37178_1227# VSS nfet_03v3 ad=0.56p pd=2.56u as=0.56p ps=2.56u w=2u l=1u
X924 a_37178_2387# vbn a_36888_2967# VSS nfet_03v3 ad=0.56p pd=2.56u as=0.56p ps=2.56u w=2u l=1u
X925 vg a_6206_14# VSS VSS nfet_03v3 ad=0.336p pd=1.76u as=0.54p ps=3.3u w=1.2u l=5.335u
X926 a_36866_9481# vbn a_37178_8187# VSS nfet_03v3 ad=0.56p pd=2.56u as=0.56p ps=2.56u w=2u l=1u
X927 a_37178_8187# vbn a_36888_7607# VSS nfet_03v3 ad=0.56p pd=2.56u as=0.56p ps=2.56u w=2u l=1u
X928 a_37178_5867# vbn a_36888_5287# VSS nfet_03v3 ad=0.56p pd=2.56u as=0.56p ps=2.56u w=2u l=1u
X929 a_41564_7607# vbn a_41854_8187# VSS nfet_03v3 ad=0.56p pd=2.56u as=0.56p ps=2.56u w=2u l=1u
X930 a_36888_5287# vbn a_37178_4707# VSS nfet_03v3 ad=0.56p pd=2.56u as=0.56p ps=2.56u w=2u l=1u
X931 a_36888_1807# vbn a_37178_1227# VSS nfet_03v3 ad=0.56p pd=2.56u as=0.56p ps=2.56u w=2u l=1u
X932 a_36888_6447# vbn a_37178_5867# VSS nfet_03v3 ad=0.56p pd=2.56u as=0.56p ps=2.56u w=2u l=1u
X933 a_36888_5287# vbn a_37178_5867# VSS nfet_03v3 ad=0.56p pd=2.56u as=0.56p ps=2.56u w=2u l=1u
X934 a_37178_4707# vbn a_36888_4127# VSS nfet_03v3 ad=0.56p pd=2.56u as=0.56p ps=2.56u w=2u l=1u
X935 a_41854_3547# vbn a_41564_4127# VSS nfet_03v3 ad=0.56p pd=2.56u as=0.56p ps=2.56u w=2u l=1u
X936 a_41564_6447# vbn a_41854_7027# VSS nfet_03v3 ad=0.56p pd=2.56u as=0.56p ps=2.56u w=2u l=1u
X937 w_36826_300# vbn a_37178_1227# VSS nfet_03v3 ad=0.56p pd=2.56u as=0.56p ps=2.56u w=2u l=1u
X938 a_37178_8187# vbn a_36866_9481# VSS nfet_03v3 ad=0.56p pd=2.56u as=0.9p ps=4.9u w=2u l=1u
X939 a_36888_1807# vbn a_37178_2387# VSS nfet_03v3 ad=0.56p pd=2.56u as=0.56p ps=2.56u w=2u l=1u
X940 a_36888_2967# vbn a_37178_2387# VSS nfet_03v3 ad=0.56p pd=2.56u as=0.56p ps=2.56u w=2u l=1u
X941 a_36888_5287# vbn a_37178_4707# VSS nfet_03v3 ad=0.56p pd=2.56u as=0.56p ps=2.56u w=2u l=1u
X942 a_37178_5867# vbn a_36888_5287# VSS nfet_03v3 ad=0.56p pd=2.56u as=0.56p ps=2.56u w=2u l=1u
X943 a_37178_5867# vbn a_36888_6447# VSS nfet_03v3 ad=0.56p pd=2.56u as=0.56p ps=2.56u w=2u l=1u
X944 vg a_6206_14# VSS VSS nfet_03v3 ad=0.336p pd=1.76u as=0.336p ps=1.76u w=1.2u l=5.335u
X945 a_37178_3547# vbn a_36888_2967# VSS nfet_03v3 ad=0.56p pd=2.56u as=0.56p ps=2.56u w=2u l=1u
X946 vg a_6206_4704# VSS VSS nfet_03v3 ad=0.336p pd=1.76u as=0.54p ps=3.3u w=1.2u l=5.335u
X947 a_36888_7607# vbn a_37178_7027# VSS nfet_03v3 ad=0.9p pd=4.9u as=0.56p ps=2.56u w=2u l=1u
X948 w_36826_300# vbn a_37178_1227# VSS nfet_03v3 ad=0.56p pd=2.56u as=0.56p ps=2.56u w=2u l=1u
X949 a_37178_8187# vbn a_36866_9481# VSS nfet_03v3 ad=0.56p pd=2.56u as=0.56p ps=2.56u w=2u l=1u
X950 a_36888_5287# vbn a_37178_5867# VSS nfet_03v3 ad=0.56p pd=2.56u as=0.56p ps=2.56u w=2u l=1u
X951 a_36888_5287# vbn a_37178_4707# VSS nfet_03v3 ad=0.56p pd=2.56u as=0.56p ps=2.56u w=2u l=1u
X952 a_41854_8187# vbn a_41564_7607# VSS nfet_03v3 ad=0.56p pd=2.56u as=0.56p ps=2.56u w=2u l=1u
X953 a_37178_2387# vbn a_36888_1807# VSS nfet_03v3 ad=0.56p pd=2.56u as=0.56p ps=2.56u w=2u l=1u
X954 a_36888_6447# vbn a_37178_5867# VSS nfet_03v3 ad=0.56p pd=2.56u as=0.56p ps=2.56u w=2u l=1u
X955 ls a_n3607_6703# VSS VSS nfet_03v3 ad=1.2p pd=4.4u as=0.54p ps=3.3u w=1.2u l=0.28u
X956 a_41854_4707# vbn a_41564_4127# VSS nfet_03v3 ad=0.56p pd=2.56u as=0.56p ps=2.56u w=2u l=1u
X957 a_37178_1227# vbn w_36826_300# VSS nfet_03v3 ad=0.56p pd=2.56u as=0.9p ps=4.9u w=2u l=1u
X958 vg a_6206_14# VSS VSS nfet_03v3 ad=0.336p pd=1.76u as=0.54p ps=3.3u w=1.2u l=5.335u
X959 a_37178_7027# vbn a_36888_6447# VSS nfet_03v3 ad=0.56p pd=2.56u as=0.56p ps=2.56u w=2u l=1u
X960 a_36888_2967# vbn a_37178_3547# VSS nfet_03v3 ad=0.56p pd=2.56u as=0.56p ps=2.56u w=2u l=1u
X961 a_36888_5287# vbn a_37178_4707# VSS nfet_03v3 ad=0.56p pd=2.56u as=0.56p ps=2.56u w=2u l=1u
X962 a_37178_2387# vbn a_36888_1807# VSS nfet_03v3 ad=0.56p pd=2.56u as=0.56p ps=2.56u w=2u l=1u
X963 a_41564_1807# vbn a_41854_1227# VSS nfet_03v3 ad=0.56p pd=2.56u as=0.56p ps=2.56u w=2u l=1u
X964 a_37178_7027# vbn a_36888_7607# VSS nfet_03v3 ad=0.56p pd=2.56u as=0.56p ps=2.56u w=2u l=1u
X965 a_37178_1227# vbn w_36826_300# VSS nfet_03v3 ad=0.56p pd=2.56u as=0.56p ps=2.56u w=2u l=1u
X966 w_37991_300# VSS VSS nplus_u r_width=2u r_length=100u
X967 a_36888_1807# vbn a_37178_2387# VSS nfet_03v3 ad=0.56p pd=2.56u as=0.56p ps=2.56u w=2u l=1u
X968 a_36888_6447# vbn a_37178_7027# VSS nfet_03v3 ad=0.56p pd=2.56u as=0.56p ps=2.56u w=2u l=1u
X969 a_37178_4707# vbn a_36888_5287# VSS nfet_03v3 ad=0.56p pd=2.56u as=0.9p ps=4.9u w=2u l=1u
X970 a_36888_4127# vbn a_37178_4707# VSS nfet_03v3 ad=0.56p pd=2.56u as=0.56p ps=2.56u w=2u l=1u
X971 a_37178_3547# vbn a_36888_2967# VSS nfet_03v3 ad=0.56p pd=2.56u as=0.56p ps=2.56u w=2u l=1u
X972 a_37178_2387# vbn a_36888_2967# VSS nfet_03v3 ad=0.56p pd=2.56u as=0.56p ps=2.56u w=2u l=1u
X973 a_41854_8187# vbn vbn VSS nfet_03v3 ad=0.56p pd=2.56u as=0.56p ps=2.56u w=2u l=1u
X974 a_996_6587# a_1867_7085# vg VSS nfet_03v3 ad=0.9p pd=4.9u as=0.9p ps=4.9u w=2u l=0.28u
X975 a_36888_7607# vbn a_37178_7027# VSS nfet_03v3 ad=0.9p pd=4.9u as=0.56p ps=2.56u w=2u l=1u
X976 a_41564_1807# vbn a_41854_1227# VSS nfet_03v3 ad=0.56p pd=2.56u as=0.56p ps=2.56u w=2u l=1u
X977 a_37178_2387# vbn a_36888_1807# VSS nfet_03v3 ad=0.56p pd=2.56u as=0.56p ps=2.56u w=2u l=1u
X978 a_37178_2387# vbn a_36888_2967# VSS nfet_03v3 ad=0.56p pd=2.56u as=0.56p ps=2.56u w=2u l=1u
X979 a_n7872_8894# VSS a_n2245_6719# VDD_LS pfet_03v3 ad=0.2808p pd=2.76u as=0.2808p ps=2.76u w=0.22u l=2u
X980 a_36888_4127# vbn a_37178_3547# VSS nfet_03v3 ad=0.9p pd=4.9u as=0.56p ps=2.56u w=2u l=1u
X981 vg vbnf VSS VSS nfet_03v3 ad=0.336p pd=1.76u as=0.336p ps=1.76u w=1.2u l=5.335u
X982 a_41564_5287# vbn a_41854_5867# VSS nfet_03v3 ad=0.56p pd=2.56u as=0.56p ps=2.56u w=2u l=1u
X983 a_37178_4707# vbn a_36888_5287# VSS nfet_03v3 ad=0.56p pd=2.56u as=0.56p ps=2.56u w=2u l=1u
X984 a_37178_2387# vbn a_36888_2967# VSS nfet_03v3 ad=0.56p pd=2.56u as=0.56p ps=2.56u w=2u l=1u
X985 a_36888_1807# vbn a_37178_2387# VSS nfet_03v3 ad=0.56p pd=2.56u as=0.56p ps=2.56u w=2u l=1u
X986 a_37178_7027# vbn a_36888_6447# VSS nfet_03v3 ad=0.56p pd=2.56u as=0.56p ps=2.56u w=2u l=1u
X987 a_37178_5867# vbn a_36888_6447# VSS nfet_03v3 ad=0.56p pd=2.56u as=0.56p ps=2.56u w=2u l=1u
X988 a_37178_4707# vbn a_36888_4127# VSS nfet_03v3 ad=0.56p pd=2.56u as=0.56p ps=2.56u w=2u l=1u
X989 a_36888_4127# vbn a_37178_4707# VSS nfet_03v3 ad=0.56p pd=2.56u as=0.56p ps=2.56u w=2u l=1u
X990 a_41854_1227# vbn a_41564_1807# VSS nfet_03v3 ad=0.56p pd=2.56u as=0.9p ps=4.9u w=2u l=1u
X991 vg vbnf VSS VSS nfet_03v3 ad=0.336p pd=1.76u as=0.336p ps=1.76u w=1.2u l=5.335u
X992 a_36866_9481# vbn a_37178_8187# VSS nfet_03v3 ad=0.56p pd=2.56u as=0.56p ps=2.56u w=2u l=1u
X993 a_41564_5287# vbn a_41854_5867# VSS nfet_03v3 ad=0.56p pd=2.56u as=0.56p ps=2.56u w=2u l=1u
X994 a_41854_2387# vbn a_41564_2967# VSS nfet_03v3 ad=0.56p pd=2.56u as=0.56p ps=2.56u w=2u l=1u
X995 a_41854_1227# vbn VSS VSS nfet_03v3 ad=0.56p pd=2.56u as=0.56p ps=2.56u w=2u l=1u
X996 VSS VDD_LS VSS VSS nfet_03v3 ad=13.7592p pd=49.7u as=0 ps=0 w=49.14u l=10u
X997 a_37178_5867# vbn a_36888_6447# VSS nfet_03v3 ad=0.56p pd=2.56u as=0.56p ps=2.56u w=2u l=1u
X998 a_37178_4707# vbn a_36888_4127# VSS nfet_03v3 ad=0.56p pd=2.56u as=0.56p ps=2.56u w=2u l=1u
X999 a_36888_2967# vbn a_37178_3547# VSS nfet_03v3 ad=0.56p pd=2.56u as=0.56p ps=2.56u w=2u l=1u
X1000 a_36888_2967# vbn a_37178_2387# VSS nfet_03v3 ad=0.56p pd=2.56u as=0.56p ps=2.56u w=2u l=1u
X1001 a_37178_5867# vbn a_36888_6447# VSS nfet_03v3 ad=0.56p pd=2.56u as=0.56p ps=2.56u w=2u l=1u
X1002 a_36888_7607# vbn a_37178_8187# VSS nfet_03v3 ad=0.9p pd=4.9u as=0.56p ps=2.56u w=2u l=1u
X1003 a_37178_8187# vbn a_36866_9481# VSS nfet_03v3 ad=0.56p pd=2.56u as=0.56p ps=2.56u w=2u l=1u
X1004 a_36866_9481# vbn a_37178_8187# VSS nfet_03v3 ad=0.56p pd=2.56u as=0.56p ps=2.56u w=2u l=1u
X1005 a_37178_3547# vbn a_36888_4127# VSS nfet_03v3 ad=0.56p pd=2.56u as=0.56p ps=2.56u w=2u l=1u
X1006 a_37178_3547# vbn a_36888_2967# VSS nfet_03v3 ad=0.56p pd=2.56u as=0.56p ps=2.56u w=2u l=1u
X1007 a_41854_5867# vbn a_41564_6447# VSS nfet_03v3 ad=0.56p pd=2.56u as=0.56p ps=2.56u w=2u l=1u
X1008 a_41854_5867# vbn a_41564_5287# VSS nfet_03v3 ad=0.56p pd=2.56u as=0.9p ps=4.9u w=2u l=1u
X1009 a_36888_2967# vbn a_37178_2387# VSS nfet_03v3 ad=0.56p pd=2.56u as=0.56p ps=2.56u w=2u l=1u
X1010 a_37178_7027# vbn a_36888_7607# VSS nfet_03v3 ad=0.56p pd=2.56u as=0.56p ps=2.56u w=2u l=1u
X1011 a_36888_6447# vbn a_37178_7027# VSS nfet_03v3 ad=0.56p pd=2.56u as=0.56p ps=2.56u w=2u l=1u
X1012 a_36888_6447# vbn a_37178_5867# VSS nfet_03v3 ad=0.56p pd=2.56u as=0.56p ps=2.56u w=2u l=1u
X1013 a_36888_4127# vbn a_37178_4707# VSS nfet_03v3 ad=0.56p pd=2.56u as=0.56p ps=2.56u w=2u l=1u
X1014 w_36826_300# vbn a_37178_1227# VSS nfet_03v3 ad=0.56p pd=2.56u as=0.56p ps=2.56u w=2u l=1u
X1015 a_37178_8187# vbn a_36866_9481# VSS nfet_03v3 ad=0.56p pd=2.56u as=0.56p ps=2.56u w=2u l=1u
X1016 a_36888_4127# vbn a_37178_3547# VSS nfet_03v3 ad=0.9p pd=4.9u as=0.56p ps=2.56u w=2u l=1u
X1017 a_41854_4707# vbn a_41564_5287# VSS nfet_03v3 ad=0.56p pd=2.56u as=0.56p ps=2.56u w=2u l=1u
X1018 VSS a_7096_6633# vg VSS nfet_03v3 ad=0.336p pd=1.76u as=0.336p ps=1.76u w=1.2u l=5.335u
X1019 a_41564_1807# vbn a_41854_2387# VSS nfet_03v3 ad=0.56p pd=2.56u as=0.56p ps=2.56u w=2u l=1u
X1020 a_37178_7027# vbn a_36888_6447# VSS nfet_03v3 ad=0.56p pd=2.56u as=0.56p ps=2.56u w=2u l=1u
X1021 a_36888_2967# vbn a_37178_2387# VSS nfet_03v3 ad=0.56p pd=2.56u as=0.56p ps=2.56u w=2u l=1u
X1022 a_36888_6447# vbn a_37178_5867# VSS nfet_03v3 ad=0.56p pd=2.56u as=0.56p ps=2.56u w=2u l=1u
X1023 a_37178_2387# vbn a_36888_2967# VSS nfet_03v3 ad=0.56p pd=2.56u as=0.9p ps=4.9u w=2u l=1u
X1024 a_37178_8187# vbn a_36888_7607# VSS nfet_03v3 ad=0.56p pd=2.56u as=0.56p ps=2.56u w=2u l=1u
X1025 a_37178_1227# vbn w_36826_300# VSS nfet_03v3 ad=0.56p pd=2.56u as=0.56p ps=2.56u w=2u l=1u
X1026 w_36826_300# vbn a_37178_1227# VSS nfet_03v3 ad=0.56p pd=2.56u as=0.56p ps=2.56u w=2u l=1u
X1027 a_36866_9481# vbn a_37178_8187# VSS nfet_03v3 ad=0.56p pd=2.56u as=0.56p ps=2.56u w=2u l=1u
X1028 VDD_LS a_n7601_6703# a_n8217_6703# VDD_LS pfet_03v3 ad=0.675p pd=3.9u as=1.5p ps=5u w=1.5u l=0.28u
X1029 a_36888_5287# vbn a_37178_4707# VSS nfet_03v3 ad=0.56p pd=2.56u as=0.56p ps=2.56u w=2u l=1u
X1030 a_37178_4707# vbn a_36888_4127# VSS nfet_03v3 ad=0.56p pd=2.56u as=0.56p ps=2.56u w=2u l=1u
X1031 a_36888_1807# vbn a_37178_1227# VSS nfet_03v3 ad=0.56p pd=2.56u as=0.56p ps=2.56u w=2u l=1u
X1032 a_36888_7607# vbn a_37178_8187# VSS nfet_03v3 ad=0.9p pd=4.9u as=0.56p ps=2.56u w=2u l=1u
X1033 a_41854_4707# vbn a_41564_4127# VSS nfet_03v3 ad=0.56p pd=2.56u as=0.9p ps=4.9u w=2u l=1u
X1034 a_41564_1807# vbn a_41854_2387# VSS nfet_03v3 ad=0.56p pd=2.56u as=0.56p ps=2.56u w=2u l=1u
X1035 a_37178_1227# vbn w_36826_300# VSS nfet_03v3 ad=0.56p pd=2.56u as=0.56p ps=2.56u w=2u l=1u
X1036 VSS a_6206_14# vg VSS nfet_03v3 ad=0.336p pd=1.76u as=0.336p ps=1.76u w=1.2u l=5.335u
X1037 a_37178_3547# vbn a_36888_2967# VSS nfet_03v3 ad=0.56p pd=2.56u as=0.56p ps=2.56u w=2u l=1u
X1038 a_37178_2387# vbn a_36888_2967# VSS nfet_03v3 ad=0.56p pd=2.56u as=0.9p ps=4.9u w=2u l=1u
X1039 a_36888_6447# vbn a_37178_5867# VSS nfet_03v3 ad=0.56p pd=2.56u as=0.56p ps=2.56u w=2u l=1u
X1040 a_36888_7607# vbn a_37178_7027# VSS nfet_03v3 ad=0.56p pd=2.56u as=0.56p ps=2.56u w=2u l=1u
X1041 a_37178_5867# vbn a_36888_6447# VSS nfet_03v3 ad=0.56p pd=2.56u as=0.9p ps=4.9u w=2u l=1u
X1042 a_41564_1807# vbn a_41854_1227# VSS nfet_03v3 ad=0.56p pd=2.56u as=0.56p ps=2.56u w=2u l=1u
X1043 a_37178_4707# vbn a_36888_5287# VSS nfet_03v3 ad=0.56p pd=2.56u as=0.56p ps=2.56u w=2u l=1u
X1044 a_36888_4127# vbn a_37178_4707# VSS nfet_03v3 ad=0.56p pd=2.56u as=0.56p ps=2.56u w=2u l=1u
X1045 a_36888_5287# vbn a_37178_4707# VSS nfet_03v3 ad=0.56p pd=2.56u as=0.56p ps=2.56u w=2u l=1u
X1046 a_41854_2387# vbn a_41564_1807# VSS nfet_03v3 ad=0.56p pd=2.56u as=0.9p ps=4.9u w=2u l=1u
X1047 a_36888_5287# vbn a_37178_5867# VSS nfet_03v3 ad=0.56p pd=2.56u as=0.56p ps=2.56u w=2u l=1u
X1048 a_37178_2387# vbn a_36888_2967# VSS nfet_03v3 ad=0.56p pd=2.56u as=0.56p ps=2.56u w=2u l=1u
X1049 a_37178_8187# vbn a_36866_9481# VSS nfet_03v3 ad=0.56p pd=2.56u as=0.56p ps=2.56u w=2u l=1u
X1050 w_36826_300# vbn a_37178_1227# VSS nfet_03v3 ad=0.56p pd=2.56u as=0.56p ps=2.56u w=2u l=1u
X1051 VDD vg VDD VDD pfet_03v3 ad=8.3496p pd=30.38u as=0 ps=0 w=29.82u l=4.12u
X1052 a_36888_1807# vbn a_37178_1227# VSS nfet_03v3 ad=0.9p pd=4.9u as=0.56p ps=2.56u w=2u l=1u
X1053 a_37178_3547# vbn a_36888_4127# VSS nfet_03v3 ad=0.56p pd=2.56u as=0.56p ps=2.56u w=2u l=1u
X1054 a_37178_2387# vbn a_36888_2967# VSS nfet_03v3 ad=0.56p pd=2.56u as=0.56p ps=2.56u w=2u l=1u
X1055 a_41854_8187# vbn vbn VSS nfet_03v3 ad=0.56p pd=2.56u as=0.9p ps=4.9u w=2u l=1u
X1056 a_37178_4707# vbn a_36888_5287# VSS nfet_03v3 ad=0.56p pd=2.56u as=0.56p ps=2.56u w=2u l=1u
X1057 a_37178_5867# vbn a_36888_6447# VSS nfet_03v3 ad=0.56p pd=2.56u as=0.9p ps=4.9u w=2u l=1u
X1058 a_37178_7027# vbn a_36888_6447# VSS nfet_03v3 ad=0.56p pd=2.56u as=0.56p ps=2.56u w=2u l=1u
X1059 a_36888_7607# vbn a_37178_7027# VSS nfet_03v3 ad=0.56p pd=2.56u as=0.56p ps=2.56u w=2u l=1u
X1060 a_37178_7027# vbn a_36888_7607# VSS nfet_03v3 ad=0.56p pd=2.56u as=0.56p ps=2.56u w=2u l=1u
X1061 VSS vbnf VSS VSS nfet_03v3 ad=13.7592p pd=49.7u as=0 ps=0 w=49.14u l=10u
X1062 a_37178_1227# vbn a_36888_1807# VSS nfet_03v3 ad=0.56p pd=2.56u as=0.56p ps=2.56u w=2u l=1u
X1063 a_37178_4707# vbn a_36888_4127# VSS nfet_03v3 ad=0.56p pd=2.56u as=0.56p ps=2.56u w=2u l=1u
X1064 a_41564_5287# vbn a_41854_5867# VSS nfet_03v3 ad=0.56p pd=2.56u as=0.56p ps=2.56u w=2u l=1u
X1065 a_37178_5867# vbn a_36888_6447# VSS nfet_03v3 ad=0.56p pd=2.56u as=0.56p ps=2.56u w=2u l=1u
X1066 a_36888_7607# vbn a_37178_7027# VSS nfet_03v3 ad=0.56p pd=2.56u as=0.56p ps=2.56u w=2u l=1u
X1067 a_36866_9481# vbn a_37178_8187# VSS nfet_03v3 ad=0.56p pd=2.56u as=0.56p ps=2.56u w=2u l=1u
X1068 a_37178_2387# vbn a_36888_2967# VSS nfet_03v3 ad=0.56p pd=2.56u as=0.56p ps=2.56u w=2u l=1u
X1069 a_37178_8187# vbn a_36888_7607# VSS nfet_03v3 ad=0.56p pd=2.56u as=0.56p ps=2.56u w=2u l=1u
X1070 a_37178_5867# vbn a_36888_6447# VSS nfet_03v3 ad=0.56p pd=2.56u as=0.56p ps=2.56u w=2u l=1u
X1071 a_36888_5287# vbn a_37178_4707# VSS nfet_03v3 ad=0.56p pd=2.56u as=0.56p ps=2.56u w=2u l=1u
X1072 vbnf bitb1 a_7096_6633# VDD pfet_03v3 ad=2.25p pd=10.9u as=2.25p ps=10.9u w=5u l=0.28u
X1073 a_36888_5287# vbn a_37178_5867# VSS nfet_03v3 ad=0.9p pd=4.9u as=0.56p ps=2.56u w=2u l=1u
X1074 a_41854_3547# vbn a_41564_2967# VSS nfet_03v3 ad=0.9p pd=4.9u as=0.56p ps=2.56u w=2u l=1u
X1075 a_41854_2387# vbn a_41564_2967# VSS nfet_03v3 ad=0.56p pd=2.56u as=0.56p ps=2.56u w=2u l=1u
X1076 a_37178_1227# vbn w_36826_300# VSS nfet_03v3 ad=0.56p pd=2.56u as=0.56p ps=2.56u w=2u l=1u
X1077 a_41854_1227# vbn VSS VSS nfet_03v3 ad=0.56p pd=2.56u as=0.9p ps=4.9u w=2u l=1u
X1078 a_36888_1807# vbn a_37178_1227# VSS nfet_03v3 ad=0.56p pd=2.56u as=0.56p ps=2.56u w=2u l=1u
X1079 vbnf bit3 a_6206_896# VSS nfet_03v3 ad=0.9p pd=4.9u as=0.9p ps=4.9u w=2u l=0.28u
X1080 a_36888_2967# vbn a_37178_2387# VSS nfet_03v3 ad=0.56p pd=2.56u as=0.56p ps=2.56u w=2u l=1u
X1081 a_37178_5867# vbn a_36888_5287# VSS nfet_03v3 ad=0.56p pd=2.56u as=0.56p ps=2.56u w=2u l=1u
X1082 a_37178_7027# vbn a_36888_7607# VSS nfet_03v3 ad=0.56p pd=2.56u as=0.56p ps=2.56u w=2u l=1u
X1083 a_36888_4127# vbn a_37178_3547# VSS nfet_03v3 ad=0.56p pd=2.56u as=0.56p ps=2.56u w=2u l=1u
X1084 a_37178_8187# vbn a_36866_9481# VSS nfet_03v3 ad=0.56p pd=2.56u as=0.56p ps=2.56u w=2u l=1u
X1085 a_37178_5867# vbn a_36888_6447# VSS nfet_03v3 ad=0.56p pd=2.56u as=0.56p ps=2.56u w=2u l=1u
X1086 a_41564_2967# vbn a_41854_3547# VSS nfet_03v3 ad=0.56p pd=2.56u as=0.56p ps=2.56u w=2u l=1u
X1087 w_36826_300# vbn a_37178_1227# VSS nfet_03v3 ad=0.56p pd=2.56u as=0.56p ps=2.56u w=2u l=1u
X1088 a_41854_7027# vbn a_41564_6447# VSS nfet_03v3 ad=0.9p pd=4.9u as=0.56p ps=2.56u w=2u l=1u
X1089 a_41854_5867# vbn a_41564_6447# VSS nfet_03v3 ad=0.56p pd=2.56u as=0.56p ps=2.56u w=2u l=1u
X1090 a_37178_4707# vbn a_36888_5287# VSS nfet_03v3 ad=0.56p pd=2.56u as=0.56p ps=2.56u w=2u l=1u
X1091 a_36888_1807# vbn a_37178_2387# VSS nfet_03v3 ad=0.56p pd=2.56u as=0.56p ps=2.56u w=2u l=1u
X1092 a_36888_2967# vbn a_37178_2387# VSS nfet_03v3 ad=0.56p pd=2.56u as=0.56p ps=2.56u w=2u l=1u
X1093 a_36888_7607# vbn a_37178_7027# VSS nfet_03v3 ad=0.56p pd=2.56u as=0.56p ps=2.56u w=2u l=1u
X1094 a_41854_4707# vbn a_41564_5287# VSS nfet_03v3 ad=0.56p pd=2.56u as=0.9p ps=4.9u w=2u l=1u
X1095 a_452_6633# a0 VDD VDD pfet_03v3 ad=2.25p pd=10.9u as=2.25p ps=10.9u w=5u l=0.28u
X1096 a_36888_6447# vbn a_37178_5867# VSS nfet_03v3 ad=0.56p pd=2.56u as=0.56p ps=2.56u w=2u l=1u
X1097 a_36888_5287# vbn a_37178_5867# VSS nfet_03v3 ad=0.56p pd=2.56u as=0.56p ps=2.56u w=2u l=1u
X1098 a_36888_4127# vbn a_37178_3547# VSS nfet_03v3 ad=0.56p pd=2.56u as=0.56p ps=2.56u w=2u l=1u
X1099 a_37178_3547# vbn a_36888_4127# VSS nfet_03v3 ad=0.56p pd=2.56u as=0.56p ps=2.56u w=2u l=1u
X1100 VSS VDD_LS VSS VSS nfet_03v3 ad=13.7592p pd=49.7u as=0 ps=0 w=49.14u l=10u
X1101 a_36888_7607# vbn a_37178_8187# VSS nfet_03v3 ad=0.56p pd=2.56u as=0.56p ps=2.56u w=2u l=1u
X1102 a_36888_4127# vbn a_37178_4707# VSS nfet_03v3 ad=0.56p pd=2.56u as=0.56p ps=2.56u w=2u l=1u
X1103 a_41564_1807# vbn a_41854_2387# VSS nfet_03v3 ad=0.56p pd=2.56u as=0.56p ps=2.56u w=2u l=1u
X1104 a_41854_2387# vbn a_41564_2967# VSS nfet_03v3 ad=0.9p pd=4.9u as=0.56p ps=2.56u w=2u l=1u
X1105 a_41564_6447# vbn a_41854_7027# VSS nfet_03v3 ad=0.56p pd=2.56u as=0.56p ps=2.56u w=2u l=1u
X1106 a_36888_4127# vbn a_37178_3547# VSS nfet_03v3 ad=0.56p pd=2.56u as=0.56p ps=2.56u w=2u l=1u
X1107 a_37178_1227# vbn w_36826_300# VSS nfet_03v3 ad=0.56p pd=2.56u as=0.56p ps=2.56u w=2u l=1u
X1108 a_36888_7607# vbn a_37178_7027# VSS nfet_03v3 ad=0.56p pd=2.56u as=0.56p ps=2.56u w=2u l=1u
X1109 a_36888_5287# vbn a_37178_4707# VSS nfet_03v3 ad=0.56p pd=2.56u as=0.56p ps=2.56u w=2u l=1u
X1110 a_36888_6447# vbn a_37178_5867# VSS nfet_03v3 ad=0.56p pd=2.56u as=0.56p ps=2.56u w=2u l=1u
C0 a_996_6587# VDD 1.38472f
C1 vbn a_60550_8387# 0.27863f
C2 a_36866_9481# VDD 28.8396f
C3 a_6356_6633# a_6206_14# 0.21414f
C4 a_n4642_7514# a_n5234_7514# 0.88042f
C5 a_36888_7607# a_36866_9481# 0.17366f
C6 a_41854_4707# a_41564_4127# 2.37452f
C7 a_6206_896# a_6206_4704# 4.47742f
C8 vctrl VDD 0.0024f
C9 bit0 bit1 0.02757f
C10 a_41854_7027# a_36888_6447# 0.03482f
C11 a_36866_9481# a_41564_7607# 0
C12 a_1632_6633# vg 0.4138f
C13 a_n7286_7514# a_n4810_7514# 0
C14 a_41854_5867# a_36888_6447# 2.91652f
C15 a_36888_1807# w_36826_300# 0.1968f
C16 a_n7286_7514# a_n6862_7514# 0.00388f
C17 a_n3101_6703# ls 0.12117f
C18 a_41854_4707# a_36888_5287# 2.91652f
C19 a_n5549_6703# a_n7601_6703# 0.0098f
C20 vctrl a_36888_4127# 0.00108f
C21 a_36866_9481# a_37178_8187# 9.66738f
C22 a_37178_5867# a_36888_5287# 11.0476f
C23 a_996_6587# a_1632_6633# 0.37969f
C24 a_452_6633# vg 0.52714f
C25 a_36888_2967# a_41564_1807# 0.00177f
C26 a_36888_7607# a_41564_6447# 0.00177f
C27 VDD bit1 0.39958f
C28 bitb0 vg 1.37238f
C29 a_n6694_7514# a_n7601_6703# 0.70254f
C30 a_37178_5867# a_36888_7607# 0
C31 a_n5549_6703# q1 0.74328f
C32 a_41854_4707# a_41854_3547# 0.05596f
C33 a_36888_1807# vbn 13.1706f
C34 a_996_6587# a_452_6633# 0.39821f
C35 a_41564_6447# a_41564_7607# 0.05596f
C36 a_n5549_6703# a_n7872_8894# 0.00156f
C37 a_37178_2387# a_37178_1227# 0
C38 a_n6694_7514# q1 0.67113f
C39 a_996_6587# VDD_LS 0
C40 a_6206_4704# bitb1 0
C41 a_n5549_6703# VDD_LS 0.58961f
C42 a_41854_4707# a_36888_4127# 0.03482f
C43 a_n7286_7514# a_n5234_7514# 0.00334f
C44 a_41854_7027# a_36888_7607# 2.91652f
C45 a_n6694_7514# a_n7872_8894# 0
C46 a_41854_5867# a_36888_5287# 0.03482f
C47 a_37178_5867# a_36888_4127# 0
C48 a_41564_2967# vbn 3.48625f
C49 a_37178_3547# a_37178_4707# 0.01838f
C50 VDD_LS a_n6694_7514# 0.21816f
C51 a_37178_3547# a_37178_2387# 0.01838f
C52 a_6206_896# bitb1 0
C53 a_n3101_6703# a_n5234_7514# 0
C54 a_41564_5287# a_41564_6447# 0.05596f
C55 a_41854_7027# a_41564_7607# 2.37431f
C56 a_41564_5287# a_41854_4707# 2.37431f
C57 a_41564_5287# a_37178_5867# 2.88648f
C58 a_41854_1227# a_37178_1227# 4.04491f
C59 a_6206_4704# bit2 0.04998f
C60 vbn a_41854_8187# 6.27374f
C61 a_n6436_6531# a_n7601_6703# 0.00463f
C62 a_41854_2387# vbn 3.49251f
C63 a_41854_7027# a_37178_8187# 0.00115f
C64 ls a_n3607_6703# 0.96168f
C65 a_41564_1807# a_37178_1227# 0.03322f
C66 ls a_n2245_6719# 0
C67 bitb4 vbnf 0.17851f
C68 a_6206_896# bit2 0.01215f
C69 a_n6436_6531# q1 0.00604f
C70 bitb4 bitb3 0.01415f
C71 a_n3101_6703# a_n4642_7514# 0
C72 a_41854_1227# a_37178_2387# 0
C73 a_n7286_7514# a_n7180_6531# 0.00757f
C74 a_6206_14# vg 5.82132f
C75 a_41564_5287# a_41854_5867# 2.37452f
C76 a_6356_6633# vg 1.06397f
C77 a_6206_4704# vbnf 11.0435f
C78 a_7096_6633# a_6206_4704# 3.99805f
C79 a_n6436_6531# VDD_LS 0.00406f
C80 a_6206_4704# bitb3 0.00123f
C81 a_41564_1807# a_37178_2387# 0.72603f
C82 a_6206_14# bitb2 0
C83 w_36826_300# vctrl 0.07808f
C84 a_36888_2967# a_41854_3547# 0.03482f
C85 a_36866_9481# a_60550_8387# 0.14595f
C86 a_36888_1807# a_41854_2387# 0.0269f
C87 a_6206_896# vbnf 8.01765f
C88 a_6206_896# a_7096_6633# 0.6087f
C89 a_n7286_7514# ck 0
C90 a_6206_4704# bit0 0
C91 a_6206_896# bitb3 0.21489f
C92 a_n5128_6451# a_n5549_6703# 0.07726f
C93 a_36866_9481# vbn 53.2906f
C94 a_6206_14# vctrl 0.19159f
C95 a_36888_2967# a_36888_4127# 0.18664f
C96 a_6356_6633# vctrl 3.22782f
C97 a_n3607_6703# a_n5234_7514# 0.003f
C98 VDD bitb4 0.69669f
C99 vbn vctrl 1.86478f
C100 a_6206_896# bit0 0.00331f
C101 ls q1 0.00995f
C102 a_41564_2967# a_41854_2387# 2.37431f
C103 a_n6862_7514# a_n7601_6703# 0.01101f
C104 a_37178_7027# a_36888_6447# 11.0476f
C105 a_36888_6447# a_37178_4707# 0
C106 a_41854_1227# a_41564_1807# 2.37431f
C107 bit3 bitb4 1.85602f
C108 ls a_n7872_8894# 0.33461f
C109 a_6206_4704# VDD 0.20804f
C110 a_37178_3547# a_41564_4127# 0.03322f
C111 a_n6862_7514# q1 0.01095f
C112 a_n4810_7514# a_n7872_8894# 0
C113 ls VDD_LS 1.22951f
C114 a_41564_4127# a_37178_4707# 2.88648f
C115 a_n8217_6703# a_n6694_7514# 0
C116 a_6206_14# bit1 0
C117 a_6206_4704# bit3 0
C118 VDD_LS a_n4810_7514# 0.23085f
C119 a_n6862_7514# a_n7872_8894# 0
C120 a_41564_6447# vbn 3.48625f
C121 a_n4642_7514# a_n3607_6703# 0.08987f
C122 a_6206_896# VDD 0.21312f
C123 vbn a_41854_4707# 3.49251f
C124 VDD_LS a_n6862_7514# 0.14459f
C125 a_37178_5867# vbn 12.4223f
C126 a_n5234_7514# a_n7601_6703# 0
C127 a_36888_1807# vctrl 2.4556f
C128 bitb1 vbnf 0.1755f
C129 a_7096_6633# bitb1 0.21396f
C130 a_6206_896# bit3 0.05328f
C131 a_n4384_6451# a_n5549_6703# 0.0061f
C132 a_37178_3547# a_36888_5287# 0
C133 a_37178_7027# a_36888_5287# 0
C134 a_36888_5287# a_37178_4707# 10.9862f
C135 a_n5234_7514# q1 0.00721f
C136 bit0 bitb1 1.85602f
C137 a_41854_7027# vbn 3.49334f
C138 a_36888_7607# a_37178_7027# 10.9862f
C139 a_41564_2967# vctrl 0
C140 a_37178_3547# a_41854_3547# 4.03621f
C141 a_n5234_7514# a_n7872_8894# 0
C142 a_37178_4707# a_41854_3547# 0.00115f
C143 bit2 vbnf 0.19681f
C144 a_41854_5867# vbn 3.49251f
C145 VDD_LS a_n5234_7514# 0.51666f
C146 bit2 bitb3 1.85602f
C147 a_37178_7027# a_41564_7607# 0.03322f
C148 a_36866_9481# a_41854_8187# 1.20914f
C149 a_6206_4704# bitb0 0
C150 a_37178_3547# a_36888_4127# 10.9862f
C151 a_37178_4707# a_36888_4127# 11.0476f
C152 a_37178_2387# a_36888_4127# 0
C153 a_n4642_7514# q1 0
C154 VDD bitb1 0.69643f
C155 a_41854_2387# vctrl 0.3277f
C156 a_37178_7027# a_37178_8187# 0.01838f
C157 a_6206_896# bitb0 0
C158 a_n7180_6531# a_n7601_6703# 0.04749f
C159 a_7096_6633# vbnf 4.66746f
C160 a_n4642_7514# VDD_LS 0.26831f
C161 a_n5128_6451# ls 0.01045f
C162 a_996_6587# vg 0.4584f
C163 a_41564_5287# a_37178_4707# 0.03322f
C164 bitb3 vbnf 0.17647f
C165 a_n7180_6531# q1 0.00689f
C166 a_n3101_6703# a_n3607_6703# 1.04229f
C167 a_n7601_6703# ck 0.00938f
C168 a_n3101_6703# a_n2245_6719# 0.20859f
C169 vctrl vg 1.00629f
C170 VDD bit2 0.39961f
C171 a_7096_6633# bit0 0.00884f
C172 bit0 vbnf 0.19018f
C173 a_36888_2967# vbn 13.2571f
C174 a_1867_7085# VDD 1.30999f
C175 VDD_LS a_n7180_6531# 0.00222f
C176 q1 ck 0
C177 bit3 bit2 0.02757f
C178 a_36888_6447# a_36888_5287# 0.18664f
C179 a_n5549_6703# a_n6694_7514# 0.00175f
C180 a_n7286_7514# a_n7601_6703# 0.71835f
C181 a_n7872_8894# ck 0
C182 bit4 bitb4 0.79928f
C183 a_41854_7027# a_41854_8187# 0.05596f
C184 a_6206_14# bitb4 0.21399f
C185 VDD_LS ck 0.92368f
C186 a_36888_7607# a_36888_6447# 0.18664f
C187 VDD vbnf 5.68903f
C188 a_7096_6633# VDD 0.19817f
C189 vg bit1 0
C190 a_36888_5287# a_41564_4127# 0.00177f
C191 bitb0 bitb1 0.01415f
C192 a_n7286_7514# q1 1.29375f
C193 VDD bitb3 0.69649f
C194 a_6206_4704# bit4 0
C195 a_n5128_6451# a_n5234_7514# 0.01134f
C196 a_n4384_6451# ls 0.01106f
C197 a_36888_1807# a_36888_2967# 0.17041f
C198 a_6206_4704# a_6206_14# 7.70065f
C199 bit3 vbnf 0.19848f
C200 bitb2 bit1 1.85602f
C201 a_6356_6633# a_6206_4704# 0.20544f
C202 a_n7286_7514# a_n7872_8894# 0
C203 w_36826_300# a_37178_1227# 12.307f
C204 bit3 bitb3 0.79928f
C205 a_1867_7085# a_1632_6633# 0.37174f
C206 VDD bit0 0.40332f
C207 VDD_LS a_n7286_7514# 0.40251f
C208 a_41564_4127# a_41854_3547# 2.37431f
C209 a_6206_896# bit4 0.00331f
C210 a_n2245_6719# a0 1.9857f
C211 a_6206_896# a_6206_14# 8.81578f
C212 a_6206_896# a_6356_6633# 3.25671f
C213 a_n3101_6703# a_n7872_8894# 0.00642f
C214 a0 VDD 1.58817f
C215 a_36888_6447# a_37178_8187# 0
C216 a_41564_2967# a_36888_2967# 4.1149f
C217 a_452_6633# a_1867_7085# 0.02066f
C218 a_41564_4127# a_36888_4127# 4.1149f
C219 a_n3101_6703# VDD_LS 0.28227f
C220 vbn a_37178_1227# 12.5272f
C221 a_n2245_6719# a_n3607_6703# 0.00588f
C222 w_36826_300# a_37178_2387# 0.00101f
C223 a_41564_5287# a_36888_6447# 0.00177f
C224 a_n6436_6531# a_n6694_7514# 0.00564f
C225 a_37178_3547# vbn 12.4223f
C226 a_41564_5287# a_41564_4127# 0.05596f
C227 a_n4384_6451# a_n5234_7514# 0.07136f
C228 VDD bit3 0.39972f
C229 a_41854_2387# a_36888_2967# 2.91652f
C230 a_37178_7027# vbn 12.4252f
C231 vbn a_37178_4707# 12.4223f
C232 bitb0 vbnf 0.0727f
C233 a_7096_6633# bitb0 0
C234 a_37178_2387# vbn 11.9387f
C235 a_36888_5287# a_36888_4127# 0.18664f
C236 a_37178_5867# a_41564_6447# 0.03322f
C237 a_36888_7607# a_41564_7607# 4.1149f
C238 a_37178_5867# a_41854_4707# 0.00115f
C239 a0 a_1632_6633# 0.00356f
C240 a_41854_1227# w_36826_300# 0.05949f
C241 a_36888_1807# a_37178_1227# 10.9861f
C242 bitb0 bit0 0.79928f
C243 VDD a_37178_8187# 0.00193f
C244 a_41854_3547# a_36888_4127# 2.91652f
C245 a_36888_7607# a_37178_8187# 11.0477f
C246 a_6206_14# bitb1 0
C247 a_41564_5287# a_36888_5287# 4.1149f
C248 a_6356_6633# bitb1 0.00121f
C249 a_41854_7027# a_41564_6447# 2.37452f
C250 a0 a_n7872_8894# 0.00459f
C251 VDD a_1632_6633# 1.51639f
C252 a_452_6633# a0 0.60056f
C253 ls a_n5549_6703# 1.56506f
C254 a_n4384_6451# a_n4642_7514# 0.00911f
C255 a_36888_1807# a_37178_3547# 0
C256 VDD_LS a0 0.0349f
C257 a_41854_1227# vbn 3.47973f
C258 a_n5549_6703# a_n4810_7514# 0.01794f
C259 a_41564_7607# a_37178_8187# 2.88648f
C260 a_41564_6447# a_41854_5867# 2.37431f
C261 a_41854_5867# a_41854_4707# 0.05596f
C262 ls a_n6694_7514# 0
C263 a_n3607_6703# a_n7872_8894# 0
C264 a_36888_1807# a_37178_2387# 10.222f
C265 a_n2245_6719# a_n7872_8894# 0.22692f
C266 a_n8217_6703# ck 1.12832f
C267 a_37178_5867# a_41854_5867# 4.03621f
C268 VDD a_n7872_8894# 0.02233f
C269 a_452_6633# VDD 1.2f
C270 VDD_LS a_n3607_6703# 0.39275f
C271 a_41564_1807# vbn 3.27202f
C272 bitb0 VDD 0.78238f
C273 w_36826_300# w_37991_300# 0.09601f
C274 VDD_LS a_n2245_6719# 0.33992f
C275 a_6206_14# bit2 0
C276 VDD_LS VDD 0.03331f
C277 a_41564_2967# a_37178_3547# 2.88648f
C278 a_n6862_7514# a_n6694_7514# 0.08507f
C279 a_36888_2967# vctrl 0.07604f
C280 a_41564_2967# a_37178_2387# 0.03322f
C281 a_n7286_7514# a_n8217_6703# 0.00738f
C282 a_41854_7027# a_41854_5867# 0.05596f
C283 a_6206_4704# vg 2.53191f
C284 vbn w_37991_300# 0.00346f
C285 a_n7601_6703# q1 1.57175f
C286 a_41854_1227# a_36888_1807# 2.91652f
C287 bit4 vbnf 1.13336f
C288 a_n5549_6703# a_n5234_7514# 0.74379f
C289 a_n7601_6703# a_n7872_8894# 0.00167f
C290 a_37178_3547# a_41854_2387# 0.00115f
C291 a_6206_14# vbnf 9.72296f
C292 a_7096_6633# a_6206_14# 1.30715f
C293 a_6356_6633# vbnf 1.13433f
C294 a_6206_4704# bitb2 0.21396f
C295 a_6356_6633# a_7096_6633# 0.51329f
C296 a_36888_6447# vbn 13.2616f
C297 a_36888_1807# a_41564_1807# 4.00658f
C298 a_6206_896# vg 3.03622f
C299 vbn vbnf 0.01083f
C300 a_6206_14# bitb3 0
C301 VDD_LS a_n7601_6703# 0.45003f
C302 a_452_6633# a_1632_6633# 0.1528f
C303 a_41854_2387# a_37178_2387# 3.97376f
C304 a_n6694_7514# a_n5234_7514# 0
C305 q1 a_n7872_8894# 0.00168f
C306 a_6206_896# bitb2 0.00104f
C307 vbn a_41564_4127# 3.48625f
C308 a_6206_14# bit0 0
C309 a_6206_4704# vctrl 0.17004f
C310 a_6356_6633# bit0 0.04998f
C311 VDD_LS q1 0.47949f
C312 a_41564_2967# a_41564_1807# 0.05596f
C313 a_n3101_6703# a_n4384_6451# 0
C314 a_n4642_7514# a_n5549_6703# 0.70987f
C315 VDD_LS a_n7872_8894# 2.59119f
C316 VDD_LS a_452_6633# 0
C317 a_6206_896# vctrl 0.30122f
C318 a_60550_8387# VDD 0.05007f
C319 a_37178_1227# vctrl 0.06613f
C320 a_36888_7607# a_60550_8387# 0.01558f
C321 a_n4642_7514# a_n6694_7514# 0.00248f
C322 VDD bit4 0.45851f
C323 a_41854_1227# a_41854_2387# 0.05596f
C324 vbn a_36888_5287# 13.2616f
C325 a_6206_14# VDD 0.2224f
C326 a_6356_6633# VDD 0.26171f
C327 a_6206_4704# bit1 0.00886f
C328 vbn VDD 0.61636f
C329 a_41854_2387# a_41564_1807# 2.34764f
C330 bit4 bit3 0.02757f
C331 a_36888_7607# vbn 13.2849f
C332 a_37178_3547# vctrl 0.01256f
C333 a_6206_14# bit3 0.00887f
C334 vg bitb1 0.00141f
C335 vbn a_41854_3547# 3.49251f
C336 a_37178_2387# vctrl 8.43974f
C337 ls a_n4810_7514# 0.02307f
C338 a_6206_896# bit1 0.00331f
C339 vbn a_41564_7607# 3.54873f
C340 a_60550_8387# a_37178_8187# 0.0117f
C341 bitb2 bitb1 0.01415f
C342 a_41564_2967# a_41564_4127# 0.05596f
C343 vbn a_36888_4127# 13.2616f
C344 a_n6694_7514# ck 0
C345 vbn a_37178_8187# 12.6636f
C346 a_41564_6447# a_37178_7027# 2.88648f
C347 a_n5549_6703# a_n7286_7514# 0.00223f
C348 a_41854_4707# a_37178_4707# 4.03621f
C349 a_1867_7085# vg 0.52997f
C350 a_41564_5287# vbn 3.48625f
C351 a_37178_5867# a_37178_7027# 0.01838f
C352 a_37178_5867# a_37178_4707# 0.01838f
C353 a_41854_1227# vctrl 0.00174f
C354 bitb2 bit2 0.79928f
C355 a_n7286_7514# a_n6694_7514# 0.87554f
C356 ls a_n5234_7514# 1.35416f
C357 a_6206_14# bitb0 0
C358 a_n3101_6703# a_n5549_6703# 0
C359 a_n8217_6703# a_n7601_6703# 0.7483f
C360 a_41564_1807# vctrl 4.74781f
C361 a_6356_6633# bitb0 0.21396f
C362 a_996_6587# a_1867_7085# 0.34397f
C363 a_n5234_7514# a_n4810_7514# 0.00509f
C364 vg vbnf 1.37475f
C365 a_n5128_6451# VDD_LS 0.00198f
C366 a_41854_7027# a_37178_7027# 4.03621f
C367 a_7096_6633# vg 3.92909f
C368 a_41564_2967# a_41854_3547# 2.37452f
C369 bit1 bitb1 0.79928f
C370 a_n8217_6703# q1 0.00656f
C371 a_37178_7027# a_41854_5867# 0.00115f
C372 a_7096_6633# bitb2 0.00121f
C373 bitb2 vbnf 0.1755f
C374 a_n8217_6703# a_n7872_8894# 0
C375 a_41854_8187# VDD 0.00481f
C376 bitb2 bitb3 0.01415f
C377 a_36888_7607# a_41854_8187# 0.03482f
C378 a_41564_2967# a_36888_4127# 0.00177f
C379 vg bit0 0.02208f
C380 a_n4642_7514# ls 0.63671f
C381 VDD_LS a_n8217_6703# 0.37512f
C382 a_n4642_7514# a_n4810_7514# 0.14135f
C383 a_41854_2387# a_41854_3547# 0.05596f
C384 vctrl vbnf 3.18603f
C385 a_7096_6633# vctrl 0.04912f
C386 a0 vg 0.40525f
C387 bit2 bit1 0.02757f
C388 a_41854_8187# a_41564_7607# 2.37452f
C389 a_n6436_6531# a_n7286_7514# 0.04322f
C390 a_6206_4704# bitb4 0
C391 a_996_6587# a0 0.1634f
C392 VDD vg 24.0577f
C393 a_41854_8187# a_37178_8187# 4.07037f
C394 a_n4384_6451# VDD_LS 0.00409f
C395 a_37178_3547# a_36888_2967# 11.0476f
C396 a_41564_6447# a_36888_6447# 4.1149f
C397 w_36826_300# vbn 6.10627f
C398 VDD bitb2 0.69643f
C399 bit1 vbnf 0.19681f
C400 a_7096_6633# bit1 0.04998f
C401 a_6206_896# bitb4 0.00214f
C402 a_36888_2967# a_37178_4707# 0
C403 a_n5549_6703# a_n3607_6703# 0.02485f
C404 a_37178_5867# a_36888_6447# 10.9862f
C405 a_36888_2967# a_37178_2387# 10.9859f
C406 a_6206_14# bit4 0.05001f
C407 vctrl VSS 18.5054f
C408 vg VSS 14.3431f
C409 bit4 VSS 0.81565f
C410 bit3 VSS 0.58471f
C411 bit2 VSS 0.58471f
C412 bit1 VSS 0.58508f
C413 bit0 VSS 0.59092f
C414 bitb4 VSS 0.64743f
C415 bitb3 VSS 0.63156f
C416 bitb2 VSS 0.63112f
C417 bitb1 VSS 0.63112f
C418 bitb0 VSS 0.69753f
C419 a0 VSS 1.04567f
C420 ck VSS 2.66052f
C421 vbnf VSS 0.11632p
C422 ls VSS 2.96798f
C423 vbn VSS 0.18984p
C424 VDD_LS VSS 72.7694f
C425 VDD VSS 0.4453p
C426 a_41854_1227# VSS 3.93442f
C427 a_41564_1807# VSS 1.69719f
C428 a_41854_2387# VSS 1.65655f
C429 a_41564_2967# VSS 1.65198f
C430 a_41854_3547# VSS 1.65655f
C431 a_41564_4127# VSS 1.65198f
C432 a_41854_4707# VSS 1.65655f
C433 a_41564_5287# VSS 1.65198f
C434 a_41854_5867# VSS 1.65655f
C435 a_41564_6447# VSS 1.65198f
C436 a_41854_7027# VSS 1.65655f
C437 a_41564_7607# VSS 1.65198f
C438 a_41854_8187# VSS 2.25067f
C439 a_37178_1227# VSS 1.91496f
C440 a_36888_1807# VSS 3.9691f
C441 a_37178_2387# VSS 1.31364f
C442 a_36888_2967# VSS 3.9634f
C443 a_37178_3547# VSS 1.34623f
C444 a_36888_4127# VSS 3.96359f
C445 a_37178_4707# VSS 1.34623f
C446 a_36888_5287# VSS 3.96359f
C447 a_37178_5867# VSS 1.34623f
C448 a_36888_6447# VSS 3.96359f
C449 a_37178_7027# VSS 1.34623f
C450 a_36888_7607# VSS 3.95929f
C451 a_37178_8187# VSS 1.67149f
C452 a_60550_8387# VSS 0.65251f
C453 a_6206_14# VSS 24.4677f
C454 a_6206_896# VSS 15.2494f
C455 a_6206_4704# VSS 7.9423f
C456 a_7096_6633# VSS 3.80578f
C457 a_6356_6633# VSS 2.52234f
C458 a_1632_6633# VSS 0.27347f
C459 a_1867_7085# VSS 0.42661f
C460 a_452_6633# VSS 0.36118f
C461 a_996_6587# VSS 0.28496f
C462 a_n4384_6451# VSS 0.14599f
C463 a_n5128_6451# VSS 0.14869f
C464 a_n6436_6531# VSS 0.09609f
C465 a_n7180_6531# VSS 0.09795f
C466 a_n2245_6719# VSS 1.45122f
C467 a_n3101_6703# VSS 0.65272f
C468 a_n4642_7514# VSS 0.56414f
C469 a_n4810_7514# VSS 0.01195f
C470 a_n6694_7514# VSS 0.47458f
C471 a_n6862_7514# VSS 0.01275f
C472 a_n7286_7514# VSS 0.51067f
C473 q1 VSS 0.88857f
C474 a_n7601_6703# VSS 1.00618f
C475 a_n5234_7514# VSS 0.52691f
C476 a_n5549_6703# VSS 1.00806f
C477 a_n8217_6703# VSS 0.82236f
C478 a_n3607_6703# VSS 0.69051f
C479 a_36866_9481# VSS 12.6032f
C480 a_n7872_8894# VSS 7.24156f
C481 w_37991_300# VSS 0.66986f
C482 w_36826_300# VSS 11.6672f
.ends
