* lsdiv: magic R+C extraction of layout/lsdiv.gds (layout/gen/pex.sh)
* extracted 2026-11-08T17:05:05+01:00 with magic 8.3.642, mode rc, from lsdiv.gds
.subckt lsdiv VDD VSS a0 ck
X0 VDD.t6 q1 a_1192_1223# VDD.t5 pfet_03v3 ad=0.336p pd=1.76u as=1.2p ps=4.4u w=1.2u l=0.28u
X1 VSS.t7 q1 a_2042_240# VSS.t6 nfet_03v3 ad=0.168p pd=1.16u as=0.168p ps=1.16u w=0.6u l=0.28u
X2 VDD.t13 a_877_412# q2 VDD.t12 pfet_03v3 ad=0.675p pd=3.9u as=1.5p ps=5u w=1.5u l=0.28u
X3 lf ls VSS.t25 ppolyf_u_1k r_width=1u r_length=0.15912m
X4 a_3836_1223# a_2929_412# VSS.t15 VSS.t14 nfet_03v3 ad=1p pd=4u as=0.28p ps=1.56u w=1u l=0.28u
X5 a_3350_160# a_3244_1223# VSS.t1 VSS.t0 nfet_03v3 ad=0.28p pd=1.56u as=0.45p ps=2.9u w=1u l=0.28u
X6 VDD.t22 lg lo1 VDD.t21 pfet_03v3 ad=0.225p pd=1.9u as=1.1p ps=5.4u w=0.5u l=0.28u
X7 lo2 lo1 VSS.t9 VSS.t8 nfet_03v3 ad=0.6p pd=3.2u as=0.27p ps=2.1u w=0.6u l=0.28u
X8 VSS.t22 lg lo1 VSS.t21 nfet_03v3 ad=0.1686p pd=1.74u as=0.5448p ps=5.16u w=0.22u l=0.28u
X9 ls lo2 VDD.t4 VDD.t3 pfet_03v3 ad=3p pd=8u as=1.35p ps=6.9u w=3u l=0.28u
X10 ck.t1 q2 VSS.t24 VSS.t23 nfet_03v3 ad=1p pd=4u as=0.45p ps=2.9u w=1u l=0.28u
X11 a_2929_412# a_3244_1223# VDD.t1 VDD.t0 pfet_03v3 ad=2p pd=6u as=0.9p ps=4.9u w=2u l=0.28u
X12 a_2042_240# a_1784_1223# a_1192_1223# VSS.t28 nfet_03v3 ad=0.168p pd=1.16u as=0.6p ps=3.2u w=0.6u l=0.28u
X13 a_3668_1223# a_2929_412# VDD.t17 VDD.t16 pfet_03v3 ad=0.56p pd=2.56u as=0.56p ps=2.56u w=2u l=0.28u
X14 VDD.t15 a_2929_412# q1 VDD.t14 pfet_03v3 ad=0.675p pd=3.9u as=1.5p ps=5u w=1.5u l=0.28u
X15 VDD.t19 ls a_3244_1223# VDD.t18 pfet_03v3 ad=0.56p pd=2.56u as=2p ps=6u w=2u l=0.28u
X16 VSS.t20 ls a_4094_160# VSS.t19 nfet_03v3 ad=0.28p pd=1.56u as=0.28p ps=1.56u w=1u l=0.28u
X17 a_1784_1223# q1 a_1616_1223# VDD.t7 pfet_03v3 ad=1.2p pd=4.4u as=0.336p ps=1.76u w=1.2u l=0.28u
X18 a_3836_1223# ls a_3668_1223# VDD.t20 pfet_03v3 ad=2p pd=6u as=0.56p ps=2.56u w=2u l=0.28u
X19 VSS.t11 a_877_412# q2 VSS.t10 nfet_03v3 ad=0.27p pd=2.1u as=0.6p ps=3.2u w=0.6u l=0.28u
X20 a_877_412# q1 a_1298_240# VSS.t5 nfet_03v3 ad=0.6p pd=3.2u as=0.168p ps=1.16u w=0.6u l=0.28u
X21 lf VSS.t31 lg VDD.t2 pfet_03v3 ad=0.2808p pd=2.76u as=0.2808p ps=2.76u w=0.22u l=2u
X22 a_4094_160# a_3836_1223# a_3244_1223# VSS.t2 nfet_03v3 ad=0.28p pd=1.56u as=1p ps=4u w=1u l=0.28u
X23 VSS.t27 lf VSS.t27 VSS.t26 nfet_03v3 ad=7.2p pd=32.9u as=0 ps=0 w=16u l=16u
X24 ck.t0 q2 VDD.t24 VDD.t23 pfet_03v3 ad=2.5p pd=7u as=1.125p ps=5.9u w=2.5u l=0.28u
X25 a_1784_1223# a_877_412# VSS.t13 VSS.t12 nfet_03v3 ad=0.6p pd=3.2u as=0.168p ps=1.16u w=0.6u l=0.28u
X26 a_1298_240# a_1192_1223# VSS.t30 VSS.t29 nfet_03v3 ad=0.168p pd=1.16u as=0.27p ps=2.1u w=0.6u l=0.28u
X27 VSS.t17 a_2929_412# q1 VSS.t16 nfet_03v3 ad=0.27p pd=2.1u as=0.6p ps=3.2u w=0.6u l=0.28u
X28 a_877_412# a_1192_1223# VDD.t26 VDD.t25 pfet_03v3 ad=1.2p pd=4.4u as=0.54p ps=3.3u w=1.2u l=0.28u
X29 ls lo2 VSS.t4 VSS.t3 nfet_03v3 ad=1.2p pd=4.4u as=0.54p ps=3.3u w=1.2u l=0.28u
X30 a_1616_1223# a_877_412# VDD.t11 VDD.t10 pfet_03v3 ad=0.336p pd=1.76u as=0.336p ps=1.76u w=1.2u l=0.28u
X31 lo2 lo1 VDD.t9 VDD.t8 pfet_03v3 ad=1.5p pd=5u as=0.675p ps=3.9u w=1.5u l=0.28u
X32 a_2929_412# ls a_3350_160# VSS.t18 nfet_03v3 ad=1p pd=4u as=0.28p ps=1.56u w=1u l=0.28u
R0 ck.n0 ck.t1 6.68892
R1 ck ck.n0 4.98129
R2 ck.n0 ck.t0 3.48853
R3 VDD.t8 VDD.t21 754.851
R4 VDD.t14 VDD.t25 691.359
R5 VDD.t21 VDD.t2 604.938
R6 VDD.t12 VDD.t23 578.484
R7 VDD.t0 VDD.t3 559.083
R8 VDD.t3 VDD.t8 446.209
R9 VDD.t20 VDD.t0 410.935
R10 VDD.t18 VDD.t14 410.935
R11 VDD.t25 VDD.t7 410.935
R12 VDD.t5 VDD.t12 410.935
R13 VDD.t16 VDD.t18 148.149
R14 VDD.t7 VDD.t10 148.149
R15 VDD.t10 VDD.t5 148.149
R16 VDD.n18 VDD.t16 112.876
R17 VDD.n18 VDD.t20 35.2739
R18 VDD.n10 VDD.t22 9.77177
R19 VDD.n4 VDD.t26 4.85686
R20 VDD.n1 VDD.t13 3.6455
R21 VDD.n24 VDD.t15 3.6455
R22 VDD.n11 VDD.t9 3.6455
R23 VDD.n31 VDD.n3 3.31103
R24 VDD.n16 VDD.t1 2.84379
R25 VDD.n37 VDD.t24 2.33908
R26 VDD.n9 VDD.t4 1.98287
R27 VDD.n7 VDD.n6 1.91629
R28 VDD.n3 VDD.t11 1.63383
R29 VDD.n3 VDD.t6 1.63383
R30 VDD VDD.n37 1.53556
R31 VDD.n13 VDD.n12 1.5005
R32 VDD.n15 VDD.n14 1.5005
R33 VDD.n17 VDD.n8 1.5005
R34 VDD.n21 VDD.n20 1.5005
R35 VDD.n23 VDD.n22 1.5005
R36 VDD.n25 VDD.n5 1.5005
R37 VDD.n27 VDD.n26 1.5005
R38 VDD.n29 VDD.n28 1.5005
R39 VDD.n30 VDD.n2 1.5005
R40 VDD.n33 VDD.n32 1.5005
R41 VDD.n35 VDD.n34 1.5005
R42 VDD.n36 VDD.n0 1.5005
R43 VDD.n6 VDD.t17 0.9805
R44 VDD.n6 VDD.t19 0.9805
R45 VDD.n13 VDD.n10 0.386165
R46 VDD.n19 VDD.n18 0.162038
R47 VDD.n11 VDD.n10 0.109999
R48 VDD.n26 VDD.n25 0.0755
R49 VDD.n30 VDD.n29 0.0755
R50 VDD.n36 VDD.n35 0.0755
R51 VDD.n14 VDD.n13 0.0755
R52 VDD.n14 VDD.n8 0.0755
R53 VDD.n21 VDD.n8 0.0755
R54 VDD.n22 VDD.n21 0.0755
R55 VDD.n22 VDD.n5 0.0755
R56 VDD.n27 VDD.n5 0.0755
R57 VDD.n28 VDD.n27 0.0755
R58 VDD.n28 VDD.n2 0.0755
R59 VDD.n33 VDD.n2 0.0755
R60 VDD.n34 VDD.n33 0.0755
R61 VDD.n34 VDD.n0 0.0755
R62 VDD.n26 VDD.n4 0.0753125
R63 VDD.n12 VDD.n11 0.0741875
R64 VDD.n19 VDD.n17 0.07025
R65 VDD.n16 VDD.n15 0.0655625
R66 VDD.n37 VDD.n36 0.0610625
R67 VDD.n32 VDD.n1 0.0576875
R68 VDD VDD.n0 0.054875
R69 VDD.n15 VDD.n9 0.0543125
R70 VDD.n24 VDD.n23 0.0479375
R71 VDD.n31 VDD.n30 0.04475
R72 VDD.n23 VDD.n7 0.041
R73 VDD.n20 VDD.n7 0.035
R74 VDD.n32 VDD.n31 0.03125
R75 VDD.n25 VDD.n24 0.0280625
R76 VDD.n12 VDD.n9 0.0216875
R77 VDD.n35 VDD.n1 0.0183125
R78 VDD.n17 VDD.n16 0.0104375
R79 VDD.n20 VDD.n19 0.00575
R80 VDD.n29 VDD.n4 0.0006875
R81 VSS.t23 VSS.t26 63524.7
R82 VSS.t25 VSS.t21 9391.72
R83 VSS.t21 VSS.t8 1742.02
R84 VSS.t26 VSS.n43 1316.43
R85 VSS.t16 VSS.t12 1253.6
R86 VSS.t10 VSS.t23 1253.6
R87 VSS.t28 VSS.t5 1172.2
R88 VSS.n44 VSS.t18 1137.6
R89 VSS.t8 VSS.t3 1029.74
R90 VSS.t3 VSS.t14 1029.74
R91 VSS.t0 VSS.t16 724.484
R92 VSS.t29 VSS.t10 724.484
R93 VSS.t14 VSS.t19 341.892
R94 VSS.t19 VSS.t2 341.892
R95 VSS.t18 VSS.t0 341.892
R96 VSS.t12 VSS.t6 341.892
R97 VSS.t6 VSS.t28 341.892
R98 VSS.t5 VSS.t29 341.892
R99 VSS.n43 VSS.t25 105.001
R100 VSS.n44 VSS.t2 34.5966
R101 VSS.n12 VSS.t22 13.0008
R102 VSS.n13 VSS.t31 11.6669
R103 VSS.n10 VSS.t9 9.43826
R104 VSS.n52 VSS.t17 9.43826
R105 VSS.n59 VSS.t30 9.43826
R106 VSS.n2 VSS.t11 9.43826
R107 VSS.n5 VSS.n4 6.65576
R108 VSS.n66 VSS.n1 5.28996
R109 VSS.n51 VSS.t1 5.12789
R110 VSS.n65 VSS.t24 5.12789
R111 VSS.n21 VSS.t4 4.82596
R112 VSS.n23 VSS.n9 3.45839
R113 VSS.n4 VSS.t13 2.9405
R114 VSS.n4 VSS.t7 2.9405
R115 VSS.n28 VSS.t27 2.64712
R116 VSS.n41 VSS.t27 2.64712
R117 VSS.n9 VSS.t15 1.7645
R118 VSS.n9 VSS.t20 1.7645
R119 VSS.n66 VSS.n65 1.52292
R120 VSS.n30 VSS.n29 1.5005
R121 VSS.n31 VSS.n27 1.5005
R122 VSS.n33 VSS.n32 1.5005
R123 VSS.n34 VSS.n26 1.5005
R124 VSS.n36 VSS.n35 1.5005
R125 VSS.n37 VSS.n25 1.5005
R126 VSS.n39 VSS.n38 1.5005
R127 VSS.n40 VSS.n24 1.5005
R128 VSS.n64 VSS.n0 1.5005
R129 VSS.n63 VSS.n62 1.5005
R130 VSS.n61 VSS.n60 1.5005
R131 VSS.n58 VSS.n3 1.5005
R132 VSS.n57 VSS.n56 1.5005
R133 VSS.n55 VSS.n54 1.5005
R134 VSS.n53 VSS.n6 1.5005
R135 VSS.n50 VSS.n49 1.5005
R136 VSS.n48 VSS.n7 1.5005
R137 VSS.n47 VSS.n46 1.5005
R138 VSS.n22 VSS.n8 1.5005
R139 VSS.n20 VSS.n19 1.5005
R140 VSS.n18 VSS.n17 1.5005
R141 VSS.n16 VSS.n11 1.5005
R142 VSS.n15 VSS.n14 1.5005
R143 VSS.n28 VSS.n1 0.757202
R144 VSS.n14 VSS.n13 0.513873
R145 VSS.n42 VSS.n24 0.501672
R146 VSS.n45 VSS.n44 0.122853
R147 VSS.n43 VSS.n42 0.122853
R148 VSS.n30 VSS.n1 0.108353
R149 VSS.n13 VSS.n12 0.0872074
R150 VSS.n16 VSS.n15 0.0755
R151 VSS.n17 VSS.n16 0.0755
R152 VSS.n50 VSS.n7 0.0755
R153 VSS.n54 VSS.n53 0.0755
R154 VSS.n58 VSS.n57 0.0755
R155 VSS.n60 VSS.n58 0.0755
R156 VSS.n64 VSS.n63 0.0755
R157 VSS.n40 VSS.n39 0.0755
R158 VSS.n39 VSS.n25 0.0755
R159 VSS.n35 VSS.n25 0.0755
R160 VSS.n35 VSS.n34 0.0755
R161 VSS.n34 VSS.n33 0.0755
R162 VSS.n33 VSS.n27 0.0755
R163 VSS.n29 VSS.n27 0.0755
R164 VSS.n38 VSS.n24 0.0755
R165 VSS.n38 VSS.n37 0.0755
R166 VSS.n37 VSS.n36 0.0755
R167 VSS.n36 VSS.n26 0.0755
R168 VSS.n32 VSS.n26 0.0755
R169 VSS.n32 VSS.n31 0.0755
R170 VSS.n31 VSS.n30 0.0755
R171 VSS.n14 VSS.n11 0.0755
R172 VSS.n18 VSS.n11 0.0755
R173 VSS.n19 VSS.n18 0.0755
R174 VSS.n19 VSS.n8 0.0755
R175 VSS.n47 VSS.n8 0.0755
R176 VSS.n48 VSS.n47 0.0755
R177 VSS.n49 VSS.n48 0.0755
R178 VSS.n49 VSS.n6 0.0755
R179 VSS.n55 VSS.n6 0.0755
R180 VSS.n56 VSS.n55 0.0755
R181 VSS.n56 VSS.n3 0.0755
R182 VSS.n61 VSS.n3 0.0755
R183 VSS.n62 VSS.n61 0.0755
R184 VSS.n62 VSS.n0 0.0755
R185 VSS.n20 VSS.n10 0.0741875
R186 VSS.n29 VSS.n28 0.072875
R187 VSS.n65 VSS.n64 0.0610625
R188 VSS.n45 VSS.n7 0.0584375
R189 VSS VSS.n0 0.054875
R190 VSS.n22 VSS.n21 0.0543125
R191 VSS.n54 VSS.n5 0.051875
R192 VSS.n23 VSS.n22 0.042125
R193 VSS.n15 VSS.n12 0.041375
R194 VSS.n52 VSS.n51 0.036875
R195 VSS.n59 VSS.n2 0.036875
R196 VSS.n42 VSS.n41 0.0363125
R197 VSS.n46 VSS.n23 0.033875
R198 VSS.n60 VSS.n59 0.0288125
R199 VSS.n57 VSS.n5 0.024125
R200 VSS.n41 VSS.n40 0.022625
R201 VSS.n21 VSS.n20 0.0216875
R202 VSS.n53 VSS.n52 0.0205625
R203 VSS.n51 VSS.n50 0.0190625
R204 VSS.n46 VSS.n45 0.0175625
R205 VSS VSS.n66 0.0140889
R206 VSS.n63 VSS.n2 0.0108125
R207 VSS.n17 VSS.n10 0.0018125
C0 a_1192_1223# a_877_412# 0.71835f
C1 ls lg 0
C2 a_3350_160# a_3244_1223# 0.01134f
C3 ls lo2 0.96168f
C4 a_1192_1223# q1 1.29375f
C5 lf a_1616_1223# 0
C6 a_1616_1223# a_1784_1223# 0.08507f
C7 a_1298_240# VDD 0.00222f
C8 ls q1 0.00995f
C9 a_1616_1223# VDD 0.14459f
C10 a_3668_1223# a_2929_412# 0.01794f
C11 a_4094_160# a_2929_412# 0.0061f
C12 a_3836_1223# a_2929_412# 0.70987f
C13 a_1298_240# a_877_412# 0.04749f
C14 lf a_2929_412# 0.00156f
C15 a_2929_412# a_1784_1223# 0.00175f
C16 a_877_412# a_1616_1223# 0.01101f
C17 lo1 ls 0.12117f
C18 a_2929_412# VDD 0.58961f
C19 lf q2 0
C20 a_1784_1223# q2 0
C21 a_1298_240# q1 0.00689f
C22 a_1616_1223# q1 0.01095f
C23 VDD q2 0.37427f
C24 a_3668_1223# a_3244_1223# 0.00509f
C25 ck q2 1.12345f
C26 a_4094_160# a_3244_1223# 0.07136f
C27 a_2929_412# a_877_412# 0.0098f
C28 a_3836_1223# a_3244_1223# 0.88042f
C29 lf a_3244_1223# 0
C30 a_2929_412# lo2 0.02485f
C31 a_3244_1223# a_1784_1223# 0
C32 a_877_412# q2 0.7483f
C33 a_3244_1223# VDD 0.51666f
C34 a_2929_412# q1 0.74328f
C35 a_3350_160# VDD 0.00198f
C36 a_1192_1223# a_1298_240# 0.00757f
C37 a_2042_240# a_1784_1223# 0.00564f
C38 a_1192_1223# a_1616_1223# 0.00388f
C39 q1 q2 0.00656f
C40 VDD a_2042_240# 0.00406f
C41 a_877_412# a_3244_1223# 0
C42 a_3244_1223# lo2 0.003f
C43 lo1 a_2929_412# 0
C44 a_3244_1223# q1 0.00721f
C45 a_877_412# a_2042_240# 0.00463f
C46 a_2929_412# a_1192_1223# 0.00223f
C47 a_2929_412# ls 1.56506f
C48 a_1192_1223# q2 0.00738f
C49 a_3836_1223# a_3668_1223# 0.14135f
C50 q1 a_2042_240# 0.00604f
C51 lf a_3668_1223# 0
C52 a0 lf 0.00402f
C53 a_4094_160# a_3836_1223# 0.00911f
C54 lo1 a_3244_1223# 0
C55 a_3836_1223# a_1784_1223# 0.00248f
C56 a_3668_1223# VDD 0.23085f
C57 lf a_1784_1223# 0
C58 a0 VDD 0.03342f
C59 a_4094_160# VDD 0.00409f
C60 a_3836_1223# VDD 0.26831f
C61 a_1192_1223# a_3244_1223# 0.00334f
C62 lf VDD 2.57939f
C63 VDD a_1784_1223# 0.21816f
C64 ck a_1784_1223# 0
C65 a0 lg 1.98512f
C66 ls a_3244_1223# 1.35416f
C67 lf lg 0.22692f
C68 ck VDD 0.31514f
C69 a_3350_160# ls 0.01045f
C70 a_1192_1223# a_2042_240# 0.04322f
C71 lf a_877_412# 0.00167f
C72 a_877_412# a_1784_1223# 0.70254f
C73 a_3836_1223# lo2 0.08987f
C74 lg VDD 0.33992f
C75 lf lo2 0
C76 a_877_412# VDD 0.45003f
C77 ck a_877_412# 0.00936f
C78 a_3836_1223# q1 0
C79 lo2 VDD 0.39275f
C80 lf q1 0.00168f
C81 q1 a_1784_1223# 0.67113f
C82 VDD q1 0.47949f
C83 lg lo2 0.00588f
C84 ck q1 0
C85 lo1 a_4094_160# 0
C86 lo1 a_3836_1223# 0
C87 lo1 lf 0.00642f
C88 a_3668_1223# a_1192_1223# 0
C89 a_877_412# q1 1.57175f
C90 lo1 VDD 0.28227f
C91 lf a_1192_1223# 0
C92 a_3668_1223# ls 0.02307f
C93 a_1192_1223# a_1784_1223# 0.87554f
C94 a_2929_412# a_3244_1223# 0.74379f
C95 a_4094_160# ls 0.01106f
C96 a_3836_1223# ls 0.63671f
C97 a_3350_160# a_2929_412# 0.07726f
C98 lo1 lg 0.20859f
C99 a_1192_1223# VDD 0.40251f
C100 lf ls 0.11442f
C101 ls a_1784_1223# 0
C102 ck a_1192_1223# 0
C103 lo1 lo2 1.04229f
C104 ls VDD 1.22951f
C105 a0 VSS 2.61305f
C106 ck VSS 0.6854f
C107 VDD VSS 29.37351f
C108 a_4094_160# VSS 0.14599f
C109 a_3350_160# VSS 0.14869f
C110 a_2042_240# VSS 0.09609f
C111 a_1298_240# VSS 0.09795f
C112 lg VSS 1.43835f
C113 lo1 VSS 0.65272f
C114 a_3836_1223# VSS 0.56414f
C115 a_3668_1223# VSS 0.01195f
C116 a_1784_1223# VSS 0.47458f
C117 a_1616_1223# VSS 0.01275f
C118 a_1192_1223# VSS 0.51067f
C119 q1 VSS 0.88832f
C120 a_877_412# VSS 1.00618f
C121 a_3244_1223# VSS 0.52691f
C122 a_2929_412# VSS 1.00806f
C123 q2 VSS 0.80919f
C124 lo2 VSS 0.69051f
C125 ls VSS 1.64111f
C126 lf VSS 7.26912f
C127 VDD.n0 VSS 0.08959f
C128 VDD.t24 VSS 0.02365f
C129 VDD.t13 VSS 0.01443f
C130 VDD.n1 VSS 0.08176f
C131 VDD.n2 VSS 0.10387f
C132 VDD.t11 VSS 0.00364f
C133 VDD.t6 VSS 0.00364f
C134 VDD.n3 VSS 0.01099f
C135 VDD.t26 VSS 0.01159f
C136 VDD.n4 VSS 0.08167f
C137 VDD.n5 VSS 0.10387f
C138 VDD.t15 VSS 0.01443f
C139 VDD.t17 VSS 0.00606f
C140 VDD.t19 VSS 0.00606f
C141 VDD.n6 VSS 0.01821f
C142 VDD.n7 VSS 0.07549f
C143 VDD.n8 VSS 0.10387f
C144 VDD.t1 VSS 0.0191f
C145 VDD.t4 VSS 0.02806f
C146 VDD.n9 VSS 0.08274f
C147 VDD.t22 VSS 0.00979f
C148 VDD.n10 VSS 0.92192f
C149 VDD.t9 VSS 0.01443f
C150 VDD.n11 VSS 0.1957f
C151 VDD.n12 VSS 0.0657f
C152 VDD.n13 VSS 0.54681f
C153 VDD.n14 VSS 0.10387f
C154 VDD.n15 VSS 0.08232f
C155 VDD.n16 VSS 0.08196f
C156 VDD.n17 VSS 0.05518f
C157 VDD.t2 VSS 0.52944f
C158 VDD.t21 VSS 0.473f
C159 VDD.t8 VSS 0.41779f
C160 VDD.t3 VSS 0.34969f
C161 VDD.t0 VSS 0.33742f
C162 VDD.t20 VSS 0.15521f
C163 VDD.t23 VSS 0.34723f
C164 VDD.t12 VSS 0.34417f
C165 VDD.t5 VSS 0.19448f
C166 VDD.t10 VSS 0.10307f
C167 VDD.t7 VSS 0.19448f
C168 VDD.t25 VSS 0.38343f
C169 VDD.t14 VSS 0.38343f
C170 VDD.t18 VSS 0.19448f
C171 VDD.t16 VSS 0.0908f
C172 VDD.n18 VSS -0.09969f
C173 VDD.n19 VSS -0.09929f
C174 VDD.n20 VSS 0.02753f
C175 VDD.n21 VSS 0.10387f
C176 VDD.n22 VSS 0.10387f
C177 VDD.n23 VSS 0.06089f
C178 VDD.n24 VSS 0.08176f
C179 VDD.n25 VSS 0.07102f
C180 VDD.n26 VSS 0.10374f
C181 VDD.n27 VSS 0.10387f
C182 VDD.n28 VSS 0.10387f
C183 VDD.n29 VSS 0.05207f
C184 VDD.n30 VSS 0.08258f
C185 VDD.n31 VSS 0.07786f
C186 VDD.n32 VSS 0.06089f
C187 VDD.n33 VSS 0.10387f
C188 VDD.n34 VSS 0.10387f
C189 VDD.n35 VSS 0.06427f
C190 VDD.n36 VSS 0.09387f
C191 VDD.n37 VSS 0.11323f
C192 ck.t0 VSS 0.42204f
C193 ck.t1 VSS 0.13311f
C194 ck.n0 VSS 0.72824f
.ends
