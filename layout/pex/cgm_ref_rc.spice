* cgm_ref: magic R+C extraction of layout/cgm_ref.gds (layout/gen/pex.sh)
* extracted 2026-11-08T18:24:20+01:00 with magic 8.3.642, mode rc, from cgm_ref.gds
.subckt cgm_ref VDD VSS vbn vbnf vctrl
X0 a_23540_3547# vbn.t118 a_23250_4127# VSS.t34 nfet_03v3 ad=0.56p pd=2.56u as=0.9p ps=4.9u w=2u l=1u
X1 a_23540_2387# vbn.t82 a_23250_2967# VSS.t36 nfet_03v3 ad=0.56p pd=2.56u as=0.56p ps=2.56u w=2u l=1u
X2 a_23250_6447# vbn.t161 a_23540_5867# VSS.t30 nfet_03v3 ad=0.9p pd=4.9u as=0.56p ps=2.56u w=2u l=1u
X3 a_23540_5867# vbn.t936 a_23250_6447# VSS.t30 nfet_03v3 ad=0.56p pd=2.56u as=0.56p ps=2.56u w=2u l=1u
X4 a_23540_5867# vbn.t926 a_23250_5287# VSS.t31 nfet_03v3 ad=0.56p pd=2.56u as=0.56p ps=2.56u w=2u l=1u
X5 a_23540_2387# vbn.t834 a_23250_1807# VSS.t37 nfet_03v3 ad=0.56p pd=2.56u as=0.56p ps=2.56u w=2u l=1u
X6 a_28216_4707# vbn.t756 a_27926_4127# VSS.t33 nfet_03v3 ad=0.9p pd=4.9u as=0.56p ps=2.56u w=2u l=1u
X7 a_27926_7607# vbn.t318 a_28216_8187# VSS.t27 nfet_03v3 ad=0.56p pd=2.56u as=0.56p ps=2.56u w=2u l=1u
X8 a_23250_7607# vbn.t664 a_23540_8187# VSS.t27 nfet_03v3 ad=0.56p pd=2.56u as=0.56p ps=2.56u w=2u l=1u
X9 a_23540_7027# vbn.t176 a_23250_6447# VSS.t29 nfet_03v3 ad=0.56p pd=2.56u as=0.56p ps=2.56u w=2u l=1u
X10 a_23540_4707# vbn.t902 a_23250_4127# VSS.t22 nfet_03v3 ad=0.56p pd=2.56u as=0.9p ps=4.9u w=2u l=1u
X11 a_23540_7027# vbn.t647 a_23250_7607# VSS.t28 nfet_03v3 ad=0.56p pd=2.56u as=0.56p ps=2.56u w=2u l=1u
X12 net3 vbn.t332 a_23540_1227# VSS.t39 nfet_03v3 ad=0.56p pd=2.56u as=0.56p ps=2.56u w=2u l=1u
X13 a_23540_1227# vbn.t355 a_23250_1807# VSS.t38 nfet_03v3 ad=0.56p pd=2.56u as=0.56p ps=2.56u w=2u l=1u
X14 a_23540_3547# vbn.t471 a_23250_4127# VSS.t34 nfet_03v3 ad=0.56p pd=2.56u as=0.56p ps=2.56u w=2u l=1u
X15 a_23250_2967# vbn.t87 a_23540_2387# VSS.t36 nfet_03v3 ad=0.56p pd=2.56u as=0.56p ps=2.56u w=2u l=1u
X16 a_23250_1807# vbn.t400 a_23540_2387# VSS.t37 nfet_03v3 ad=0.56p pd=2.56u as=0.56p ps=2.56u w=2u l=1u
X17 a_23540_5867# vbn.t156 a_23250_5287# VSS.t31 nfet_03v3 ad=0.56p pd=2.56u as=0.56p ps=2.56u w=2u l=1u
X18 a_23540_5867# vbn.t166 a_23250_6447# VSS.t30 nfet_03v3 ad=0.56p pd=2.56u as=0.56p ps=2.56u w=2u l=1u
X19 a_23540_8187# vbn.t216 a_23250_7607# VSS.t27 nfet_03v3 ad=0.56p pd=2.56u as=0.9p ps=4.9u w=2u l=1u
X20 a_23540_2387# vbn.t407 a_23250_2967# VSS.t36 nfet_03v3 ad=0.56p pd=2.56u as=0.56p ps=2.56u w=2u l=1u
X21 a_28216_1227# vbn.t240 a_27926_1807# VSS.t38 nfet_03v3 ad=0.56p pd=2.56u as=0.56p ps=2.56u w=2u l=1u
X22 a_23250_1807# vbn.t61 a_23540_1227# VSS.t38 nfet_03v3 ad=0.56p pd=2.56u as=0.56p ps=2.56u w=2u l=1u
X23 a_27926_4127# vbn.t274 a_28216_4707# VSS.t33 nfet_03v3 ad=0.56p pd=2.56u as=0.56p ps=2.56u w=2u l=1u
X24 a_28216_8187# vbn.t18 vbn.t19 VSS.t26 nfet_03v3 ad=0.9p pd=4.9u as=0.56p ps=2.56u w=2u l=1u
X25 a_23250_2967# vbn.t85 a_23540_2387# VSS.t36 nfet_03v3 ad=0.56p pd=2.56u as=0.56p ps=2.56u w=2u l=1u
X26 a_23250_4127# vbn.t476 a_23540_3547# VSS.t34 nfet_03v3 ad=0.56p pd=2.56u as=0.56p ps=2.56u w=2u l=1u
X27 a_23540_8187# vbn.t1000 net1 VSS.t22 nfet_03v3 ad=0.56p pd=2.56u as=0.9p ps=4.9u w=2u l=1u
X28 a_23250_1807# vbn.t837 a_23540_2387# VSS.t37 nfet_03v3 ad=0.56p pd=2.56u as=0.56p ps=2.56u w=2u l=1u
X29 a_28216_7027# vbn.t795 a_27926_7607# VSS.t28 nfet_03v3 ad=0.56p pd=2.56u as=0.56p ps=2.56u w=2u l=1u
X30 a_23250_6447# vbn.t171 a_23540_5867# VSS.t30 nfet_03v3 ad=0.56p pd=2.56u as=0.56p ps=2.56u w=2u l=1u
X31 a_23540_8187# vbn.t667 a_23250_7607# VSS.t27 nfet_03v3 ad=0.56p pd=2.56u as=0.56p ps=2.56u w=2u l=1u
X32 a_23540_5867# vbn.t575 a_23250_6447# VSS.t30 nfet_03v3 ad=0.56p pd=2.56u as=0.56p ps=2.56u w=2u l=1u
X33 a_23540_5867# vbn.t551 a_23250_5287# VSS.t31 nfet_03v3 ad=0.56p pd=2.56u as=0.56p ps=2.56u w=2u l=1u
X34 a_23250_5287# vbn.t528 a_23540_4707# VSS.t32 nfet_03v3 ad=0.56p pd=2.56u as=0.56p ps=2.56u w=2u l=1u
X35 a_27926_2967# vbn.t264 a_28216_3547# VSS.t35 nfet_03v3 ad=0.56p pd=2.56u as=0.56p ps=2.56u w=2u l=1u
X36 a_23250_1807# vbn.t358 a_23540_1227# VSS.t38 nfet_03v3 ad=0.56p pd=2.56u as=0.56p ps=2.56u w=2u l=1u
X37 a_28216_5867# vbn.t289 a_27926_5287# VSS.t31 nfet_03v3 ad=0.56p pd=2.56u as=0.56p ps=2.56u w=2u l=1u
X38 vbn.t31 vbn.t30 a_28216_8187# VSS.t26 nfet_03v3 ad=0.56p pd=2.56u as=0.56p ps=2.56u w=2u l=1u
X39 a_23250_5287# vbn.t159 a_23540_5867# VSS.t31 nfet_03v3 ad=0.56p pd=2.56u as=0.56p ps=2.56u w=2u l=1u
X40 a_23250_6447# vbn.t169 a_23540_5867# VSS.t30 nfet_03v3 ad=0.56p pd=2.56u as=0.56p ps=2.56u w=2u l=1u
X41 a_23540_2387# vbn.t842 a_23250_1807# VSS.t37 nfet_03v3 ad=0.56p pd=2.56u as=0.56p ps=2.56u w=2u l=1u
X42 a_23250_2967# vbn.t861 a_23540_3547# VSS.t35 nfet_03v3 ad=0.9p pd=4.9u as=0.56p ps=2.56u w=2u l=1u
X43 a_28216_1227# vbn.t714 VSS.t46 VSS.t39 nfet_03v3 ad=0.9p pd=4.9u as=0.56p ps=2.56u w=2u l=1u
X44 a_23250_7607# vbn.t672 a_23540_8187# VSS.t27 nfet_03v3 ad=0.56p pd=2.56u as=0.56p ps=2.56u w=2u l=1u
X45 a_23540_1227# vbn.t818 net3 VSS.t22 nfet_03v3 ad=0.56p pd=2.56u as=0.9p ps=4.9u w=2u l=1u
X46 a_27926_6447# vbn.t306 a_28216_7027# VSS.t29 nfet_03v3 ad=0.56p pd=2.56u as=0.56p ps=2.56u w=2u l=1u
X47 a_23540_3547# vbn.t479 a_23250_4127# VSS.t34 nfet_03v3 ad=0.56p pd=2.56u as=0.56p ps=2.56u w=2u l=1u
X48 a_23540_1227# vbn.t363 a_23250_1807# VSS.t38 nfet_03v3 ad=0.56p pd=2.56u as=0.56p ps=2.56u w=2u l=1u
X49 a_23250_4127# vbn.t502 a_23540_4707# VSS.t33 nfet_03v3 ad=0.56p pd=2.56u as=0.56p ps=2.56u w=2u l=1u
X50 a_23250_5287# vbn.t554 a_23540_5867# VSS.t31 nfet_03v3 ad=0.56p pd=2.56u as=0.56p ps=2.56u w=2u l=1u
X51 a_23540_2387# vbn.t72 a_23250_1807# VSS.t37 nfet_03v3 ad=0.56p pd=2.56u as=0.56p ps=2.56u w=2u l=1u
X52 a_23250_7607# vbn.t193 a_23540_7027# VSS.t28 nfet_03v3 ad=0.56p pd=2.56u as=0.56p ps=2.56u w=2u l=1u
X53 VSS.t3 vbnf.t10 VSS.t3 VSS.t2 nfet_03v3 ad=22.113p pd=99.18u as=0 ps=0 w=49.14u l=10u
X54 a_23250_6447# vbn.t945 a_23540_7027# VSS.t29 nfet_03v3 ad=0.9p pd=4.9u as=0.56p ps=2.56u w=2u l=1u
X55 VSS.t52 vbn.t232 a_28216_1227# VSS.t39 nfet_03v3 ad=0.56p pd=2.56u as=0.56p ps=2.56u w=2u l=1u
X56 a_23540_2387# vbn.t431 a_23250_2967# VSS.t36 nfet_03v3 ad=0.56p pd=2.56u as=0.56p ps=2.56u w=2u l=1u
X57 a_28216_4707# vbn.t763 a_27926_5287# VSS.t32 nfet_03v3 ad=0.9p pd=4.9u as=0.56p ps=2.56u w=2u l=1u
X58 a_23540_4707# vbn.t916 a_23250_5287# VSS.t22 nfet_03v3 ad=0.56p pd=2.56u as=0.9p ps=4.9u w=2u l=1u
X59 a_28216_3547# vbn.t753 a_27926_4127# VSS.t34 nfet_03v3 ad=0.56p pd=2.56u as=0.56p ps=2.56u w=2u l=1u
X60 net1 vbn.t698 a_23540_8187# VSS.t26 nfet_03v3 ad=0.56p pd=2.56u as=0.56p ps=2.56u w=2u l=1u
X61 a_23540_8187# vbn.t675 a_23250_7607# VSS.t27 nfet_03v3 ad=0.56p pd=2.56u as=0.56p ps=2.56u w=2u l=1u
X62 a_23250_7607# vbn.t630 a_23540_7027# VSS.t28 nfet_03v3 ad=0.9p pd=4.9u as=0.56p ps=2.56u w=2u l=1u
X63 a_23540_5867# vbn.t559 a_23250_5287# VSS.t31 nfet_03v3 ad=0.56p pd=2.56u as=0.56p ps=2.56u w=2u l=1u
X64 a_23540_2387# vbn.t383 a_23250_1807# VSS.t37 nfet_03v3 ad=0.56p pd=2.56u as=0.56p ps=2.56u w=2u l=1u
X65 a_23250_2967# vbn.t460 a_23540_3547# VSS.t35 nfet_03v3 ad=0.56p pd=2.56u as=0.56p ps=2.56u w=2u l=1u
X66 a_23540_2387# vbn.t854 a_23250_2967# VSS.t36 nfet_03v3 ad=0.56p pd=2.56u as=0.56p ps=2.56u w=2u l=1u
X67 a_23540_5867# vbn.t599 a_23250_6447# VSS.t30 nfet_03v3 ad=0.56p pd=2.56u as=0.56p ps=2.56u w=2u l=1u
X68 a_28216_2387# vbn.t247 a_27926_1807# VSS.t37 nfet_03v3 ad=0.56p pd=2.56u as=0.56p ps=2.56u w=2u l=1u
X69 a_27926_5287# vbn.t281 a_28216_4707# VSS.t32 nfet_03v3 ad=0.56p pd=2.56u as=0.56p ps=2.56u w=2u l=1u
X70 a_28216_3547# vbn.t748 a_27926_2967# VSS.t35 nfet_03v3 ad=0.56p pd=2.56u as=0.9p ps=4.9u w=2u l=1u
X71 a_23540_3547# vbn.t94 a_23250_2967# VSS.t35 nfet_03v3 ad=0.56p pd=2.56u as=0.56p ps=2.56u w=2u l=1u
X72 a_23250_1807# vbn.t75 a_23540_2387# VSS.t37 nfet_03v3 ad=0.56p pd=2.56u as=0.56p ps=2.56u w=2u l=1u
X73 a_23540_7027# vbn.t196 a_23250_7607# VSS.t28 nfet_03v3 ad=0.56p pd=2.56u as=0.56p ps=2.56u w=2u l=1u
X74 a_28216_8187# vbn.t802 a_27926_7607# VSS.t27 nfet_03v3 ad=0.56p pd=2.56u as=0.56p ps=2.56u w=2u l=1u
X75 a_23250_2967# vbn.t859 a_23540_2387# VSS.t23 nfet_03v3 ad=0.56p pd=2.56u as=0.56p ps=2.56u w=2u l=1u
X76 a_23540_5867# vbn.t938 a_23250_6447# VSS.t30 nfet_03v3 ad=0.56p pd=2.56u as=0.56p ps=2.56u w=2u l=1u
X77 a_23250_2967# vbn.t869 a_23540_3547# VSS.t35 nfet_03v3 ad=0.56p pd=2.56u as=0.56p ps=2.56u w=2u l=1u
X78 a_27926_1807# vbn.t724 a_28216_1227# VSS.t38 nfet_03v3 ad=0.56p pd=2.56u as=0.56p ps=2.56u w=2u l=1u
X79 a_23540_7027# vbn.t651 a_23250_7607# VSS.t28 nfet_03v3 ad=0.56p pd=2.56u as=0.56p ps=2.56u w=2u l=1u
X80 a_23250_6447# vbn.t628 a_23540_7027# VSS.t29 nfet_03v3 ad=0.56p pd=2.56u as=0.56p ps=2.56u w=2u l=1u
X81 net3 vbn.t334 a_23540_1227# VSS.t39 nfet_03v3 ad=0.56p pd=2.56u as=0.56p ps=2.56u w=2u l=1u
X82 a_28216_7027# vbn.t790 a_27926_6447# VSS.t29 nfet_03v3 ad=0.56p pd=2.56u as=0.9p ps=4.9u w=2u l=1u
X83 a_28216_4707# vbn.t758 a_27926_4127# VSS.t33 nfet_03v3 ad=0.56p pd=2.56u as=0.56p ps=2.56u w=2u l=1u
X84 a_23250_4127# vbn.t109 a_23540_3547# VSS.t34 nfet_03v3 ad=0.56p pd=2.56u as=0.56p ps=2.56u w=2u l=1u
X85 a_23540_7027# vbn.t178 a_23250_6447# VSS.t29 nfet_03v3 ad=0.56p pd=2.56u as=0.56p ps=2.56u w=2u l=1u
X86 a_23250_1807# vbn.t386 a_23540_2387# VSS.t37 nfet_03v3 ad=0.56p pd=2.56u as=0.56p ps=2.56u w=2u l=1u
X87 vbn.t3 net1 VDD.t3 VDD.t2 pfet_03v3 ad=3.92p pd=14.56u as=6.3p ps=28.9u w=14u l=14u
X88 a_28216_1227# vbn.t242 a_27926_1807# VSS.t38 nfet_03v3 ad=0.56p pd=2.56u as=0.56p ps=2.56u w=2u l=1u
X89 a_23540_7027# vbn.t649 a_23250_7607# VSS.t28 nfet_03v3 ad=0.56p pd=2.56u as=0.56p ps=2.56u w=2u l=1u
X90 a_28216_2387# vbn.t252 a_27926_2967# VSS.t36 nfet_03v3 ad=0.9p pd=4.9u as=0.56p ps=2.56u w=2u l=1u
X91 a_23250_2967# vbn.t97 a_23540_3547# VSS.t35 nfet_03v3 ad=0.56p pd=2.56u as=0.56p ps=2.56u w=2u l=1u
X92 a_23540_7027# vbn.t962 a_23250_7607# VSS.t28 nfet_03v3 ad=0.56p pd=2.56u as=0.56p ps=2.56u w=2u l=1u
X93 a_23250_6447# vbn.t953 a_23540_7027# VSS.t29 nfet_03v3 ad=0.56p pd=2.56u as=0.56p ps=2.56u w=2u l=1u
X94 a_23250_6447# vbn.t943 a_23540_5867# VSS.t23 nfet_03v3 ad=0.56p pd=2.56u as=0.56p ps=2.56u w=2u l=1u
X95 a_23250_5287# vbn.t530 a_23540_4707# VSS.t32 nfet_03v3 ad=0.56p pd=2.56u as=0.56p ps=2.56u w=2u l=1u
X96 a_23250_4127# vbn.t462 a_23540_3547# VSS.t34 nfet_03v3 ad=0.9p pd=4.9u as=0.56p ps=2.56u w=2u l=1u
X97 a_23250_2967# vbn.t438 a_23540_3547# VSS.t35 nfet_03v3 ad=0.56p pd=2.56u as=0.56p ps=2.56u w=2u l=1u
X98 a_23540_2387# vbn.t391 a_23250_1807# VSS.t37 nfet_03v3 ad=0.56p pd=2.56u as=0.56p ps=2.56u w=2u l=1u
X99 a_28216_8187# vbn.t14 vbn.t15 VSS.t26 nfet_03v3 ad=0.56p pd=2.56u as=0.56p ps=2.56u w=2u l=1u
X100 a_27926_5287# vbn.t773 a_28216_5867# VSS.t31 nfet_03v3 ad=0.56p pd=2.56u as=0.56p ps=2.56u w=2u l=1u
X101 a_23250_7607# vbn.t207 a_23540_8187# VSS.t27 nfet_03v3 ad=0.56p pd=2.56u as=0.56p ps=2.56u w=2u l=1u
X102 a_23250_7607# vbn.t654 a_23540_7027# VSS.t28 nfet_03v3 ad=0.56p pd=2.56u as=0.56p ps=2.56u w=2u l=1u
X103 a_28216_5867# vbn.t291 a_27926_5287# VSS.t31 nfet_03v3 ad=0.56p pd=2.56u as=0.56p ps=2.56u w=2u l=1u
X104 a_28216_5867# vbn.t294 a_27926_6447# VSS.t30 nfet_03v3 ad=0.9p pd=4.9u as=0.56p ps=2.56u w=2u l=1u
X105 a_27926_4127# vbn.t761 a_28216_4707# VSS.t33 nfet_03v3 ad=0.56p pd=2.56u as=0.56p ps=2.56u w=2u l=1u
X106 a_23250_2967# vbn.t436 a_23540_3547# VSS.t35 nfet_03v3 ad=0.56p pd=2.56u as=0.56p ps=2.56u w=2u l=1u
X107 a_23250_4127# vbn.t121 a_23540_4707# VSS.t33 nfet_03v3 ad=0.56p pd=2.56u as=0.56p ps=2.56u w=2u l=1u
X108 a_23540_3547# vbn.t112 a_23250_4127# VSS.t34 nfet_03v3 ad=0.56p pd=2.56u as=0.56p ps=2.56u w=2u l=1u
X109 a_23540_3547# vbn.t102 a_23250_2967# VSS.t35 nfet_03v3 ad=0.56p pd=2.56u as=0.56p ps=2.56u w=2u l=1u
X110 a_23250_6447# vbn.t181 a_23540_7027# VSS.t29 nfet_03v3 ad=0.56p pd=2.56u as=0.56p ps=2.56u w=2u l=1u
X111 a_23250_6447# vbn.t606 a_23540_7027# VSS.t29 nfet_03v3 ad=0.56p pd=2.56u as=0.56p ps=2.56u w=2u l=1u
X112 a_23250_7607# vbn.t658 a_23540_8187# VSS.t27 nfet_03v3 ad=0.9p pd=4.9u as=0.56p ps=2.56u w=2u l=1u
X113 a_23250_7607# vbn.t965 a_23540_7027# VSS.t28 nfet_03v3 ad=0.56p pd=2.56u as=0.56p ps=2.56u w=2u l=1u
X114 a_23540_3547# vbn.t483 a_23250_4127# VSS.t34 nfet_03v3 ad=0.56p pd=2.56u as=0.56p ps=2.56u w=2u l=1u
X115 a_28216_1227# vbn.t716 VSS.t44 VSS.t39 nfet_03v3 ad=0.56p pd=2.56u as=0.56p ps=2.56u w=2u l=1u
X116 a_23250_6447# vbn.t604 a_23540_7027# VSS.t29 nfet_03v3 ad=0.56p pd=2.56u as=0.56p ps=2.56u w=2u l=1u
X117 a_23540_3547# vbn.t441 a_23250_2967# VSS.t35 nfet_03v3 ad=0.56p pd=2.56u as=0.56p ps=2.56u w=2u l=1u
X118 a_23540_7027# vbn.t186 a_23250_6447# VSS.t29 nfet_03v3 ad=0.56p pd=2.56u as=0.56p ps=2.56u w=2u l=1u
X119 vbn.t9 vbn.t8 a_28216_8187# VSS.t26 nfet_03v3 ad=0.56p pd=2.56u as=0.56p ps=2.56u w=2u l=1u
X120 a_23540_8187# vbn.t210 a_23250_7607# VSS.t27 nfet_03v3 ad=0.56p pd=2.56u as=0.56p ps=2.56u w=2u l=1u
X121 net1 vbn.t219 a_23540_8187# VSS.t26 nfet_03v3 ad=0.56p pd=2.56u as=0.56p ps=2.56u w=2u l=1u
X122 a_23540_7027# vbn.t657 a_23250_7607# VSS.t28 nfet_03v3 ad=0.56p pd=2.56u as=0.9p ps=4.9u w=2u l=1u
X123 a_23540_3547# vbn.t481 a_23250_4127# VSS.t34 nfet_03v3 ad=0.56p pd=2.56u as=0.56p ps=2.56u w=2u l=1u
X124 a_23540_1227# vbn.t365 a_23250_1807# VSS.t38 nfet_03v3 ad=0.56p pd=2.56u as=0.56p ps=2.56u w=2u l=1u
X125 a_23540_2387# vbn.t417 a_23250_2967# VSS.t36 nfet_03v3 ad=0.56p pd=2.56u as=0.56p ps=2.56u w=2u l=1u
X126 a_23540_7027# vbn.t970 a_23250_7607# VSS.t24 nfet_03v3 ad=0.56p pd=2.56u as=0.56p ps=2.56u w=2u l=1u
X127 a_23540_3547# vbn.t878 a_23250_4127# VSS.t34 nfet_03v3 ad=0.56p pd=2.56u as=0.56p ps=2.56u w=2u l=1u
X128 a_23540_7027# vbn.t609 a_23250_6447# VSS.t29 nfet_03v3 ad=0.56p pd=2.56u as=0.56p ps=2.56u w=2u l=1u
X129 a_23540_4707# vbn.t493 a_23250_4127# VSS.t33 nfet_03v3 ad=0.56p pd=2.56u as=0.56p ps=2.56u w=2u l=1u
X130 a_27926_1807# vbn.t731 a_28216_2387# VSS.t37 nfet_03v3 ad=0.56p pd=2.56u as=0.56p ps=2.56u w=2u l=1u
X131 a_23540_8187# vbn.t679 a_23250_7607# VSS.t27 nfet_03v3 ad=0.56p pd=2.56u as=0.56p ps=2.56u w=2u l=1u
X132 a_28216_4707# vbn.t765 a_27926_5287# VSS.t32 nfet_03v3 ad=0.56p pd=2.56u as=0.56p ps=2.56u w=2u l=1u
X133 a_23250_4127# vbn.t486 a_23540_3547# VSS.t34 nfet_03v3 ad=0.56p pd=2.56u as=0.56p ps=2.56u w=2u l=1u
X134 a_23250_1807# vbn.t370 a_23540_1227# VSS.t38 nfet_03v3 ad=0.56p pd=2.56u as=0.56p ps=2.56u w=2u l=1u
X135 VSS.t41 vbn.t719 a_28216_1227# VSS.t39 nfet_03v3 ad=0.56p pd=2.56u as=0.56p ps=2.56u w=2u l=1u
X136 a_23540_5867# vbn.t585 a_23250_6447# VSS.t30 nfet_03v3 ad=0.56p pd=2.56u as=0.56p ps=2.56u w=2u l=1u
X137 a_23540_5867# vbn.t561 a_23250_5287# VSS.t31 nfet_03v3 ad=0.56p pd=2.56u as=0.56p ps=2.56u w=2u l=1u
X138 a_23250_2967# vbn.t422 a_23540_2387# VSS.t36 nfet_03v3 ad=0.56p pd=2.56u as=0.56p ps=2.56u w=2u l=1u
X139 net3 vbn.t37 a_23540_1227# VSS.t39 nfet_03v3 ad=0.56p pd=2.56u as=0.56p ps=2.56u w=2u l=1u
X140 a_28216_2387# vbn.t249 a_27926_1807# VSS.t37 nfet_03v3 ad=0.56p pd=2.56u as=0.56p ps=2.56u w=2u l=1u
X141 a_23540_8187# vbn.t677 a_23250_7607# VSS.t27 nfet_03v3 ad=0.56p pd=2.56u as=0.56p ps=2.56u w=2u l=1u
X142 a_28216_4707# vbn.t279 a_27926_4127# VSS.t33 nfet_03v3 ad=0.56p pd=2.56u as=0.9p ps=4.9u w=2u l=1u
X143 a_23250_1807# vbn.t368 a_23540_1227# VSS.t38 nfet_03v3 ad=0.56p pd=2.56u as=0.56p ps=2.56u w=2u l=1u
X144 a_23540_8187# vbn.t976 a_23250_7607# VSS.t27 nfet_03v3 ad=0.56p pd=2.56u as=0.56p ps=2.56u w=2u l=1u
X145 a_23540_8187# vbn.t689 net1 VSS.t26 nfet_03v3 ad=0.56p pd=2.56u as=0.56p ps=2.56u w=2u l=1u
X146 a_23540_4707# vbn.t890 a_23250_4127# VSS.t33 nfet_03v3 ad=0.56p pd=2.56u as=0.56p ps=2.56u w=2u l=1u
X147 a_23250_4127# vbn.t881 a_23540_3547# VSS.t34 nfet_03v3 ad=0.56p pd=2.56u as=0.56p ps=2.56u w=2u l=1u
X148 a_23250_2967# vbn.t871 a_23540_3547# VSS.t25 nfet_03v3 ad=0.56p pd=2.56u as=0.56p ps=2.56u w=2u l=1u
X149 a_23250_1807# vbn.t821 a_23540_1227# VSS.t38 nfet_03v3 ad=0.56p pd=2.56u as=0.56p ps=2.56u w=2u l=1u
X150 a_23250_7607# vbn.t682 a_23540_8187# VSS.t27 nfet_03v3 ad=0.56p pd=2.56u as=0.56p ps=2.56u w=2u l=1u
X151 a_23250_6447# vbn.t590 a_23540_5867# VSS.t30 nfet_03v3 ad=0.56p pd=2.56u as=0.56p ps=2.56u w=2u l=1u
X152 a_23250_5287# vbn.t566 a_23540_5867# VSS.t31 nfet_03v3 ad=0.56p pd=2.56u as=0.56p ps=2.56u w=2u l=1u
X153 a_27926_5287# vbn.t768 a_28216_4707# VSS.t32 nfet_03v3 ad=0.56p pd=2.56u as=0.56p ps=2.56u w=2u l=1u
X154 a_27926_2967# vbn.t736 a_28216_2387# VSS.t36 nfet_03v3 ad=0.56p pd=2.56u as=0.56p ps=2.56u w=2u l=1u
X155 a_23250_5287# vbn.t135 a_23540_4707# VSS.t32 nfet_03v3 ad=0.56p pd=2.56u as=0.56p ps=2.56u w=2u l=1u
X156 VSS.t13 vbnf.t5 VSS.t13 VSS.t12 nfet_03v3 ad=13.7592p pd=49.7u as=0 ps=0 w=49.14u l=10u
X157 a_23250_4127# vbn.t512 a_23540_4707# VSS.t33 nfet_03v3 ad=0.56p pd=2.56u as=0.56p ps=2.56u w=2u l=1u
X158 a_23540_3547# vbn.t489 a_23250_4127# VSS.t34 nfet_03v3 ad=0.56p pd=2.56u as=0.9p ps=4.9u w=2u l=1u
X159 a_28216_8187# vbn.t20 vbn.t21 VSS.t26 nfet_03v3 ad=0.56p pd=2.56u as=0.9p ps=4.9u w=2u l=1u
X160 a_23540_1227# vbn.t373 a_23250_1807# VSS.t38 nfet_03v3 ad=0.56p pd=2.56u as=0.56p ps=2.56u w=2u l=1u
X161 a_23250_5287# vbn.t564 a_23540_5867# VSS.t31 nfet_03v3 ad=0.56p pd=2.56u as=0.56p ps=2.56u w=2u l=1u
X162 a_23250_6447# vbn.t955 a_23540_7027# VSS.t25 nfet_03v3 ad=0.56p pd=2.56u as=0.56p ps=2.56u w=2u l=1u
X163 a_23540_3547# vbn.t886 a_23250_4127# VSS.t24 nfet_03v3 ad=0.56p pd=2.56u as=0.56p ps=2.56u w=2u l=1u
X164 a_23250_5287# vbn.t919 a_23540_5867# VSS.t31 nfet_03v3 ad=0.56p pd=2.56u as=0.56p ps=2.56u w=2u l=1u
X165 a_23540_1227# vbn.t325 net3 VSS.t39 nfet_03v3 ad=0.56p pd=2.56u as=0.56p ps=2.56u w=2u l=1u
X166 a_23540_8187# vbn.t988 net1 VSS.t26 nfet_03v3 ad=0.56p pd=2.56u as=0.56p ps=2.56u w=2u l=1u
X167 a_23250_7607# vbn.t979 a_23540_8187# VSS.t27 nfet_03v3 ad=0.56p pd=2.56u as=0.56p ps=2.56u w=2u l=1u
X168 a_27926_6447# vbn.t778 a_28216_5867# VSS.t30 nfet_03v3 ad=0.56p pd=2.56u as=0.56p ps=2.56u w=2u l=1u
X169 VSS.t21 vbnf.t1 VSS.t21 VSS.t20 nfet_03v3 ad=13.7592p pd=49.7u as=0 ps=0 w=49.14u l=10u
X170 a_23250_1807# vbn.t49 a_23540_1227# VSS.t38 nfet_03v3 ad=0.9p pd=4.9u as=0.56p ps=2.56u w=2u l=1u
X171 a_23250_4127# vbn.t893 a_23540_4707# VSS.t33 nfet_03v3 ad=0.56p pd=2.56u as=0.56p ps=2.56u w=2u l=1u
X172 a_23540_1227# vbn.t824 a_23250_1807# VSS.t38 nfet_03v3 ad=0.56p pd=2.56u as=0.56p ps=2.56u w=2u l=1u
X173 a_27926_2967# vbn.t262 a_28216_3547# VSS.t35 nfet_03v3 ad=0.56p pd=2.56u as=0.56p ps=2.56u w=2u l=1u
X174 a_23540_8187# vbn.t685 a_23250_7607# VSS.t27 nfet_03v3 ad=0.56p pd=2.56u as=0.9p ps=4.9u w=2u l=1u
X175 a_23250_7607# vbn.t640 a_23540_7027# VSS.t28 nfet_03v3 ad=0.56p pd=2.56u as=0.56p ps=2.56u w=2u l=1u
X176 a_23540_5867# vbn.t569 a_23250_5287# VSS.t31 nfet_03v3 ad=0.56p pd=2.56u as=0.56p ps=2.56u w=2u l=1u
X177 net1 vbn.t708 a_23540_8187# VSS.t26 nfet_03v3 ad=0.56p pd=2.56u as=0.56p ps=2.56u w=2u l=1u
X178 a_23250_2967# vbn.t440 a_23540_3547# VSS.t35 nfet_03v3 ad=0.56p pd=2.56u as=0.56p ps=2.56u w=2u l=1u
X179 a_23540_2387# vbn.t78 a_23250_2967# VSS.t36 nfet_03v3 ad=0.56p pd=2.56u as=0.56p ps=2.56u w=2u l=1u
X180 a_28216_1227# vbn.t237 VSS.t47 VSS.t39 nfet_03v3 ad=0.56p pd=2.56u as=0.9p ps=4.9u w=2u l=1u
X181 a_23540_2387# vbn.t393 a_23250_1807# VSS.t37 nfet_03v3 ad=0.56p pd=2.56u as=0.56p ps=2.56u w=2u l=1u
X182 a_23540_8187# vbn.t984 a_23250_7607# VSS.t24 nfet_03v3 ad=0.56p pd=2.56u as=0.56p ps=2.56u w=2u l=1u
X183 a_23540_1227# vbn.t54 a_23250_1807# VSS.t38 nfet_03v3 ad=0.56p pd=2.56u as=0.56p ps=2.56u w=2u l=1u
X184 a_23540_4707# vbn.t521 a_23250_5287# VSS.t32 nfet_03v3 ad=0.56p pd=2.56u as=0.56p ps=2.56u w=2u l=1u
X185 a_23540_3547# vbn.t104 a_23250_2967# VSS.t35 nfet_03v3 ad=0.56p pd=2.56u as=0.9p ps=4.9u w=2u l=1u
X186 a_23540_4707# vbn.t898 a_23250_4127# VSS.t33 nfet_03v3 ad=0.56p pd=2.56u as=0.56p ps=2.56u w=2u l=1u
X187 a_23250_5287# vbn.t147 a_23540_5867# VSS.t31 nfet_03v3 ad=0.9p pd=4.9u as=0.56p ps=2.56u w=2u l=1u
X188 a_23540_5867# vbn.t922 a_23250_5287# VSS.t31 nfet_03v3 ad=0.56p pd=2.56u as=0.56p ps=2.56u w=2u l=1u
X189 a_23540_1227# vbn.t806 net3 VSS.t39 nfet_03v3 ad=0.56p pd=2.56u as=0.56p ps=2.56u w=2u l=1u
X190 a_27926_6447# vbn.t304 a_28216_7027# VSS.t29 nfet_03v3 ad=0.56p pd=2.56u as=0.56p ps=2.56u w=2u l=1u
X191 net1 vbn.t991 a_23540_8187# VSS.t26 nfet_03v3 ad=0.56p pd=2.56u as=0.56p ps=2.56u w=2u l=1u
X192 a_23250_6447# vbn.t608 a_23540_7027# VSS.t29 nfet_03v3 ad=0.56p pd=2.56u as=0.56p ps=2.56u w=2u l=1u
X193 a_23250_1807# vbn.t398 a_23540_2387# VSS.t37 nfet_03v3 ad=0.56p pd=2.56u as=0.56p ps=2.56u w=2u l=1u
X194 a_23540_5867# vbn.t162 a_23250_6447# VSS.t30 nfet_03v3 ad=0.56p pd=2.56u as=0.56p ps=2.56u w=2u l=1u
X195 a_28216_4707# vbn.t286 a_27926_5287# VSS.t32 nfet_03v3 ad=0.56p pd=2.56u as=0.9p ps=4.9u w=2u l=1u
X196 net3 vbn.t344 a_23540_1227# VSS.t39 nfet_03v3 ad=0.56p pd=2.56u as=0.56p ps=2.56u w=2u l=1u
X197 a_23250_1807# vbn.t59 a_23540_1227# VSS.t38 nfet_03v3 ad=0.56p pd=2.56u as=0.56p ps=2.56u w=2u l=1u
X198 a_23540_3547# vbn.t443 a_23250_2967# VSS.t35 nfet_03v3 ad=0.56p pd=2.56u as=0.56p ps=2.56u w=2u l=1u
X199 a_23540_4707# vbn.t128 a_23250_4127# VSS.t33 nfet_03v3 ad=0.56p pd=2.56u as=0.56p ps=2.56u w=2u l=1u
X200 a_23540_7027# vbn.t188 a_23250_6447# VSS.t29 nfet_03v3 ad=0.56p pd=2.56u as=0.9p ps=4.9u w=2u l=1u
X201 a_23540_1227# vbn.t351 a_23250_1807# VSS.t38 nfet_03v3 ad=0.56p pd=2.56u as=0.56p ps=2.56u w=2u l=1u
X202 a_23250_1807# vbn.t396 a_23540_2387# VSS.t37 nfet_03v3 ad=0.56p pd=2.56u as=0.56p ps=2.56u w=2u l=1u
X203 a_23540_5867# vbn.t152 a_23250_5287# VSS.t31 nfet_03v3 ad=0.56p pd=2.56u as=0.56p ps=2.56u w=2u l=1u
X204 a_23540_8187# vbn.t996 net1 VSS.t26 nfet_03v3 ad=0.56p pd=2.56u as=0.56p ps=2.56u w=2u l=1u
X205 a_23540_4707# vbn.t904 a_23250_5287# VSS.t32 nfet_03v3 ad=0.56p pd=2.56u as=0.56p ps=2.56u w=2u l=1u
X206 a_23250_1807# vbn.t835 a_23540_2387# VSS.t37 nfet_03v3 ad=0.56p pd=2.56u as=0.56p ps=2.56u w=2u l=1u
X207 a_28216_7027# vbn.t791 a_27926_7607# VSS.t28 nfet_03v3 ad=0.9p pd=4.9u as=0.56p ps=2.56u w=2u l=1u
X208 a_23250_1807# vbn.t57 a_23540_1227# VSS.t38 nfet_03v3 ad=0.56p pd=2.56u as=0.56p ps=2.56u w=2u l=1u
X209 a_23540_7027# vbn.t972 a_23250_7607# VSS.t22 nfet_03v3 ad=0.56p pd=2.56u as=0.9p ps=4.9u w=2u l=1u
X210 net3 vbn.t809 a_23540_1227# VSS.t39 nfet_03v3 ad=0.56p pd=2.56u as=0.56p ps=2.56u w=2u l=1u
X211 a_23540_2387# vbn.t401 a_23250_1807# VSS.t37 nfet_03v3 ad=0.56p pd=2.56u as=0.56p ps=2.56u w=2u l=1u
X212 a_23540_7027# vbn.t611 a_23250_6447# VSS.t29 nfet_03v3 ad=0.56p pd=2.56u as=0.56p ps=2.56u w=2u l=1u
X213 a_23250_5287# vbn.t540 a_23540_4707# VSS.t32 nfet_03v3 ad=0.56p pd=2.56u as=0.56p ps=2.56u w=2u l=1u
X214 a_23540_4707# vbn.t495 a_23250_4127# VSS.t33 nfet_03v3 ad=0.56p pd=2.56u as=0.56p ps=2.56u w=2u l=1u
X215 a_23250_4127# vbn.t472 a_23540_3547# VSS.t34 nfet_03v3 ad=0.56p pd=2.56u as=0.56p ps=2.56u w=2u l=1u
X216 a_23250_2967# vbn.t448 a_23540_3547# VSS.t35 nfet_03v3 ad=0.56p pd=2.56u as=0.56p ps=2.56u w=2u l=1u
X217 a_23540_5867# vbn.t547 a_23250_5287# VSS.t31 nfet_03v3 ad=0.56p pd=2.56u as=0.56p ps=2.56u w=2u l=1u
X218 a_23250_5287# vbn.t157 a_23540_5867# VSS.t31 nfet_03v3 ad=0.56p pd=2.56u as=0.56p ps=2.56u w=2u l=1u
X219 a_23540_8187# vbn.t226 net1 VSS.t26 nfet_03v3 ad=0.56p pd=2.56u as=0.56p ps=2.56u w=2u l=1u
X220 a_27926_2967# vbn.t257 a_28216_2387# VSS.t36 nfet_03v3 ad=0.56p pd=2.56u as=0.56p ps=2.56u w=2u l=1u
X221 a_28216_4707# vbn.t275 a_27926_4127# VSS.t33 nfet_03v3 ad=0.56p pd=2.56u as=0.56p ps=2.56u w=2u l=1u
X222 a_23250_4127# vbn.t131 a_23540_4707# VSS.t33 nfet_03v3 ad=0.56p pd=2.56u as=0.56p ps=2.56u w=2u l=1u
X223 a_27926_7607# vbn.t309 a_28216_7027# VSS.t28 nfet_03v3 ad=0.56p pd=2.56u as=0.56p ps=2.56u w=2u l=1u
X224 a_23540_1227# vbn.t814 net3 VSS.t39 nfet_03v3 ad=0.56p pd=2.56u as=0.56p ps=2.56u w=2u l=1u
X225 a_23250_1807# vbn.t63 a_23540_2387# VSS.t37 nfet_03v3 ad=0.9p pd=4.9u as=0.56p ps=2.56u w=2u l=1u
X226 a_23250_5287# vbn.t155 a_23540_5867# VSS.t31 nfet_03v3 ad=0.56p pd=2.56u as=0.56p ps=2.56u w=2u l=1u
X227 a_23250_5287# vbn.t907 a_23540_4707# VSS.t32 nfet_03v3 ad=0.56p pd=2.56u as=0.56p ps=2.56u w=2u l=1u
X228 a_23250_2967# vbn.t847 a_23540_2387# VSS.t36 nfet_03v3 ad=0.9p pd=4.9u as=0.56p ps=2.56u w=2u l=1u
X229 a_23540_2387# vbn.t838 a_23250_1807# VSS.t37 nfet_03v3 ad=0.56p pd=2.56u as=0.56p ps=2.56u w=2u l=1u
X230 a_23250_6447# vbn.t616 a_23540_7027# VSS.t29 nfet_03v3 ad=0.56p pd=2.56u as=0.56p ps=2.56u w=2u l=1u
X231 a_23540_8187# vbn.t691 net1 VSS.t26 nfet_03v3 ad=0.56p pd=2.56u as=0.56p ps=2.56u w=2u l=1u
X232 a_23250_7607# vbn.t668 a_23540_8187# VSS.t27 nfet_03v3 ad=0.56p pd=2.56u as=0.56p ps=2.56u w=2u l=1u
X233 a_27926_6447# vbn.t299 a_28216_5867# VSS.t30 nfet_03v3 ad=0.56p pd=2.56u as=0.56p ps=2.56u w=2u l=1u
X234 a_23250_4127# vbn.t498 a_23540_4707# VSS.t33 nfet_03v3 ad=0.56p pd=2.56u as=0.56p ps=2.56u w=2u l=1u
X235 a_23540_3547# vbn.t451 a_23250_2967# VSS.t35 nfet_03v3 ad=0.56p pd=2.56u as=0.56p ps=2.56u w=2u l=1u
X236 a_23540_1227# vbn.t44 net3 VSS.t39 nfet_03v3 ad=0.56p pd=2.56u as=0.56p ps=2.56u w=2u l=1u
X237 a_28216_8187# vbn.t28 vbn.t29 VSS.t26 nfet_03v3 ad=0.56p pd=2.56u as=0.56p ps=2.56u w=2u l=1u
X238 VDD.t17 VSS.t58 net2 VDD.t16 pfet_03v3 ad=0.225p pd=1.9u as=0.225p ps=1.9u w=0.5u l=10u
X239 a_23540_2387# vbn.t68 a_23250_1807# VSS.t37 nfet_03v3 ad=0.56p pd=2.56u as=0.56p ps=2.56u w=2u l=1u
X240 net1 vbn.t229 a_23540_8187# VSS.t26 nfet_03v3 ad=0.56p pd=2.56u as=0.56p ps=2.56u w=2u l=1u
X241 a_23540_1227# vbn.t375 a_23250_1807# VSS.t38 nfet_03v3 ad=0.56p pd=2.56u as=0.56p ps=2.56u w=2u l=1u
X242 a_23250_6447# vbn.t931 a_23540_5867# VSS.t30 nfet_03v3 ad=0.9p pd=4.9u as=0.56p ps=2.56u w=2u l=1u
X243 a_23540_4707# vbn.t912 a_23250_5287# VSS.t32 nfet_03v3 ad=0.56p pd=2.56u as=0.56p ps=2.56u w=2u l=1u
X244 a_28216_3547# vbn.t749 a_27926_4127# VSS.t34 nfet_03v3 ad=0.9p pd=4.9u as=0.56p ps=2.56u w=2u l=1u
X245 a_23540_3547# vbn.t888 a_23250_4127# VSS.t22 nfet_03v3 ad=0.56p pd=2.56u as=0.9p ps=4.9u w=2u l=1u
X246 a_23540_4707# vbn.t503 a_23250_4127# VSS.t33 nfet_03v3 ad=0.56p pd=2.56u as=0.56p ps=2.56u w=2u l=1u
X247 a_23250_7607# vbn.t642 a_23540_7027# VSS.t28 nfet_03v3 ad=0.56p pd=2.56u as=0.56p ps=2.56u w=2u l=1u
X248 a_23540_7027# vbn.t619 a_23250_6447# VSS.t29 nfet_03v3 ad=0.56p pd=2.56u as=0.56p ps=2.56u w=2u l=1u
X249 a_23540_1227# vbn.t327 net3 VSS.t39 nfet_03v3 ad=0.56p pd=2.56u as=0.56p ps=2.56u w=2u l=1u
X250 a_28216_3547# vbn.t746 a_27926_2967# VSS.t35 nfet_03v3 ad=0.56p pd=2.56u as=0.56p ps=2.56u w=2u l=1u
X251 net1 vbn.t694 a_23540_8187# VSS.t26 nfet_03v3 ad=0.56p pd=2.56u as=0.56p ps=2.56u w=2u l=1u
X252 a_23250_1807# vbn.t73 a_23540_2387# VSS.t37 nfet_03v3 ad=0.56p pd=2.56u as=0.56p ps=2.56u w=2u l=1u
X253 a_23540_4707# vbn.t142 a_23250_5287# VSS.t32 nfet_03v3 ad=0.56p pd=2.56u as=0.56p ps=2.56u w=2u l=1u
X254 a_23540_2387# vbn.t379 a_23250_1807# VSS.t37 nfet_03v3 ad=0.56p pd=2.56u as=0.56p ps=2.56u w=2u l=1u
X255 a_23540_1227# vbn.t826 a_23250_1807# VSS.t38 nfet_03v3 ad=0.56p pd=2.56u as=0.56p ps=2.56u w=2u l=1u
X256 a_23250_2967# vbn.t432 a_23540_2387# VSS.t36 nfet_03v3 ad=0.56p pd=2.56u as=0.56p ps=2.56u w=2u l=1u
X257 a_28216_1227# vbn.t233 VSS.t51 VSS.t39 nfet_03v3 ad=0.56p pd=2.56u as=0.56p ps=2.56u w=2u l=1u
X258 a_27926_4127# vbn.t267 a_28216_3547# VSS.t34 nfet_03v3 ad=0.56p pd=2.56u as=0.56p ps=2.56u w=2u l=1u
X259 a_23540_5867# vbn.t571 a_23250_5287# VSS.t31 nfet_03v3 ad=0.56p pd=2.56u as=0.56p ps=2.56u w=2u l=1u
X260 net3 vbn.t47 a_23540_1227# VSS.t39 nfet_03v3 ad=0.56p pd=2.56u as=0.56p ps=2.56u w=2u l=1u
X261 a_28216_8187# vbn.t798 a_27926_7607# VSS.t27 nfet_03v3 ad=0.9p pd=4.9u as=0.56p ps=2.56u w=2u l=1u
X262 a_28216_2387# vbn.t741 a_27926_2967# VSS.t36 nfet_03v3 ad=0.56p pd=2.56u as=0.9p ps=4.9u w=2u l=1u
X263 a_23540_2387# vbn.t80 a_23250_2967# VSS.t36 nfet_03v3 ad=0.56p pd=2.56u as=0.56p ps=2.56u w=2u l=1u
X264 a_23250_1807# vbn.t71 a_23540_2387# VSS.t37 nfet_03v3 ad=0.56p pd=2.56u as=0.56p ps=2.56u w=2u l=1u
X265 a_23540_8187# vbn.t986 a_23250_7607# VSS.t22 nfet_03v3 ad=0.56p pd=2.56u as=0.9p ps=4.9u w=2u l=1u
X266 a_28216_7027# vbn.t788 a_27926_6447# VSS.t29 nfet_03v3 ad=0.56p pd=2.56u as=0.56p ps=2.56u w=2u l=1u
X267 a_23540_8187# vbn.t699 net1 VSS.t26 nfet_03v3 ad=0.56p pd=2.56u as=0.56p ps=2.56u w=2u l=1u
X268 a_23250_1807# vbn.t831 a_23540_1227# VSS.t23 nfet_03v3 ad=0.56p pd=2.56u as=0.56p ps=2.56u w=2u l=1u
X269 a_23540_4707# vbn.t523 a_23250_5287# VSS.t32 nfet_03v3 ad=0.56p pd=2.56u as=0.56p ps=2.56u w=2u l=1u
X270 a_23540_5867# vbn.t924 a_23250_5287# VSS.t31 nfet_03v3 ad=0.56p pd=2.56u as=0.56p ps=2.56u w=2u l=1u
X271 a_23250_2967# vbn.t855 a_23540_2387# VSS.t36 nfet_03v3 ad=0.56p pd=2.56u as=0.56p ps=2.56u w=2u l=1u
X272 a_23250_6447# vbn.t600 a_23540_5867# VSS.t30 nfet_03v3 ad=0.56p pd=2.56u as=0.56p ps=2.56u w=2u l=1u
X273 a_28216_4707# vbn.t282 a_27926_5287# VSS.t32 nfet_03v3 ad=0.56p pd=2.56u as=0.56p ps=2.56u w=2u l=1u
X274 net3 vbn.t330 a_23540_1227# VSS.t39 nfet_03v3 ad=0.56p pd=2.56u as=0.56p ps=2.56u w=2u l=1u
X275 a_28216_5867# vbn.t783 a_27926_6447# VSS.t30 nfet_03v3 ad=0.56p pd=2.56u as=0.9p ps=4.9u w=2u l=1u
X276 a_23250_2967# vbn.t95 a_23540_3547# VSS.t35 nfet_03v3 ad=0.56p pd=2.56u as=0.56p ps=2.56u w=2u l=1u
X277 a_23250_5287# vbn.t145 a_23540_4707# VSS.t32 nfet_03v3 ad=0.56p pd=2.56u as=0.56p ps=2.56u w=2u l=1u
X278 a_23540_5867# vbn.t164 a_23250_6447# VSS.t30 nfet_03v3 ad=0.56p pd=2.56u as=0.56p ps=2.56u w=2u l=1u
X279 a_27926_7607# vbn.t316 a_28216_8187# VSS.t27 nfet_03v3 ad=0.56p pd=2.56u as=0.56p ps=2.56u w=2u l=1u
X280 a_28216_1227# vbn.t238 a_27926_1807# VSS.t38 nfet_03v3 ad=0.9p pd=4.9u as=0.56p ps=2.56u w=2u l=1u
X281 VSS.t7 vbnf.t8 VSS.t7 VSS.t6 nfet_03v3 ad=13.7592p pd=49.7u as=0 ps=0 w=49.14u l=10u
X282 a_23250_2967# vbn.t83 a_23540_2387# VSS.t36 nfet_03v3 ad=0.56p pd=2.56u as=0.56p ps=2.56u w=2u l=1u
X283 a_23250_6447# vbn.t939 a_23540_5867# VSS.t30 nfet_03v3 ad=0.56p pd=2.56u as=0.56p ps=2.56u w=2u l=1u
X284 a_23250_5287# vbn.t929 a_23540_5867# VSS.t23 nfet_03v3 ad=0.56p pd=2.56u as=0.56p ps=2.56u w=2u l=1u
X285 a_23250_4127# vbn.t474 a_23540_3547# VSS.t34 nfet_03v3 ad=0.56p pd=2.56u as=0.56p ps=2.56u w=2u l=1u
X286 a_23540_1227# vbn.t335 net3 VSS.t39 nfet_03v3 ad=0.56p pd=2.56u as=0.56p ps=2.56u w=2u l=1u
X287 a_28216_7027# vbn.t793 a_27926_7607# VSS.t28 nfet_03v3 ad=0.56p pd=2.56u as=0.56p ps=2.56u w=2u l=1u
X288 a_27926_4127# vbn.t759 a_28216_4707# VSS.t33 nfet_03v3 ad=0.56p pd=2.56u as=0.56p ps=2.56u w=2u l=1u
X289 a_23250_2967# vbn.t434 a_23540_3547# VSS.t35 nfet_03v3 ad=0.9p pd=4.9u as=0.56p ps=2.56u w=2u l=1u
X290 a_23250_2967# vbn.t410 a_23540_2387# VSS.t36 nfet_03v3 ad=0.56p pd=2.56u as=0.56p ps=2.56u w=2u l=1u
X291 a_23250_6447# vbn.t179 a_23540_7027# VSS.t29 nfet_03v3 ad=0.56p pd=2.56u as=0.56p ps=2.56u w=2u l=1u
X292 a_23250_5287# vbn.t526 a_23540_4707# VSS.t32 nfet_03v3 ad=0.56p pd=2.56u as=0.56p ps=2.56u w=2u l=1u
X293 a_28216_4707# vbn.t277 a_27926_4127# VSS.t33 nfet_03v3 ad=0.56p pd=2.56u as=0.56p ps=2.56u w=2u l=1u
X294 a_28216_5867# vbn.t287 a_27926_5287# VSS.t31 nfet_03v3 ad=0.9p pd=4.9u as=0.56p ps=2.56u w=2u l=1u
X295 a_23540_2387# vbn.t403 a_23250_1807# VSS.t37 nfet_03v3 ad=0.56p pd=2.56u as=0.56p ps=2.56u w=2u l=1u
X296 a_23540_3547# vbn.t98 a_23250_2967# VSS.t35 nfet_03v3 ad=0.56p pd=2.56u as=0.56p ps=2.56u w=2u l=1u
X297 a_23540_2387# vbn.t88 a_23250_2967# VSS.t36 nfet_03v3 ad=0.56p pd=2.56u as=0.56p ps=2.56u w=2u l=1u
X298 a_23250_6447# vbn.t167 a_23540_5867# VSS.t30 nfet_03v3 ad=0.56p pd=2.56u as=0.56p ps=2.56u w=2u l=1u
X299 a_23250_2967# vbn.t408 a_23540_2387# VSS.t36 nfet_03v3 ad=0.56p pd=2.56u as=0.56p ps=2.56u w=2u l=1u
X300 a_23250_6447# vbn.t602 a_23540_7027# VSS.t29 nfet_03v3 ad=0.9p pd=4.9u as=0.56p ps=2.56u w=2u l=1u
X301 a_23250_6447# vbn.t578 a_23540_5867# VSS.t30 nfet_03v3 ad=0.56p pd=2.56u as=0.56p ps=2.56u w=2u l=1u
X302 a_23540_4707# vbn.t531 a_23250_5287# VSS.t32 nfet_03v3 ad=0.56p pd=2.56u as=0.56p ps=2.56u w=2u l=1u
X303 vbn.t13 vbn.t12 a_28216_8187# VSS.t26 nfet_03v3 ad=0.56p pd=2.56u as=0.56p ps=2.56u w=2u l=1u
X304 a_23250_7607# vbn.t670 a_23540_8187# VSS.t27 nfet_03v3 ad=0.56p pd=2.56u as=0.56p ps=2.56u w=2u l=1u
X305 a_23540_2387# vbn.t840 a_23250_1807# VSS.t37 nfet_03v3 ad=0.56p pd=2.56u as=0.56p ps=2.56u w=2u l=1u
X306 a_23540_3547# vbn.t455 a_23250_2967# VSS.t35 nfet_03v3 ad=0.56p pd=2.56u as=0.56p ps=2.56u w=2u l=1u
X307 a_27926_7607# vbn.t796 a_28216_7027# VSS.t28 nfet_03v3 ad=0.56p pd=2.56u as=0.56p ps=2.56u w=2u l=1u
X308 a_23540_2387# vbn.t413 a_23250_2967# VSS.t36 nfet_03v3 ad=0.56p pd=2.56u as=0.56p ps=2.56u w=2u l=1u
X309 a_23540_5867# vbn.t172 a_23250_6447# VSS.t30 nfet_03v3 ad=0.56p pd=2.56u as=0.56p ps=2.56u w=2u l=1u
X310 a_23540_7027# vbn.t182 a_23250_6447# VSS.t29 nfet_03v3 ad=0.56p pd=2.56u as=0.56p ps=2.56u w=2u l=1u
X311 a_23250_7607# vbn.t191 a_23540_7027# VSS.t28 nfet_03v3 ad=0.56p pd=2.56u as=0.56p ps=2.56u w=2u l=1u
X312 a_28216_8187# vbn.t24 vbn.t25 VSS.t26 nfet_03v3 ad=0.56p pd=2.56u as=0.56p ps=2.56u w=2u l=1u
X313 a_23250_6447# vbn.t576 a_23540_5867# VSS.t30 nfet_03v3 ad=0.56p pd=2.56u as=0.56p ps=2.56u w=2u l=1u
X314 a_23540_3547# vbn.t453 a_23250_2967# VSS.t35 nfet_03v3 ad=0.56p pd=2.56u as=0.56p ps=2.56u w=2u l=1u
X315 a_23540_1227# vbn.t361 a_23250_1807# VSS.t38 nfet_03v3 ad=0.56p pd=2.56u as=0.56p ps=2.56u w=2u l=1u
X316 a_23540_3547# vbn.t864 a_23250_2967# VSS.t35 nfet_03v3 ad=0.56p pd=2.56u as=0.56p ps=2.56u w=2u l=1u
X317 a_23250_1807# vbn.t845 a_23540_2387# VSS.t23 nfet_03v3 ad=0.56p pd=2.56u as=0.56p ps=2.56u w=2u l=1u
X318 a_23540_7027# vbn.t623 a_23250_6447# VSS.t29 nfet_03v3 ad=0.56p pd=2.56u as=0.56p ps=2.56u w=2u l=1u
X319 a_28216_3547# vbn.t751 a_27926_4127# VSS.t34 nfet_03v3 ad=0.56p pd=2.56u as=0.56p ps=2.56u w=2u l=1u
X320 VSS.t43 vbn.t717 a_28216_1227# VSS.t39 nfet_03v3 ad=0.56p pd=2.56u as=0.56p ps=2.56u w=2u l=1u
X321 a_23540_5867# vbn.t581 a_23250_6447# VSS.t30 nfet_03v3 ad=0.56p pd=2.56u as=0.56p ps=2.56u w=2u l=1u
X322 a_28216_1227# vbn.t235 VSS.t49 VSS.t39 nfet_03v3 ad=0.56p pd=2.56u as=0.56p ps=2.56u w=2u l=1u
X323 a_23540_4707# vbn.t505 a_23250_4127# VSS.t33 nfet_03v3 ad=0.56p pd=2.56u as=0.56p ps=2.56u w=2u l=1u
X324 a_23250_2967# vbn.t458 a_23540_3547# VSS.t35 nfet_03v3 ad=0.56p pd=2.56u as=0.56p ps=2.56u w=2u l=1u
X325 a_23250_1807# vbn.t366 a_23540_1227# VSS.t38 nfet_03v3 ad=0.56p pd=2.56u as=0.56p ps=2.56u w=2u l=1u
X326 a_23540_7027# vbn.t621 a_23250_6447# VSS.t29 nfet_03v3 ad=0.56p pd=2.56u as=0.56p ps=2.56u w=2u l=1u
X327 a_28216_2387# vbn.t245 a_27926_1807# VSS.t37 nfet_03v3 ad=0.9p pd=4.9u as=0.56p ps=2.56u w=2u l=1u
X328 a_23540_5867# vbn.t557 a_23250_5287# VSS.t31 nfet_03v3 ad=0.56p pd=2.56u as=0.56p ps=2.56u w=2u l=1u
X329 a_23540_7027# vbn.t948 a_23250_6447# VSS.t29 nfet_03v3 ad=0.56p pd=2.56u as=0.56p ps=2.56u w=2u l=1u
X330 a_23540_7027# vbn.t633 a_23250_7607# VSS.t28 nfet_03v3 ad=0.56p pd=2.56u as=0.56p ps=2.56u w=2u l=1u
X331 a_27926_5287# vbn.t766 a_28216_4707# VSS.t32 nfet_03v3 ad=0.56p pd=2.56u as=0.56p ps=2.56u w=2u l=1u
X332 a_28216_8187# vbn.t800 a_27926_7607# VSS.t27 nfet_03v3 ad=0.56p pd=2.56u as=0.56p ps=2.56u w=2u l=1u
X333 a_23250_2967# vbn.t867 a_23540_3547# VSS.t35 nfet_03v3 ad=0.56p pd=2.56u as=0.56p ps=2.56u w=2u l=1u
X334 a_23250_2967# vbn.t857 a_23540_2387# VSS.t25 nfet_03v3 ad=0.56p pd=2.56u as=0.56p ps=2.56u w=2u l=1u
X335 a_23250_6447# vbn.t626 a_23540_7027# VSS.t29 nfet_03v3 ad=0.56p pd=2.56u as=0.56p ps=2.56u w=2u l=1u
X336 a_23250_4127# vbn.t510 a_23540_4707# VSS.t33 nfet_03v3 ad=0.56p pd=2.56u as=0.56p ps=2.56u w=2u l=1u
X337 a_27926_4127# vbn.t754 a_28216_3547# VSS.t34 nfet_03v3 ad=0.56p pd=2.56u as=0.56p ps=2.56u w=2u l=1u
X338 a_27926_1807# vbn.t722 a_28216_1227# VSS.t38 nfet_03v3 ad=0.56p pd=2.56u as=0.56p ps=2.56u w=2u l=1u
X339 a_23250_5287# vbn.t562 a_23540_5867# VSS.t31 nfet_03v3 ad=0.56p pd=2.56u as=0.56p ps=2.56u w=2u l=1u
X340 a_28216_4707# vbn.t284 a_27926_5287# VSS.t32 nfet_03v3 ad=0.56p pd=2.56u as=0.56p ps=2.56u w=2u l=1u
X341 a_23540_8187# vbn.t701 net1 VSS.t26 nfet_03v3 ad=0.56p pd=2.56u as=0.56p ps=2.56u w=2u l=1u
X342 a_23250_4127# vbn.t107 a_23540_3547# VSS.t34 nfet_03v3 ad=0.56p pd=2.56u as=0.56p ps=2.56u w=2u l=1u
X343 a_28216_7027# vbn.t314 a_27926_7607# VSS.t28 nfet_03v3 ad=0.56p pd=2.56u as=0.9p ps=4.9u w=2u l=1u
X344 a_23250_4127# vbn.t508 a_23540_4707# VSS.t33 nfet_03v3 ad=0.56p pd=2.56u as=0.56p ps=2.56u w=2u l=1u
X345 a_23540_3547# vbn.t461 a_23250_2967# VSS.t35 nfet_03v3 ad=0.56p pd=2.56u as=0.9p ps=4.9u w=2u l=1u
X346 a_23250_6447# vbn.t951 a_23540_7027# VSS.t29 nfet_03v3 ad=0.56p pd=2.56u as=0.56p ps=2.56u w=2u l=1u
X347 a_23250_6447# vbn.t941 a_23540_5867# VSS.t25 nfet_03v3 ad=0.56p pd=2.56u as=0.56p ps=2.56u w=2u l=1u
X348 a_23250_4127# vbn.t891 a_23540_4707# VSS.t33 nfet_03v3 ad=0.56p pd=2.56u as=0.56p ps=2.56u w=2u l=1u
X349 a_23540_3547# vbn.t872 a_23250_2967# VSS.t24 nfet_03v3 ad=0.56p pd=2.56u as=0.56p ps=2.56u w=2u l=1u
X350 a_23540_7027# vbn.t960 a_23250_7607# VSS.t28 nfet_03v3 ad=0.56p pd=2.56u as=0.56p ps=2.56u w=2u l=1u
X351 net1 vbn.t706 a_23540_8187# VSS.t26 nfet_03v3 ad=0.56p pd=2.56u as=0.56p ps=2.56u w=2u l=1u
X352 a_27926_5287# vbn.t771 a_28216_5867# VSS.t31 nfet_03v3 ad=0.56p pd=2.56u as=0.56p ps=2.56u w=2u l=1u
X353 a_27926_7607# vbn.t803 a_28216_8187# VSS.t27 nfet_03v3 ad=0.56p pd=2.56u as=0.56p ps=2.56u w=2u l=1u
X354 a_23250_7607# vbn.t205 a_23540_8187# VSS.t27 nfet_03v3 ad=0.56p pd=2.56u as=0.56p ps=2.56u w=2u l=1u
X355 a_23250_7607# vbn.t652 a_23540_7027# VSS.t28 nfet_03v3 ad=0.56p pd=2.56u as=0.56p ps=2.56u w=2u l=1u
X356 a_23540_7027# vbn.t629 a_23250_6447# VSS.t29 nfet_03v3 ad=0.56p pd=2.56u as=0.9p ps=4.9u w=2u l=1u
X357 a_23540_4707# vbn.t513 a_23250_4127# VSS.t33 nfet_03v3 ad=0.56p pd=2.56u as=0.56p ps=2.56u w=2u l=1u
X358 a_23540_1227# vbn.t50 a_23250_1807# VSS.t38 nfet_03v3 ad=0.56p pd=2.56u as=0.56p ps=2.56u w=2u l=1u
X359 a_27926_2967# vbn.t255 a_28216_2387# VSS.t36 nfet_03v3 ad=0.56p pd=2.56u as=0.56p ps=2.56u w=2u l=1u
X360 a_23540_1227# vbn.t337 net3 VSS.t39 nfet_03v3 ad=0.56p pd=2.56u as=0.56p ps=2.56u w=2u l=1u
X361 net1 vbn.t704 a_23540_8187# VSS.t26 nfet_03v3 ad=0.56p pd=2.56u as=0.56p ps=2.56u w=2u l=1u
X362 a_23250_2967# vbn.t412 a_23540_2387# VSS.t36 nfet_03v3 ad=0.56p pd=2.56u as=0.56p ps=2.56u w=2u l=1u
X363 a_23540_2387# vbn.t389 a_23250_1807# VSS.t37 nfet_03v3 ad=0.56p pd=2.56u as=0.56p ps=2.56u w=2u l=1u
X364 a_23540_7027# vbn.t956 a_23250_6447# VSS.t24 nfet_03v3 ad=0.56p pd=2.56u as=0.56p ps=2.56u w=2u l=1u
X365 net1 vbn.t989 a_23540_8187# VSS.t26 nfet_03v3 ad=0.56p pd=2.56u as=0.56p ps=2.56u w=2u l=1u
X366 a_23540_3547# vbn.t465 a_23250_4127# VSS.t34 nfet_03v3 ad=0.56p pd=2.56u as=0.56p ps=2.56u w=2u l=1u
X367 VDD.t7 net1 net1 VDD.t6 pfet_03v3 ad=3.92p pd=14.56u as=3.92p ps=14.56u w=14u l=14u
X368 a_23250_4127# vbn.t119 a_23540_4707# VSS.t33 nfet_03v3 ad=0.9p pd=4.9u as=0.56p ps=2.56u w=2u l=1u
X369 a_23540_2387# vbn.t90 a_23250_2967# VSS.t36 nfet_03v3 ad=0.56p pd=2.56u as=0.9p ps=4.9u w=2u l=1u
X370 a_23250_7607# vbn.t963 a_23540_7027# VSS.t28 nfet_03v3 ad=0.56p pd=2.56u as=0.56p ps=2.56u w=2u l=1u
X371 a_23540_4707# vbn.t894 a_23250_4127# VSS.t33 nfet_03v3 ad=0.56p pd=2.56u as=0.56p ps=2.56u w=2u l=1u
X372 vbn.t0 net2 net1 VSS.t0 nfet_03v3 ad=0.45p pd=2.9u as=0.45p ps=2.9u w=1u l=0.28u
X373 net3 vbn.t342 a_23540_1227# VSS.t39 nfet_03v3 ad=0.56p pd=2.56u as=0.56p ps=2.56u w=2u l=1u
X374 a_23540_8187# vbn.t709 net1 VSS.t26 nfet_03v3 ad=0.56p pd=2.56u as=0.56p ps=2.56u w=2u l=1u
X375 a_27926_6447# vbn.t297 a_28216_5867# VSS.t30 nfet_03v3 ad=0.56p pd=2.56u as=0.56p ps=2.56u w=2u l=1u
X376 a_23250_6447# vbn.t580 a_23540_5867# VSS.t30 nfet_03v3 ad=0.56p pd=2.56u as=0.56p ps=2.56u w=2u l=1u
X377 a_23540_4707# vbn.t533 a_23250_5287# VSS.t32 nfet_03v3 ad=0.56p pd=2.56u as=0.56p ps=2.56u w=2u l=1u
X378 a_23250_1807# vbn.t394 a_23540_2387# VSS.t37 nfet_03v3 ad=0.56p pd=2.56u as=0.56p ps=2.56u w=2u l=1u
X379 a_23540_5867# vbn.t148 a_23250_5287# VSS.t31 nfet_03v3 ad=0.56p pd=2.56u as=0.56p ps=2.56u w=2u l=1u
X380 a_28216_3547# vbn.t272 a_27926_4127# VSS.t34 nfet_03v3 ad=0.56p pd=2.56u as=0.9p ps=4.9u w=2u l=1u
X381 net3 vbn.t340 a_23540_1227# VSS.t39 nfet_03v3 ad=0.56p pd=2.56u as=0.56p ps=2.56u w=2u l=1u
X382 a_23540_8187# vbn.t661 a_23250_7607# VSS.t27 nfet_03v3 ad=0.56p pd=2.56u as=0.56p ps=2.56u w=2u l=1u
X383 a_23540_2387# vbn.t415 a_23250_2967# VSS.t36 nfet_03v3 ad=0.56p pd=2.56u as=0.56p ps=2.56u w=2u l=1u
X384 a_23540_4707# vbn.t124 a_23250_4127# VSS.t33 nfet_03v3 ad=0.56p pd=2.56u as=0.56p ps=2.56u w=2u l=1u
X385 a_23540_5867# vbn.t174 a_23250_6447# VSS.t30 nfet_03v3 ad=0.56p pd=2.56u as=0.9p ps=4.9u w=2u l=1u
X386 a_23540_7027# vbn.t968 a_23250_7607# VSS.t28 nfet_03v3 ad=0.56p pd=2.56u as=0.56p ps=2.56u w=2u l=1u
X387 net3 vbn.t807 a_23540_1227# VSS.t39 nfet_03v3 ad=0.56p pd=2.56u as=0.56p ps=2.56u w=2u l=1u
X388 net1 vbn.t217 a_23540_8187# VSS.t26 nfet_03v3 ad=0.9p pd=4.9u as=0.56p ps=2.56u w=2u l=1u
X389 a_23540_3547# vbn.t876 a_23250_4127# VSS.t34 nfet_03v3 ad=0.56p pd=2.56u as=0.56p ps=2.56u w=2u l=1u
X390 a_23540_8187# vbn.t992 net1 VSS.t26 nfet_03v3 ad=0.56p pd=2.56u as=0.56p ps=2.56u w=2u l=1u
X391 a_23250_5287# vbn.t538 a_23540_4707# VSS.t32 nfet_03v3 ad=0.56p pd=2.56u as=0.56p ps=2.56u w=2u l=1u
X392 a_27926_1807# vbn.t729 a_28216_2387# VSS.t37 nfet_03v3 ad=0.56p pd=2.56u as=0.56p ps=2.56u w=2u l=1u
X393 a_28216_8187# vbn.t321 a_27926_7607# VSS.t27 nfet_03v3 ad=0.56p pd=2.56u as=0.9p ps=4.9u w=2u l=1u
X394 a_23540_1227# vbn.t345 net3 VSS.t39 nfet_03v3 ad=0.56p pd=2.56u as=0.56p ps=2.56u w=2u l=1u
X395 a_23250_4127# vbn.t484 a_23540_3547# VSS.t34 nfet_03v3 ad=0.56p pd=2.56u as=0.56p ps=2.56u w=2u l=1u
X396 a_23250_4127# vbn.t129 a_23540_4707# VSS.t33 nfet_03v3 ad=0.56p pd=2.56u as=0.56p ps=2.56u w=2u l=1u
X397 a_23540_5867# vbn.t583 a_23250_6447# VSS.t30 nfet_03v3 ad=0.56p pd=2.56u as=0.56p ps=2.56u w=2u l=1u
X398 a_23250_5287# vbn.t536 a_23540_4707# VSS.t32 nfet_03v3 ad=0.56p pd=2.56u as=0.56p ps=2.56u w=2u l=1u
X399 a_23540_4707# vbn.t491 a_23250_4127# VSS.t33 nfet_03v3 ad=0.56p pd=2.56u as=0.56p ps=2.56u w=2u l=1u
X400 a_23250_2967# vbn.t444 a_23540_3547# VSS.t35 nfet_03v3 ad=0.56p pd=2.56u as=0.56p ps=2.56u w=2u l=1u
X401 a_23250_2967# vbn.t420 a_23540_2387# VSS.t36 nfet_03v3 ad=0.56p pd=2.56u as=0.56p ps=2.56u w=2u l=1u
X402 a_23540_7027# vbn.t198 a_23250_7607# VSS.t28 nfet_03v3 ad=0.56p pd=2.56u as=0.56p ps=2.56u w=2u l=1u
X403 a_27926_1807# vbn.t243 a_28216_1227# VSS.t38 nfet_03v3 ad=0.56p pd=2.56u as=0.56p ps=2.56u w=2u l=1u
X404 a_23540_8187# vbn.t222 net1 VSS.t26 nfet_03v3 ad=0.56p pd=2.56u as=0.56p ps=2.56u w=2u l=1u
X405 a_23540_8187# vbn.t974 a_23250_7607# VSS.t27 nfet_03v3 ad=0.56p pd=2.56u as=0.56p ps=2.56u w=2u l=1u
X406 a_23250_5287# vbn.t905 a_23540_4707# VSS.t32 nfet_03v3 ad=0.56p pd=2.56u as=0.56p ps=2.56u w=2u l=1u
X407 a_23250_4127# vbn.t127 a_23540_4707# VSS.t33 nfet_03v3 ad=0.56p pd=2.56u as=0.56p ps=2.56u w=2u l=1u
X408 net3 vbn.t35 a_23540_1227# VSS.t39 nfet_03v3 ad=0.9p pd=4.9u as=0.56p ps=2.56u w=2u l=1u
X409 a_23540_1227# vbn.t810 net3 VSS.t39 nfet_03v3 ad=0.56p pd=2.56u as=0.56p ps=2.56u w=2u l=1u
X410 a_23250_4127# vbn.t879 a_23540_3547# VSS.t34 nfet_03v3 ad=0.56p pd=2.56u as=0.56p ps=2.56u w=2u l=1u
X411 a_23250_1807# vbn.t819 a_23540_1227# VSS.t38 nfet_03v3 ad=0.9p pd=4.9u as=0.56p ps=2.56u w=2u l=1u
X412 a_23250_7607# vbn.t680 a_23540_8187# VSS.t27 nfet_03v3 ad=0.56p pd=2.56u as=0.56p ps=2.56u w=2u l=1u
X413 a_23540_7027# vbn.t635 a_23250_7607# VSS.t28 nfet_03v3 ad=0.56p pd=2.56u as=0.56p ps=2.56u w=2u l=1u
X414 a_23250_6447# vbn.t612 a_23540_7027# VSS.t29 nfet_03v3 ad=0.56p pd=2.56u as=0.56p ps=2.56u w=2u l=1u
X415 a_23250_6447# vbn.t588 a_23540_5867# VSS.t30 nfet_03v3 ad=0.56p pd=2.56u as=0.56p ps=2.56u w=2u l=1u
X416 a_23540_4707# vbn.t541 a_23250_5287# VSS.t32 nfet_03v3 ad=0.56p pd=2.56u as=0.56p ps=2.56u w=2u l=1u
X417 a_23540_8187# vbn.t687 net1 VSS.t26 nfet_03v3 ad=0.56p pd=2.56u as=0.56p ps=2.56u w=2u l=1u
X418 a_23540_2387# vbn.t64 a_23250_1807# VSS.t37 nfet_03v3 ad=0.56p pd=2.56u as=0.56p ps=2.56u w=2u l=1u
X419 net1 vbn.t227 a_23540_8187# VSS.t26 nfet_03v3 ad=0.56p pd=2.56u as=0.56p ps=2.56u w=2u l=1u
X420 a_27926_5287# vbn.t292 a_28216_5867# VSS.t31 nfet_03v3 ad=0.56p pd=2.56u as=0.56p ps=2.56u w=2u l=1u
X421 a_28216_7027# vbn.t310 a_27926_7607# VSS.t28 nfet_03v3 ad=0.56p pd=2.56u as=0.56p ps=2.56u w=2u l=1u
X422 a_23540_2387# vbn.t423 a_23250_2967# VSS.t36 nfet_03v3 ad=0.56p pd=2.56u as=0.56p ps=2.56u w=2u l=1u
X423 a_23540_1227# vbn.t40 net3 VSS.t39 nfet_03v3 ad=0.56p pd=2.56u as=0.56p ps=2.56u w=2u l=1u
X424 a_23250_7607# vbn.t201 a_23540_7027# VSS.t28 nfet_03v3 ad=0.56p pd=2.56u as=0.56p ps=2.56u w=2u l=1u
X425 net1 vbn.t225 a_23540_8187# VSS.t26 nfet_03v3 ad=0.56p pd=2.56u as=0.56p ps=2.56u w=2u l=1u
X426 a_23540_3547# vbn.t884 a_23250_4127# VSS.t34 nfet_03v3 ad=0.56p pd=2.56u as=0.56p ps=2.56u w=2u l=1u
X427 a_23250_5287# vbn.t133 a_23540_4707# VSS.t32 nfet_03v3 ad=0.9p pd=4.9u as=0.56p ps=2.56u w=2u l=1u
X428 a_23250_7607# vbn.t977 a_23540_8187# VSS.t27 nfet_03v3 ad=0.56p pd=2.56u as=0.56p ps=2.56u w=2u l=1u
X429 a_23250_5287# vbn.t917 a_23540_5867# VSS.t31 nfet_03v3 ad=0.9p pd=4.9u as=0.56p ps=2.56u w=2u l=1u
X430 a_23540_4707# vbn.t908 a_23250_5287# VSS.t32 nfet_03v3 ad=0.56p pd=2.56u as=0.56p ps=2.56u w=2u l=1u
X431 a_28216_3547# vbn.t742 a_27926_2967# VSS.t35 nfet_03v3 ad=0.9p pd=4.9u as=0.56p ps=2.56u w=2u l=1u
X432 net3 net4 VSS nwell r_width=2u r_length=5.025u
X433 a_23540_3547# vbn.t874 a_23250_2967# VSS.t22 nfet_03v3 ad=0.56p pd=2.56u as=0.9p ps=4.9u w=2u l=1u
X434 a_23250_7607# vbn.t638 a_23540_7027# VSS.t28 nfet_03v3 ad=0.56p pd=2.56u as=0.56p ps=2.56u w=2u l=1u
X435 a_23540_5867# vbn.t591 a_23250_6447# VSS.t30 nfet_03v3 ad=0.56p pd=2.56u as=0.56p ps=2.56u w=2u l=1u
X436 a_23540_3547# vbn.t114 a_23250_4127# VSS.t34 nfet_03v3 ad=0.56p pd=2.56u as=0.56p ps=2.56u w=2u l=1u
X437 net3 vbn.t45 a_23540_1227# VSS.t39 nfet_03v3 ad=0.56p pd=2.56u as=0.56p ps=2.56u w=2u l=1u
X438 a_23540_1227# vbn.t323 net3 VSS.t39 nfet_03v3 ad=0.56p pd=2.56u as=0.56p ps=2.56u w=2u l=1u
X439 a_28216_2387# vbn.t739 a_27926_2967# VSS.t36 nfet_03v3 ad=0.56p pd=2.56u as=0.56p ps=2.56u w=2u l=1u
X440 a_23540_4707# vbn.t138 a_23250_5287# VSS.t32 nfet_03v3 ad=0.56p pd=2.56u as=0.56p ps=2.56u w=2u l=1u
X441 a_23250_1807# vbn.t376 a_23540_1227# VSS.t38 nfet_03v3 ad=0.56p pd=2.56u as=0.56p ps=2.56u w=2u l=1u
X442 a_23540_8187# vbn.t982 a_23250_7607# VSS.t27 nfet_03v3 ad=0.56p pd=2.56u as=0.56p ps=2.56u w=2u l=1u
X443 a_23540_4707# vbn.t515 a_23250_4127# VSS.t33 nfet_03v3 ad=0.56p pd=2.56u as=0.56p ps=2.56u w=2u l=1u
X444 a_27926_2967# vbn.t260 a_28216_3547# VSS.t35 nfet_03v3 ad=0.56p pd=2.56u as=0.56p ps=2.56u w=2u l=1u
X445 a_28216_7027# vbn.t784 a_27926_6447# VSS.t29 nfet_03v3 ad=0.9p pd=4.9u as=0.56p ps=2.56u w=2u l=1u
X446 a_28216_1227# vbn.t727 a_27926_1807# VSS.t38 nfet_03v3 ad=0.56p pd=2.56u as=0.9p ps=4.9u w=2u l=1u
X447 a_23540_1227# vbn.t52 a_23250_1807# VSS.t38 nfet_03v3 ad=0.56p pd=2.56u as=0.56p ps=2.56u w=2u l=1u
X448 net3 vbn.t43 a_23540_1227# VSS.t39 nfet_03v3 ad=0.56p pd=2.56u as=0.56p ps=2.56u w=2u l=1u
X449 a_23540_7027# vbn.t958 a_23250_6447# VSS.t22 nfet_03v3 ad=0.56p pd=2.56u as=0.9p ps=4.9u w=2u l=1u
X450 a_23540_7027# vbn.t643 a_23250_7607# VSS.t28 nfet_03v3 ad=0.56p pd=2.56u as=0.56p ps=2.56u w=2u l=1u
X451 a_23540_3547# vbn.t467 a_23250_4127# VSS.t34 nfet_03v3 ad=0.56p pd=2.56u as=0.56p ps=2.56u w=2u l=1u
X452 a_28216_5867# vbn.t781 a_27926_6447# VSS.t30 nfet_03v3 ad=0.56p pd=2.56u as=0.56p ps=2.56u w=2u l=1u
X453 a_23250_5287# vbn.t143 a_23540_4707# VSS.t32 nfet_03v3 ad=0.56p pd=2.56u as=0.56p ps=2.56u w=2u l=1u
X454 a_23250_1807# vbn.t827 a_23540_1227# VSS.t38 nfet_03v3 ad=0.56p pd=2.56u as=0.56p ps=2.56u w=2u l=1u
X455 a_23540_4707# vbn.t519 a_23250_5287# VSS.t32 nfet_03v3 ad=0.56p pd=2.56u as=0.56p ps=2.56u w=2u l=1u
X456 a_23540_8187# vbn.t212 a_23250_7607# VSS.t27 nfet_03v3 ad=0.56p pd=2.56u as=0.56p ps=2.56u w=2u l=1u
X457 a_27926_1807# vbn.t250 a_28216_2387# VSS.t37 nfet_03v3 ad=0.56p pd=2.56u as=0.56p ps=2.56u w=2u l=1u
X458 a_23540_4707# vbn.t896 a_23250_4127# VSS.t33 nfet_03v3 ad=0.56p pd=2.56u as=0.56p ps=2.56u w=2u l=1u
X459 a_28216_3547# vbn.t268 a_27926_4127# VSS.t34 nfet_03v3 ad=0.56p pd=2.56u as=0.56p ps=2.56u w=2u l=1u
X460 a_23540_8187# vbn.t711 net1 VSS.t26 nfet_03v3 ad=0.56p pd=2.56u as=0.56p ps=2.56u w=2u l=1u
X461 a_23250_5287# vbn.t572 a_23540_5867# VSS.t31 nfet_03v3 ad=0.56p pd=2.56u as=0.56p ps=2.56u w=2u l=1u
X462 a_23250_4127# vbn.t117 a_23540_3547# VSS.t34 nfet_03v3 ad=0.56p pd=2.56u as=0.56p ps=2.56u w=2u l=1u
X463 a_27926_6447# vbn.t302 a_28216_7027# VSS.t29 nfet_03v3 ad=0.56p pd=2.56u as=0.56p ps=2.56u w=2u l=1u
X464 a_28216_5867# vbn.t776 a_27926_5287# VSS.t31 nfet_03v3 ad=0.56p pd=2.56u as=0.9p ps=4.9u w=2u l=1u
X465 a_23250_2967# vbn.t81 a_23540_2387# VSS.t36 nfet_03v3 ad=0.56p pd=2.56u as=0.56p ps=2.56u w=2u l=1u
X466 a_23250_5287# vbn.t141 a_23540_4707# VSS.t32 nfet_03v3 ad=0.56p pd=2.56u as=0.56p ps=2.56u w=2u l=1u
X467 a_23540_5867# vbn.t150 a_23250_5287# VSS.t31 nfet_03v3 ad=0.56p pd=2.56u as=0.56p ps=2.56u w=2u l=1u
X468 a_23250_1807# vbn.t833 a_23540_2387# VSS.t37 nfet_03v3 ad=0.9p pd=4.9u as=0.56p ps=2.56u w=2u l=1u
X469 a_23250_1807# vbn.t55 a_23540_1227# VSS.t38 nfet_03v3 ad=0.56p pd=2.56u as=0.56p ps=2.56u w=2u l=1u
X470 a_23540_8187# vbn.t663 a_23250_7607# VSS.t27 nfet_03v3 ad=0.56p pd=2.56u as=0.56p ps=2.56u w=2u l=1u
X471 a_23250_4127# vbn.t901 a_23540_4707# VSS.t23 nfet_03v3 ad=0.56p pd=2.56u as=0.56p ps=2.56u w=2u l=1u
X472 a_23540_8187# vbn.t994 net1 VSS.t26 nfet_03v3 ad=0.56p pd=2.56u as=0.56p ps=2.56u w=2u l=1u
X473 a_23250_5287# vbn.t925 a_23540_5867# VSS.t31 nfet_03v3 ad=0.56p pd=2.56u as=0.56p ps=2.56u w=2u l=1u
X474 a_23250_4127# vbn.t470 a_23540_3547# VSS.t34 nfet_03v3 ad=0.56p pd=2.56u as=0.56p ps=2.56u w=2u l=1u
X475 a_23250_2967# vbn.t446 a_23540_3547# VSS.t35 nfet_03v3 ad=0.56p pd=2.56u as=0.56p ps=2.56u w=2u l=1u
X476 a_23250_1807# vbn.t354 a_23540_1227# VSS.t38 nfet_03v3 ad=0.56p pd=2.56u as=0.56p ps=2.56u w=2u l=1u
X477 a_23250_6447# vbn.t165 a_23540_5867# VSS.t30 nfet_03v3 ad=0.56p pd=2.56u as=0.56p ps=2.56u w=2u l=1u
X478 a_28216_8187# vbn.t317 a_27926_7607# VSS.t27 nfet_03v3 ad=0.56p pd=2.56u as=0.56p ps=2.56u w=2u l=1u
X479 a_23250_2967# vbn.t406 a_23540_2387# VSS.t36 nfet_03v3 ad=0.9p pd=4.9u as=0.56p ps=2.56u w=2u l=1u
X480 VSS.t15 vbnf.t4 VSS.t15 VSS.t14 nfet_03v3 ad=13.7592p pd=49.7u as=0 ps=0 w=49.14u l=10u
X481 a_23250_7607# vbn.t215 a_23540_8187# VSS.t27 nfet_03v3 ad=0.56p pd=2.56u as=0.56p ps=2.56u w=2u l=1u
X482 a_28216_4707# vbn.t273 a_27926_4127# VSS.t33 nfet_03v3 ad=0.9p pd=4.9u as=0.56p ps=2.56u w=2u l=1u
X483 a_23540_1227# vbn.t347 net3 VSS.t39 nfet_03v3 ad=0.56p pd=2.56u as=0.56p ps=2.56u w=2u l=1u
X484 a_23540_1227# vbn.t60 a_23250_1807# VSS.t38 nfet_03v3 ad=0.56p pd=2.56u as=0.56p ps=2.56u w=2u l=1u
X485 a_23250_1807# vbn.t352 a_23540_1227# VSS.t38 nfet_03v3 ad=0.56p pd=2.56u as=0.56p ps=2.56u w=2u l=1u
X486 a_23540_2387# vbn.t84 a_23250_2967# VSS.t36 nfet_03v3 ad=0.56p pd=2.56u as=0.56p ps=2.56u w=2u l=1u
X487 a_23250_5287# vbn.t153 a_23540_5867# VSS.t31 nfet_03v3 ad=0.56p pd=2.56u as=0.56p ps=2.56u w=2u l=1u
X488 net1 vbn.t999 a_23540_8187# VSS.t23 nfet_03v3 ad=0.56p pd=2.56u as=0.56p ps=2.56u w=2u l=1u
X489 a_23540_3547# vbn.t475 a_23250_4127# VSS.t34 nfet_03v3 ad=0.56p pd=2.56u as=0.56p ps=2.56u w=2u l=1u
X490 a_27926_7607# vbn.t794 a_28216_7027# VSS.t28 nfet_03v3 ad=0.56p pd=2.56u as=0.56p ps=2.56u w=2u l=1u
X491 a_23250_6447# vbn.t614 a_23540_7027# VSS.t29 nfet_03v3 ad=0.56p pd=2.56u as=0.56p ps=2.56u w=2u l=1u
X492 a_23250_5287# vbn.t550 a_23540_5867# VSS.t31 nfet_03v3 ad=0.56p pd=2.56u as=0.56p ps=2.56u w=2u l=1u
X493 a_23250_7607# vbn.t666 a_23540_8187# VSS.t27 nfet_03v3 ad=0.56p pd=2.56u as=0.56p ps=2.56u w=2u l=1u
X494 a_23250_6447# vbn.t574 a_23540_5867# VSS.t30 nfet_03v3 ad=0.9p pd=4.9u as=0.56p ps=2.56u w=2u l=1u
X495 a_23540_1227# vbn.t812 net3 VSS.t39 nfet_03v3 ad=0.56p pd=2.56u as=0.56p ps=2.56u w=2u l=1u
X496 a_28216_7027# vbn.t312 a_27926_7607# VSS.t28 nfet_03v3 ad=0.56p pd=2.56u as=0.56p ps=2.56u w=2u l=1u
X497 a_23540_2387# vbn.t427 a_23250_2967# VSS.t36 nfet_03v3 ad=0.56p pd=2.56u as=0.56p ps=2.56u w=2u l=1u
X498 a_23540_1227# vbn.t357 a_23250_1807# VSS.t38 nfet_03v3 ad=0.56p pd=2.56u as=0.56p ps=2.56u w=2u l=1u
X499 a_23250_1807# vbn.t404 a_23540_2387# VSS.t37 nfet_03v3 ad=0.56p pd=2.56u as=0.56p ps=2.56u w=2u l=1u
X500 a_23540_4707# vbn.t543 a_23250_5287# VSS.t32 nfet_03v3 ad=0.56p pd=2.56u as=0.56p ps=2.56u w=2u l=1u
X501 a_23540_5867# vbn.t158 a_23250_5287# VSS.t31 nfet_03v3 ad=0.56p pd=2.56u as=0.56p ps=2.56u w=2u l=1u
X502 a_23540_5867# vbn.t168 a_23250_6447# VSS.t30 nfet_03v3 ad=0.56p pd=2.56u as=0.56p ps=2.56u w=2u l=1u
X503 a_28216_8187# vbn.t32 vbn.t33 VSS.t26 nfet_03v3 ad=0.9p pd=4.9u as=0.56p ps=2.56u w=2u l=1u
X504 a_28216_2387# vbn.t734 a_27926_1807# VSS.t37 nfet_03v3 ad=0.56p pd=2.56u as=0.9p ps=4.9u w=2u l=1u
X505 a_23250_5287# vbn.t548 a_23540_5867# VSS.t31 nfet_03v3 ad=0.56p pd=2.56u as=0.56p ps=2.56u w=2u l=1u
X506 a_23540_2387# vbn.t66 a_23250_1807# VSS.t37 nfet_03v3 ad=0.56p pd=2.56u as=0.56p ps=2.56u w=2u l=1u
X507 a_23540_2387# vbn.t425 a_23250_2967# VSS.t36 nfet_03v3 ad=0.56p pd=2.56u as=0.56p ps=2.56u w=2u l=1u
X508 a_23540_8187# vbn.t671 a_23250_7607# VSS.t27 nfet_03v3 ad=0.56p pd=2.56u as=0.56p ps=2.56u w=2u l=1u
X509 net3 vbn.t817 a_23540_1227# VSS.t23 nfet_03v3 ad=0.56p pd=2.56u as=0.56p ps=2.56u w=2u l=1u
X510 VDD.t5 net1 vbn.t2 VDD.t4 pfet_03v3 ad=3.92p pd=14.56u as=3.92p ps=14.56u w=14u l=14u
X511 a_23540_2387# vbn.t850 a_23250_2967# VSS.t36 nfet_03v3 ad=0.56p pd=2.56u as=0.56p ps=2.56u w=2u l=1u
X512 a_23250_1807# vbn.t841 a_23540_2387# VSS.t37 nfet_03v3 ad=0.56p pd=2.56u as=0.56p ps=2.56u w=2u l=1u
X513 a_23540_5867# vbn.t595 a_23250_6447# VSS.t30 nfet_03v3 ad=0.56p pd=2.56u as=0.56p ps=2.56u w=2u l=1u
X514 a_23540_4707# vbn.t910 a_23250_5287# VSS.t32 nfet_03v3 ad=0.56p pd=2.56u as=0.56p ps=2.56u w=2u l=1u
X515 a_28216_3547# vbn.t744 a_27926_2967# VSS.t35 nfet_03v3 ad=0.56p pd=2.56u as=0.56p ps=2.56u w=2u l=1u
X516 a_23540_5867# vbn.t553 a_23250_5287# VSS.t31 nfet_03v3 ad=0.56p pd=2.56u as=0.56p ps=2.56u w=2u l=1u
X517 a_23540_4707# vbn.t501 a_23250_4127# VSS.t33 nfet_03v3 ad=0.56p pd=2.56u as=0.56p ps=2.56u w=2u l=1u
X518 a_23250_2967# vbn.t430 a_23540_2387# VSS.t36 nfet_03v3 ad=0.56p pd=2.56u as=0.56p ps=2.56u w=2u l=1u
X519 a_28216_1227# vbn.t231 VSS.t53 VSS.t39 nfet_03v3 ad=0.9p pd=4.9u as=0.56p ps=2.56u w=2u l=1u
X520 a_23540_5867# vbn.t593 a_23250_6447# VSS.t30 nfet_03v3 ad=0.56p pd=2.56u as=0.56p ps=2.56u w=2u l=1u
X521 a_23250_1807# vbn.t69 a_23540_2387# VSS.t37 nfet_03v3 ad=0.56p pd=2.56u as=0.56p ps=2.56u w=2u l=1u
X522 a_23250_5287# vbn.t915 a_23540_4707# VSS.t23 nfet_03v3 ad=0.56p pd=2.56u as=0.56p ps=2.56u w=2u l=1u
X523 a_23540_5867# vbn.t934 a_23250_6447# VSS.t30 nfet_03v3 ad=0.56p pd=2.56u as=0.56p ps=2.56u w=2u l=1u
X524 a_27926_4127# vbn.t752 a_28216_3547# VSS.t34 nfet_03v3 ad=0.56p pd=2.56u as=0.56p ps=2.56u w=2u l=1u
X525 a_28216_7027# vbn.t786 a_27926_6447# VSS.t29 nfet_03v3 ad=0.56p pd=2.56u as=0.56p ps=2.56u w=2u l=1u
X526 a_23250_1807# vbn.t382 a_23540_2387# VSS.t37 nfet_03v3 ad=0.56p pd=2.56u as=0.56p ps=2.56u w=2u l=1u
X527 a_23250_1807# vbn.t829 a_23540_1227# VSS.t25 nfet_03v3 ad=0.56p pd=2.56u as=0.56p ps=2.56u w=2u l=1u
X528 a_23250_2967# vbn.t853 a_23540_2387# VSS.t36 nfet_03v3 ad=0.56p pd=2.56u as=0.56p ps=2.56u w=2u l=1u
X529 a_23250_6447# vbn.t598 a_23540_5867# VSS.t30 nfet_03v3 ad=0.56p pd=2.56u as=0.56p ps=2.56u w=2u l=1u
X530 a_23250_4127# vbn.t506 a_23540_4707# VSS.t33 nfet_03v3 ad=0.56p pd=2.56u as=0.56p ps=2.56u w=2u l=1u
X531 a_28216_3547# vbn.t270 a_27926_4127# VSS.t34 nfet_03v3 ad=0.56p pd=2.56u as=0.56p ps=2.56u w=2u l=1u
X532 a_27926_2967# vbn.t747 a_28216_3547# VSS.t35 nfet_03v3 ad=0.56p pd=2.56u as=0.56p ps=2.56u w=2u l=1u
X533 a_23540_7027# vbn.t645 a_23250_7607# VSS.t28 nfet_03v3 ad=0.56p pd=2.56u as=0.56p ps=2.56u w=2u l=1u
X534 a_28216_4707# vbn.t280 a_27926_5287# VSS.t32 nfet_03v3 ad=0.9p pd=4.9u as=0.56p ps=2.56u w=2u l=1u
X535 net1 net1 VDD.t9 VDD.t8 pfet_03v3 ad=3.92p pd=14.56u as=3.92p ps=14.56u w=14u l=14u
X536 a_23540_8187# vbn.t697 net1 VSS.t26 nfet_03v3 ad=0.56p pd=2.56u as=0.56p ps=2.56u w=2u l=1u
X537 a_23250_2967# vbn.t93 a_23540_3547# VSS.t35 nfet_03v3 ad=0.56p pd=2.56u as=0.56p ps=2.56u w=2u l=1u
X538 a_23540_2387# vbn.t74 a_23250_1807# VSS.t37 nfet_03v3 ad=0.56p pd=2.56u as=0.56p ps=2.56u w=2u l=1u
X539 a_23250_1807# vbn.t380 a_23540_2387# VSS.t37 nfet_03v3 ad=0.56p pd=2.56u as=0.56p ps=2.56u w=2u l=1u
X540 a_23540_2387# vbn.t433 a_23250_2967# VSS.t36 nfet_03v3 ad=0.56p pd=2.56u as=0.9p ps=4.9u w=2u l=1u
X541 a_27926_7607# vbn.t801 a_28216_8187# VSS.t27 nfet_03v3 ad=0.56p pd=2.56u as=0.56p ps=2.56u w=2u l=1u
X542 VSS.t17 vbnf.t3 VSS.t17 VSS.t16 nfet_03v3 ad=13.7592p pd=49.7u as=0 ps=0 w=49.14u l=10u
X543 a_23540_2387# vbn.t858 a_23250_2967# VSS.t24 nfet_03v3 ad=0.56p pd=2.56u as=0.56p ps=2.56u w=2u l=1u
X544 a_23250_7607# vbn.t650 a_23540_7027# VSS.t28 nfet_03v3 ad=0.56p pd=2.56u as=0.56p ps=2.56u w=2u l=1u
X545 a_23250_6447# vbn.t937 a_23540_5867# VSS.t30 nfet_03v3 ad=0.56p pd=2.56u as=0.56p ps=2.56u w=2u l=1u
X546 a_23250_5287# vbn.t927 a_23540_5867# VSS.t25 nfet_03v3 ad=0.56p pd=2.56u as=0.56p ps=2.56u w=2u l=1u
X547 a_27926_4127# vbn.t757 a_28216_4707# VSS.t33 nfet_03v3 ad=0.56p pd=2.56u as=0.56p ps=2.56u w=2u l=1u
X548 a_28216_8187# vbn.t319 a_27926_7607# VSS.t27 nfet_03v3 ad=0.56p pd=2.56u as=0.56p ps=2.56u w=2u l=1u
X549 a_27926_6447# vbn.t789 a_28216_7027# VSS.t29 nfet_03v3 ad=0.56p pd=2.56u as=0.56p ps=2.56u w=2u l=1u
X550 net1 vbn.t702 a_23540_8187# VSS.t26 nfet_03v3 ad=0.56p pd=2.56u as=0.56p ps=2.56u w=2u l=1u
X551 a_23250_6447# vbn.t177 a_23540_7027# VSS.t29 nfet_03v3 ad=0.56p pd=2.56u as=0.56p ps=2.56u w=2u l=1u
X552 a_23540_2387# vbn.t385 a_23250_1807# VSS.t37 nfet_03v3 ad=0.56p pd=2.56u as=0.56p ps=2.56u w=2u l=1u
X553 a_27926_1807# vbn.t241 a_28216_1227# VSS.t38 nfet_03v3 ad=0.56p pd=2.56u as=0.56p ps=2.56u w=2u l=1u
X554 a_23250_7607# vbn.t648 a_23540_7027# VSS.t28 nfet_03v3 ad=0.56p pd=2.56u as=0.56p ps=2.56u w=2u l=1u
X555 a_23540_5867# vbn.t601 a_23250_6447# VSS.t30 nfet_03v3 ad=0.56p pd=2.56u as=0.9p ps=4.9u w=2u l=1u
X556 a_23540_1227# vbn.t333 net3 VSS.t39 nfet_03v3 ad=0.56p pd=2.56u as=0.56p ps=2.56u w=2u l=1u
X557 a_23250_1807# vbn.t356 a_23540_1227# VSS.t38 nfet_03v3 ad=0.56p pd=2.56u as=0.56p ps=2.56u w=2u l=1u
X558 a_23250_7607# vbn.t961 a_23540_7027# VSS.t28 nfet_03v3 ad=0.56p pd=2.56u as=0.56p ps=2.56u w=2u l=1u
X559 a_23540_5867# vbn.t942 a_23250_6447# VSS.t24 nfet_03v3 ad=0.56p pd=2.56u as=0.56p ps=2.56u w=2u l=1u
X560 a_23540_3547# vbn.t437 a_23250_2967# VSS.t35 nfet_03v3 ad=0.56p pd=2.56u as=0.56p ps=2.56u w=2u l=1u
X561 a_23540_1227# vbn.t62 a_23250_1807# VSS.t38 nfet_03v3 ad=0.56p pd=2.56u as=0.9p ps=4.9u w=2u l=1u
X562 vbn.t17 vbn.t16 a_28216_8187# VSS.t26 nfet_03v3 ad=0.56p pd=2.56u as=0.56p ps=2.56u w=2u l=1u
X563 a_23540_7027# vbn.t653 a_23250_7607# VSS.t28 nfet_03v3 ad=0.56p pd=2.56u as=0.56p ps=2.56u w=2u l=1u
X564 net3 vbn.t338 a_23540_1227# VSS.t39 nfet_03v3 ad=0.56p pd=2.56u as=0.56p ps=2.56u w=2u l=1u
X565 a_23540_3547# vbn.t477 a_23250_4127# VSS.t34 nfet_03v3 ad=0.56p pd=2.56u as=0.56p ps=2.56u w=2u l=1u
X566 a_27926_5287# vbn.t290 a_28216_5867# VSS.t31 nfet_03v3 ad=0.56p pd=2.56u as=0.56p ps=2.56u w=2u l=1u
X567 a_23250_5287# vbn.t552 a_23540_5867# VSS.t31 nfet_03v3 ad=0.56p pd=2.56u as=0.56p ps=2.56u w=2u l=1u
X568 a_23540_4707# vbn.t529 a_23250_5287# VSS.t32 nfet_03v3 ad=0.56p pd=2.56u as=0.56p ps=2.56u w=2u l=1u
X569 a_23540_4707# vbn.t120 a_23250_4127# VSS.t33 nfet_03v3 ad=0.56p pd=2.56u as=0.56p ps=2.56u w=2u l=1u
X570 a_28216_3547# vbn.t265 a_27926_2967# VSS.t35 nfet_03v3 ad=0.56p pd=2.56u as=0.9p ps=4.9u w=2u l=1u
X571 a_23540_7027# vbn.t605 a_23250_6447# VSS.t29 nfet_03v3 ad=0.56p pd=2.56u as=0.56p ps=2.56u w=2u l=1u
X572 a_23540_1227# vbn.t359 a_23250_1807# VSS.t38 nfet_03v3 ad=0.56p pd=2.56u as=0.56p ps=2.56u w=2u l=1u
X573 a_23540_5867# vbn.t160 a_23250_5287# VSS.t31 nfet_03v3 ad=0.56p pd=2.56u as=0.9p ps=4.9u w=2u l=1u
X574 a_23250_7607# vbn.t189 a_23540_7027# VSS.t28 nfet_03v3 ad=0.9p pd=4.9u as=0.56p ps=2.56u w=2u l=1u
X575 a_23540_7027# vbn.t964 a_23250_7607# VSS.t28 nfet_03v3 ad=0.56p pd=2.56u as=0.56p ps=2.56u w=2u l=1u
X576 a_23540_3547# vbn.t862 a_23250_2967# VSS.t35 nfet_03v3 ad=0.56p pd=2.56u as=0.56p ps=2.56u w=2u l=1u
X577 a_23250_1807# vbn.t843 a_23540_2387# VSS.t25 nfet_03v3 ad=0.56p pd=2.56u as=0.56p ps=2.56u w=2u l=1u
X578 a_23250_4127# vbn.t482 a_23540_3547# VSS.t34 nfet_03v3 ad=0.56p pd=2.56u as=0.56p ps=2.56u w=2u l=1u
X579 VSS.t45 vbn.t715 a_28216_1227# VSS.t39 nfet_03v3 ad=0.56p pd=2.56u as=0.56p ps=2.56u w=2u l=1u
X580 a_23540_8187# vbn.t673 a_23250_7607# VSS.t27 nfet_03v3 ad=0.56p pd=2.56u as=0.56p ps=2.56u w=2u l=1u
X581 a_23250_5287# vbn.t534 a_23540_4707# VSS.t32 nfet_03v3 ad=0.56p pd=2.56u as=0.56p ps=2.56u w=2u l=1u
X582 a_23540_8187# vbn.t218 net1 VSS.t26 nfet_03v3 ad=0.56p pd=2.56u as=0.56p ps=2.56u w=2u l=1u
X583 a_28216_7027# vbn.t307 a_27926_6447# VSS.t29 nfet_03v3 ad=0.56p pd=2.56u as=0.9p ps=4.9u w=2u l=1u
X584 a_23250_1807# vbn.t364 a_23540_1227# VSS.t38 nfet_03v3 ad=0.56p pd=2.56u as=0.56p ps=2.56u w=2u l=1u
X585 a_23250_4127# vbn.t480 a_23540_3547# VSS.t34 nfet_03v3 ad=0.56p pd=2.56u as=0.56p ps=2.56u w=2u l=1u
X586 a_23250_2967# vbn.t456 a_23540_3547# VSS.t35 nfet_03v3 ad=0.56p pd=2.56u as=0.56p ps=2.56u w=2u l=1u
X587 a_23540_5867# vbn.t555 a_23250_5287# VSS.t31 nfet_03v3 ad=0.56p pd=2.56u as=0.56p ps=2.56u w=2u l=1u
X588 a_23250_2967# vbn.t416 a_23540_2387# VSS.t36 nfet_03v3 ad=0.56p pd=2.56u as=0.56p ps=2.56u w=2u l=1u
X589 a_23540_7027# vbn.t194 a_23250_7607# VSS.t28 nfet_03v3 ad=0.56p pd=2.56u as=0.56p ps=2.56u w=2u l=1u
X590 a_23540_7027# vbn.t946 a_23250_6447# VSS.t29 nfet_03v3 ad=0.56p pd=2.56u as=0.56p ps=2.56u w=2u l=1u
X591 a_23250_4127# vbn.t877 a_23540_3547# VSS.t34 nfet_03v3 ad=0.56p pd=2.56u as=0.56p ps=2.56u w=2u l=1u
X592 a_23250_7607# vbn.t678 a_23540_8187# VSS.t27 nfet_03v3 ad=0.56p pd=2.56u as=0.56p ps=2.56u w=2u l=1u
X593 VSS.t9 vbnf.t7 VSS.t9 VSS.t8 nfet_03v3 ad=13.7592p pd=49.7u as=0 ps=0 w=49.14u l=10u
X594 a_27926_5287# vbn.t764 a_28216_4707# VSS.t32 nfet_03v3 ad=0.56p pd=2.56u as=0.56p ps=2.56u w=2u l=1u
X595 a_23250_2967# vbn.t865 a_23540_3547# VSS.t35 nfet_03v3 ad=0.56p pd=2.56u as=0.56p ps=2.56u w=2u l=1u
X596 a_23250_6447# vbn.t624 a_23540_7027# VSS.t29 nfet_03v3 ad=0.56p pd=2.56u as=0.56p ps=2.56u w=2u l=1u
X597 a_23540_3547# vbn.t485 a_23250_4127# VSS.t34 nfet_03v3 ad=0.56p pd=2.56u as=0.56p ps=2.56u w=2u l=1u
X598 a_27926_1807# vbn.t248 a_28216_2387# VSS.t37 nfet_03v3 ad=0.56p pd=2.56u as=0.56p ps=2.56u w=2u l=1u
X599 a_23250_7607# vbn.t676 a_23540_8187# VSS.t27 nfet_03v3 ad=0.56p pd=2.56u as=0.56p ps=2.56u w=2u l=1u
X600 a_23540_7027# vbn.t631 a_23250_7607# VSS.t28 nfet_03v3 ad=0.56p pd=2.56u as=0.56p ps=2.56u w=2u l=1u
X601 a_23250_6447# vbn.t584 a_23540_5867# VSS.t30 nfet_03v3 ad=0.56p pd=2.56u as=0.56p ps=2.56u w=2u l=1u
X602 a_23250_5287# vbn.t560 a_23540_5867# VSS.t31 nfet_03v3 ad=0.56p pd=2.56u as=0.56p ps=2.56u w=2u l=1u
X603 a_23540_1227# vbn.t36 net3 VSS.t39 nfet_03v3 ad=0.56p pd=2.56u as=0.56p ps=2.56u w=2u l=1u
X604 a_23250_7607# vbn.t199 a_23540_7027# VSS.t28 nfet_03v3 ad=0.56p pd=2.56u as=0.56p ps=2.56u w=2u l=1u
X605 a_27926_4127# vbn.t278 a_28216_4707# VSS.t33 nfet_03v3 ad=0.56p pd=2.56u as=0.56p ps=2.56u w=2u l=1u
X606 a_23250_1807# vbn.t384 a_23540_2387# VSS.t37 nfet_03v3 ad=0.56p pd=2.56u as=0.56p ps=2.56u w=2u l=1u
X607 a_23540_1227# vbn.t367 a_23250_1807# VSS.t38 nfet_03v3 ad=0.56p pd=2.56u as=0.56p ps=2.56u w=2u l=1u
X608 a_23250_7607# vbn.t975 a_23540_8187# VSS.t27 nfet_03v3 ad=0.56p pd=2.56u as=0.56p ps=2.56u w=2u l=1u
X609 a_23540_2387# vbn.t76 a_23250_1807# VSS.t37 nfet_03v3 ad=0.56p pd=2.56u as=0.9p ps=4.9u w=2u l=1u
X610 a_23250_7607# vbn.t197 a_23540_7027# VSS.t28 nfet_03v3 ad=0.56p pd=2.56u as=0.56p ps=2.56u w=2u l=1u
X611 a_23250_4127# vbn.t105 a_23540_3547# VSS.t34 nfet_03v3 ad=0.9p pd=4.9u as=0.56p ps=2.56u w=2u l=1u
X612 a_23250_6447# vbn.t949 a_23540_7027# VSS.t29 nfet_03v3 ad=0.56p pd=2.56u as=0.56p ps=2.56u w=2u l=1u
X613 a_23250_4127# vbn.t889 a_23540_4707# VSS.t33 nfet_03v3 ad=0.9p pd=4.9u as=0.56p ps=2.56u w=2u l=1u
X614 a_23540_3547# vbn.t880 a_23250_4127# VSS.t34 nfet_03v3 ad=0.56p pd=2.56u as=0.56p ps=2.56u w=2u l=1u
X615 a_23540_3547# vbn.t870 a_23250_2967# VSS.t35 nfet_03v3 ad=0.56p pd=2.56u as=0.56p ps=2.56u w=2u l=1u
X616 a_23540_8187# vbn.t681 a_23250_7607# VSS.t27 nfet_03v3 ad=0.56p pd=2.56u as=0.56p ps=2.56u w=2u l=1u
X617 a_28216_2387# vbn.t735 a_27926_2967# VSS.t36 nfet_03v3 ad=0.9p pd=4.9u as=0.56p ps=2.56u w=2u l=1u
X618 a_23540_4707# vbn.t134 a_23250_5287# VSS.t32 nfet_03v3 ad=0.56p pd=2.56u as=0.56p ps=2.56u w=2u l=1u
X619 vbn.t23 vbn.t22 a_28216_8187# VSS.t26 nfet_03v3 ad=0.56p pd=2.56u as=0.56p ps=2.56u w=2u l=1u
X620 a_23540_2387# vbn.t860 a_23250_2967# VSS.t22 nfet_03v3 ad=0.56p pd=2.56u as=0.9p ps=4.9u w=2u l=1u
X621 a_28216_1227# vbn.t725 a_27926_1807# VSS.t38 nfet_03v3 ad=0.56p pd=2.56u as=0.56p ps=2.56u w=2u l=1u
X622 a_23540_5867# vbn.t563 a_23250_5287# VSS.t31 nfet_03v3 ad=0.56p pd=2.56u as=0.56p ps=2.56u w=2u l=1u
X623 a_23540_3547# vbn.t110 a_23250_4127# VSS.t34 nfet_03v3 ad=0.56p pd=2.56u as=0.56p ps=2.56u w=2u l=1u
X624 a_23540_3547# vbn.t100 a_23250_2967# VSS.t35 nfet_03v3 ad=0.56p pd=2.56u as=0.56p ps=2.56u w=2u l=1u
X625 a_23540_2387# vbn.t387 a_23250_1807# VSS.t37 nfet_03v3 ad=0.56p pd=2.56u as=0.56p ps=2.56u w=2u l=1u
X626 a_23540_7027# vbn.t954 a_23250_6447# VSS.t29 nfet_03v3 ad=0.56p pd=2.56u as=0.56p ps=2.56u w=2u l=1u
X627 a_23250_7607# vbn.t203 a_23540_8187# VSS.t27 nfet_03v3 ad=0.9p pd=4.9u as=0.56p ps=2.56u w=2u l=1u
X628 net1 vbn.t987 a_23540_8187# VSS.t26 nfet_03v3 ad=0.9p pd=4.9u as=0.56p ps=2.56u w=2u l=1u
X629 a_23540_8187# vbn.t978 a_23250_7607# VSS.t27 nfet_03v3 ad=0.56p pd=2.56u as=0.56p ps=2.56u w=2u l=1u
X630 a_27926_2967# vbn.t253 a_28216_2387# VSS.t36 nfet_03v3 ad=0.56p pd=2.56u as=0.56p ps=2.56u w=2u l=1u
X631 a_28216_5867# vbn.t777 a_27926_6447# VSS.t30 nfet_03v3 ad=0.9p pd=4.9u as=0.56p ps=2.56u w=2u l=1u
X632 a_23540_5867# vbn.t944 a_23250_6447# VSS.t22 nfet_03v3 ad=0.56p pd=2.56u as=0.9p ps=4.9u w=2u l=1u
X633 a_23540_3547# vbn.t439 a_23250_2967# VSS.t35 nfet_03v3 ad=0.56p pd=2.56u as=0.56p ps=2.56u w=2u l=1u
X634 a_23250_4127# vbn.t115 a_23540_3547# VSS.t34 nfet_03v3 ad=0.56p pd=2.56u as=0.56p ps=2.56u w=2u l=1u
X635 a_23250_1807# vbn.t392 a_23540_2387# VSS.t37 nfet_03v3 ad=0.56p pd=2.56u as=0.56p ps=2.56u w=2u l=1u
X636 a_28216_5867# vbn.t774 a_27926_5287# VSS.t31 nfet_03v3 ad=0.56p pd=2.56u as=0.56p ps=2.56u w=2u l=1u
X637 a_23540_3547# vbn.t463 a_23250_4127# VSS.t34 nfet_03v3 ad=0.56p pd=2.56u as=0.56p ps=2.56u w=2u l=1u
X638 a_23540_7027# vbn.t184 a_23250_6447# VSS.t29 nfet_03v3 ad=0.56p pd=2.56u as=0.56p ps=2.56u w=2u l=1u
X639 VSS.t48 vbn.t236 a_28216_1227# VSS.t39 nfet_03v3 ad=0.56p pd=2.56u as=0.56p ps=2.56u w=2u l=1u
X640 a_23540_8187# vbn.t208 a_23250_7607# VSS.t27 nfet_03v3 ad=0.56p pd=2.56u as=0.56p ps=2.56u w=2u l=1u
X641 a_23540_7027# vbn.t655 a_23250_7607# VSS.t28 nfet_03v3 ad=0.56p pd=2.56u as=0.56p ps=2.56u w=2u l=1u
X642 a_23250_4127# vbn.t516 a_23540_4707# VSS.t33 nfet_03v3 ad=0.56p pd=2.56u as=0.56p ps=2.56u w=2u l=1u
X643 a_28216_3547# vbn.t261 a_27926_2967# VSS.t35 nfet_03v3 ad=0.56p pd=2.56u as=0.56p ps=2.56u w=2u l=1u
X644 a_28216_4707# vbn.t762 a_27926_4127# VSS.t33 nfet_03v3 ad=0.56p pd=2.56u as=0.9p ps=4.9u w=2u l=1u
X645 a_23540_4707# vbn.t122 a_23250_4127# VSS.t33 nfet_03v3 ad=0.56p pd=2.56u as=0.56p ps=2.56u w=2u l=1u
X646 a_23250_4127# vbn.t113 a_23540_3547# VSS.t34 nfet_03v3 ad=0.56p pd=2.56u as=0.56p ps=2.56u w=2u l=1u
X647 a_23250_2967# vbn.t103 a_23540_3547# VSS.t35 nfet_03v3 ad=0.56p pd=2.56u as=0.56p ps=2.56u w=2u l=1u
X648 a_23250_1807# vbn.t53 a_23540_1227# VSS.t38 nfet_03v3 ad=0.56p pd=2.56u as=0.56p ps=2.56u w=2u l=1u
X649 a_27926_6447# vbn.t295 a_28216_5867# VSS.t30 nfet_03v3 ad=0.56p pd=2.56u as=0.56p ps=2.56u w=2u l=1u
X650 net3 vbn.t805 a_23540_1227# VSS.t39 nfet_03v3 ad=0.9p pd=4.9u as=0.56p ps=2.56u w=2u l=1u
X651 a_23540_7027# vbn.t607 a_23250_6447# VSS.t29 nfet_03v3 ad=0.56p pd=2.56u as=0.56p ps=2.56u w=2u l=1u
X652 a_23540_8187# vbn.t659 a_23250_7607# VSS.t27 nfet_03v3 ad=0.56p pd=2.56u as=0.56p ps=2.56u w=2u l=1u
X653 a_23250_7607# vbn.t213 a_23540_8187# VSS.t27 nfet_03v3 ad=0.56p pd=2.56u as=0.56p ps=2.56u w=2u l=1u
X654 a_23540_7027# vbn.t966 a_23250_7607# VSS.t28 nfet_03v3 ad=0.56p pd=2.56u as=0.56p ps=2.56u w=2u l=1u
X655 a_23250_4127# vbn.t897 a_23540_4707# VSS.t33 nfet_03v3 ad=0.56p pd=2.56u as=0.56p ps=2.56u w=2u l=1u
X656 a_27926_5287# vbn.t285 a_28216_4707# VSS.t32 nfet_03v3 ad=0.56p pd=2.56u as=0.56p ps=2.56u w=2u l=1u
X657 a_28216_7027# vbn.t303 a_27926_6447# VSS.t29 nfet_03v3 ad=0.56p pd=2.56u as=0.56p ps=2.56u w=2u l=1u
X658 net1 vbn.t712 a_23540_8187# VSS.t26 nfet_03v3 ad=0.56p pd=2.56u as=0.56p ps=2.56u w=2u l=1u
X659 a_23250_2967# vbn.t442 a_23540_3547# VSS.t35 nfet_03v3 ad=0.56p pd=2.56u as=0.56p ps=2.56u w=2u l=1u
X660 a_23250_2967# vbn.t418 a_23540_2387# VSS.t36 nfet_03v3 ad=0.56p pd=2.56u as=0.56p ps=2.56u w=2u l=1u
X661 a_23250_6447# vbn.t187 a_23540_7027# VSS.t29 nfet_03v3 ad=0.56p pd=2.56u as=0.56p ps=2.56u w=2u l=1u
X662 a_23250_1807# vbn.t350 a_23540_1227# VSS.t38 nfet_03v3 ad=0.9p pd=4.9u as=0.56p ps=2.56u w=2u l=1u
X663 a_23540_2387# vbn.t395 a_23250_1807# VSS.t37 nfet_03v3 ad=0.56p pd=2.56u as=0.56p ps=2.56u w=2u l=1u
X664 a_23250_5287# vbn.t151 a_23540_5867# VSS.t31 nfet_03v3 ad=0.56p pd=2.56u as=0.56p ps=2.56u w=2u l=1u
X665 a_28216_8187# vbn.t6 vbn.t7 VSS.t26 nfet_03v3 ad=0.56p pd=2.56u as=0.9p ps=4.9u w=2u l=1u
X666 a_23250_7607# vbn.t211 a_23540_8187# VSS.t27 nfet_03v3 ad=0.56p pd=2.56u as=0.56p ps=2.56u w=2u l=1u
X667 a_23540_8187# vbn.t220 net1 VSS.t26 nfet_03v3 ad=0.56p pd=2.56u as=0.56p ps=2.56u w=2u l=1u
X668 net1 net1 VDD.t1 VDD.t0 pfet_03v3 ad=3.92p pd=14.56u as=3.92p ps=14.56u w=14u l=14u
X669 a_23250_5287# vbn.t903 a_23540_4707# VSS.t32 nfet_03v3 ad=0.9p pd=4.9u as=0.56p ps=2.56u w=2u l=1u
X670 a_23250_4127# vbn.t125 a_23540_4707# VSS.t33 nfet_03v3 ad=0.56p pd=2.56u as=0.56p ps=2.56u w=2u l=1u
X671 a_23540_1227# vbn.t56 a_23250_1807# VSS.t38 nfet_03v3 ad=0.56p pd=2.56u as=0.56p ps=2.56u w=2u l=1u
X672 a_23250_7607# vbn.t971 a_23540_7027# VSS.t23 nfet_03v3 ad=0.56p pd=2.56u as=0.56p ps=2.56u w=2u l=1u
X673 net1 vbn.t995 a_23540_8187# VSS.t26 nfet_03v3 ad=0.56p pd=2.56u as=0.56p ps=2.56u w=2u l=1u
X674 a_23250_4127# vbn.t494 a_23540_4707# VSS.t33 nfet_03v3 ad=0.56p pd=2.56u as=0.56p ps=2.56u w=2u l=1u
X675 a_23540_3547# vbn.t447 a_23250_2967# VSS.t35 nfet_03v3 ad=0.56p pd=2.56u as=0.56p ps=2.56u w=2u l=1u
X676 a_28216_2387# vbn.t732 a_27926_1807# VSS.t37 nfet_03v3 ad=0.56p pd=2.56u as=0.56p ps=2.56u w=2u l=1u
X677 a_23250_6447# vbn.t610 a_23540_7027# VSS.t29 nfet_03v3 ad=0.56p pd=2.56u as=0.56p ps=2.56u w=2u l=1u
X678 a_23250_6447# vbn.t586 a_23540_5867# VSS.t30 nfet_03v3 ad=0.56p pd=2.56u as=0.56p ps=2.56u w=2u l=1u
X679 a_23250_5287# vbn.t546 a_23540_5867# VSS.t31 nfet_03v3 ad=0.9p pd=4.9u as=0.56p ps=2.56u w=2u l=1u
X680 VSS.t55 vbn.t34 net2 VSS.t54 nfet_03v3 ad=0.9p pd=4.9u as=2.36p ps=6.36u w=2u l=0.28u
X681 a_23540_3547# vbn.t487 a_23250_4127# VSS.t34 nfet_03v3 ad=0.56p pd=2.56u as=0.56p ps=2.56u w=2u l=1u
X682 net3 vbn.t348 a_23540_1227# VSS.t39 nfet_03v3 ad=0.56p pd=2.56u as=0.56p ps=2.56u w=2u l=1u
X683 a_23540_1227# vbn.t371 a_23250_1807# VSS.t38 nfet_03v3 ad=0.56p pd=2.56u as=0.56p ps=2.56u w=2u l=1u
X684 a_28216_1227# vbn.t720 VSS.t40 VSS.t39 nfet_03v3 ad=0.56p pd=2.56u as=0.9p ps=4.9u w=2u l=1u
X685 a_23250_4127# vbn.t492 a_23540_4707# VSS.t33 nfet_03v3 ad=0.56p pd=2.56u as=0.56p ps=2.56u w=2u l=1u
X686 a_23540_4707# vbn.t130 a_23250_4127# VSS.t33 nfet_03v3 ad=0.56p pd=2.56u as=0.56p ps=2.56u w=2u l=1u
X687 a_28216_7027# vbn.t308 a_27926_7607# VSS.t28 nfet_03v3 ad=0.9p pd=4.9u as=0.56p ps=2.56u w=2u l=1u
X688 a_23540_1227# vbn.t38 net3 VSS.t39 nfet_03v3 ad=0.56p pd=2.56u as=0.56p ps=2.56u w=2u l=1u
X689 a_23540_5867# vbn.t154 a_23250_5287# VSS.t31 nfet_03v3 ad=0.56p pd=2.56u as=0.56p ps=2.56u w=2u l=1u
X690 net1 vbn.t223 a_23540_8187# VSS.t26 nfet_03v3 ad=0.56p pd=2.56u as=0.56p ps=2.56u w=2u l=1u
X691 a_23540_7027# vbn.t615 a_23250_6447# VSS.t29 nfet_03v3 ad=0.56p pd=2.56u as=0.56p ps=2.56u w=2u l=1u
X692 a_23540_1227# vbn.t369 a_23250_1807# VSS.t38 nfet_03v3 ad=0.56p pd=2.56u as=0.56p ps=2.56u w=2u l=1u
X693 net1 vbn.t690 a_23540_8187# VSS.t26 nfet_03v3 ad=0.56p pd=2.56u as=0.56p ps=2.56u w=2u l=1u
X694 VDD.t11 net1 net1 VDD.t10 pfet_03v3 ad=3.92p pd=14.56u as=3.92p ps=14.56u w=14u l=14u
X695 a_23540_1227# vbn.t822 a_23250_1807# VSS.t38 nfet_03v3 ad=0.56p pd=2.56u as=0.56p ps=2.56u w=2u l=1u
X696 net3 vbn.t813 a_23540_1227# VSS.t39 nfet_03v3 ad=0.56p pd=2.56u as=0.56p ps=2.56u w=2u l=1u
X697 a_23540_3547# vbn.t882 a_23250_4127# VSS.t34 nfet_03v3 ad=0.56p pd=2.56u as=0.56p ps=2.56u w=2u l=1u
X698 a_23250_5287# vbn.t544 a_23540_4707# VSS.t32 nfet_03v3 ad=0.56p pd=2.56u as=0.56p ps=2.56u w=2u l=1u
X699 a_23540_4707# vbn.t497 a_23250_4127# VSS.t33 nfet_03v3 ad=0.56p pd=2.56u as=0.56p ps=2.56u w=2u l=1u
X700 a_23540_8187# vbn.t683 a_23250_7607# VSS.t27 nfet_03v3 ad=0.56p pd=2.56u as=0.56p ps=2.56u w=2u l=1u
X701 a_23540_5867# vbn.t567 a_23250_5287# VSS.t31 nfet_03v3 ad=0.56p pd=2.56u as=0.56p ps=2.56u w=2u l=1u
X702 a_28216_4707# vbn.t769 a_27926_5287# VSS.t32 nfet_03v3 ad=0.56p pd=2.56u as=0.9p ps=4.9u w=2u l=1u
X703 a_28216_2387# vbn.t737 a_27926_2967# VSS.t36 nfet_03v3 ad=0.56p pd=2.56u as=0.56p ps=2.56u w=2u l=1u
X704 net1 vbn.t688 a_23540_8187# VSS.t26 nfet_03v3 ad=0.56p pd=2.56u as=0.56p ps=2.56u w=2u l=1u
X705 a_23250_1807# vbn.t67 a_23540_2387# VSS.t37 nfet_03v3 ad=0.56p pd=2.56u as=0.56p ps=2.56u w=2u l=1u
X706 a_23540_4707# vbn.t136 a_23250_5287# VSS.t32 nfet_03v3 ad=0.56p pd=2.56u as=0.56p ps=2.56u w=2u l=1u
X707 a_23540_8187# vbn.t228 net1 VSS.t26 nfet_03v3 ad=0.56p pd=2.56u as=0.56p ps=2.56u w=2u l=1u
X708 a_23250_1807# vbn.t374 a_23540_1227# VSS.t38 nfet_03v3 ad=0.56p pd=2.56u as=0.56p ps=2.56u w=2u l=1u
X709 a_23540_5867# vbn.t565 a_23250_5287# VSS.t31 nfet_03v3 ad=0.56p pd=2.56u as=0.56p ps=2.56u w=2u l=1u
X710 net3 vbn.t41 a_23540_1227# VSS.t39 nfet_03v3 ad=0.56p pd=2.56u as=0.56p ps=2.56u w=2u l=1u
X711 a_23250_4127# vbn.t887 a_23540_3547# VSS.t23 nfet_03v3 ad=0.56p pd=2.56u as=0.56p ps=2.56u w=2u l=1u
X712 a_23540_8187# vbn.t980 a_23250_7607# VSS.t27 nfet_03v3 ad=0.56p pd=2.56u as=0.56p ps=2.56u w=2u l=1u
X713 a_23540_5867# vbn.t920 a_23250_5287# VSS.t31 nfet_03v3 ad=0.56p pd=2.56u as=0.56p ps=2.56u w=2u l=1u
X714 a_23250_5287# vbn.t911 a_23540_4707# VSS.t32 nfet_03v3 ad=0.56p pd=2.56u as=0.56p ps=2.56u w=2u l=1u
X715 a_27926_2967# vbn.t745 a_28216_3547# VSS.t35 nfet_03v3 ad=0.56p pd=2.56u as=0.56p ps=2.56u w=2u l=1u
X716 net3 vbn.t326 a_23540_1227# VSS.t39 nfet_03v3 ad=0.56p pd=2.56u as=0.56p ps=2.56u w=2u l=1u
X717 a_28216_5867# vbn.t779 a_27926_6447# VSS.t30 nfet_03v3 ad=0.56p pd=2.56u as=0.56p ps=2.56u w=2u l=1u
X718 a_23540_8187# vbn.t693 net1 VSS.t26 nfet_03v3 ad=0.56p pd=2.56u as=0.56p ps=2.56u w=2u l=1u
X719 a_23250_1807# vbn.t378 a_23540_2387# VSS.t37 nfet_03v3 ad=0.9p pd=4.9u as=0.56p ps=2.56u w=2u l=1u
X720 a_23250_1807# vbn.t825 a_23540_1227# VSS.t38 nfet_03v3 ad=0.56p pd=2.56u as=0.56p ps=2.56u w=2u l=1u
X721 a_23250_5287# vbn.t570 a_23540_5867# VSS.t31 nfet_03v3 ad=0.56p pd=2.56u as=0.56p ps=2.56u w=2u l=1u
X722 a_23540_1227# vbn.t46 net3 VSS.t39 nfet_03v3 ad=0.56p pd=2.56u as=0.56p ps=2.56u w=2u l=1u
X723 a_28216_3547# vbn.t263 a_27926_2967# VSS.t35 nfet_03v3 ad=0.56p pd=2.56u as=0.56p ps=2.56u w=2u l=1u
X724 a_28216_3547# vbn.t266 a_27926_4127# VSS.t34 nfet_03v3 ad=0.9p pd=4.9u as=0.56p ps=2.56u w=2u l=1u
X725 a_27926_2967# vbn.t740 a_28216_2387# VSS.t36 nfet_03v3 ad=0.56p pd=2.56u as=0.56p ps=2.56u w=2u l=1u
X726 a_23540_7027# vbn.t641 a_23250_7607# VSS.t28 nfet_03v3 ad=0.56p pd=2.56u as=0.56p ps=2.56u w=2u l=1u
X727 net3 vbn.t324 a_23540_1227# VSS.t39 nfet_03v3 ad=0.56p pd=2.56u as=0.56p ps=2.56u w=2u l=1u
X728 a_23250_2967# vbn.t79 a_23540_2387# VSS.t36 nfet_03v3 ad=0.56p pd=2.56u as=0.56p ps=2.56u w=2u l=1u
X729 a_23540_2387# vbn.t70 a_23250_1807# VSS.t37 nfet_03v3 ad=0.56p pd=2.56u as=0.56p ps=2.56u w=2u l=1u
X730 a_23250_5287# vbn.t139 a_23540_4707# VSS.t32 nfet_03v3 ad=0.56p pd=2.56u as=0.56p ps=2.56u w=2u l=1u
X731 a_23540_1227# vbn.t377 a_23250_1807# VSS.t38 nfet_03v3 ad=0.56p pd=2.56u as=0.9p ps=4.9u w=2u l=1u
X732 a_23250_7607# vbn.t985 a_23540_8187# VSS.t23 nfet_03v3 ad=0.56p pd=2.56u as=0.56p ps=2.56u w=2u l=1u
X733 a_27926_6447# vbn.t787 a_28216_7027# VSS.t29 nfet_03v3 ad=0.56p pd=2.56u as=0.56p ps=2.56u w=2u l=1u
X734 a_23250_5287# vbn.t522 a_23540_4707# VSS.t32 nfet_03v3 ad=0.56p pd=2.56u as=0.56p ps=2.56u w=2u l=1u
X735 a_23250_4127# vbn.t899 a_23540_4707# VSS.t25 nfet_03v3 ad=0.56p pd=2.56u as=0.56p ps=2.56u w=2u l=1u
X736 a_23540_1227# vbn.t830 a_23250_1807# VSS.t24 nfet_03v3 ad=0.56p pd=2.56u as=0.56p ps=2.56u w=2u l=1u
X737 a_23250_7607# vbn.t646 a_23540_7027# VSS.t28 nfet_03v3 ad=0.56p pd=2.56u as=0.56p ps=2.56u w=2u l=1u
X738 a_28216_7027# vbn.t305 a_27926_6447# VSS.t29 nfet_03v3 ad=0.56p pd=2.56u as=0.56p ps=2.56u w=2u l=1u
X739 a_23250_5287# vbn.t923 a_23540_5867# VSS.t31 nfet_03v3 ad=0.56p pd=2.56u as=0.56p ps=2.56u w=2u l=1u
X740 a_28216_8187# vbn.t315 a_27926_7607# VSS.t27 nfet_03v3 ad=0.9p pd=4.9u as=0.56p ps=2.56u w=2u l=1u
X741 a_23540_1227# vbn.t329 net3 VSS.t39 nfet_03v3 ad=0.56p pd=2.56u as=0.56p ps=2.56u w=2u l=1u
X742 a_23540_2387# vbn.t399 a_23250_1807# VSS.t37 nfet_03v3 ad=0.56p pd=2.56u as=0.56p ps=2.56u w=2u l=1u
X743 a_27926_6447# vbn.t782 a_28216_5867# VSS.t30 nfet_03v3 ad=0.56p pd=2.56u as=0.56p ps=2.56u w=2u l=1u
X744 a_23250_5287# vbn.t520 a_23540_4707# VSS.t32 nfet_03v3 ad=0.56p pd=2.56u as=0.56p ps=2.56u w=2u l=1u
X745 a_23540_4707# vbn.t144 a_23250_5287# VSS.t32 nfet_03v3 ad=0.56p pd=2.56u as=0.56p ps=2.56u w=2u l=1u
X746 a_23250_6447# vbn.t163 a_23540_5867# VSS.t30 nfet_03v3 ad=0.56p pd=2.56u as=0.56p ps=2.56u w=2u l=1u
X747 a_23540_5867# vbn.t573 a_23250_5287# VSS.t31 nfet_03v3 ad=0.56p pd=2.56u as=0.9p ps=4.9u w=2u l=1u
X748 a_23540_2387# vbn.t397 a_23250_1807# VSS.t37 nfet_03v3 ad=0.56p pd=2.56u as=0.56p ps=2.56u w=2u l=1u
X749 a_23540_5867# vbn.t928 a_23250_5287# VSS.t24 nfet_03v3 ad=0.56p pd=2.56u as=0.56p ps=2.56u w=2u l=1u
X750 net1 vbn.t997 a_23540_8187# VSS.t25 nfet_03v3 ad=0.56p pd=2.56u as=0.56p ps=2.56u w=2u l=1u
X751 a_23540_2387# vbn.t836 a_23250_1807# VSS.t37 nfet_03v3 ad=0.56p pd=2.56u as=0.56p ps=2.56u w=2u l=1u
X752 vbn.t1 net1 VDD.t13 VDD.t12 pfet_03v3 ad=3.92p pd=14.56u as=3.92p ps=14.56u w=14u l=14u
X753 a_27926_7607# vbn.t792 a_28216_7027# VSS.t28 nfet_03v3 ad=0.56p pd=2.56u as=0.56p ps=2.56u w=2u l=1u
X754 a_23540_4707# vbn.t525 a_23250_5287# VSS.t32 nfet_03v3 ad=0.56p pd=2.56u as=0.56p ps=2.56u w=2u l=1u
X755 a_23540_2387# vbn.t409 a_23250_2967# VSS.t36 nfet_03v3 ad=0.56p pd=2.56u as=0.56p ps=2.56u w=2u l=1u
X756 a_27926_4127# vbn.t276 a_28216_4707# VSS.t33 nfet_03v3 ad=0.56p pd=2.56u as=0.56p ps=2.56u w=2u l=1u
X757 a_23250_4127# vbn.t496 a_23540_4707# VSS.t33 nfet_03v3 ad=0.56p pd=2.56u as=0.56p ps=2.56u w=2u l=1u
X758 a_23540_3547# vbn.t473 a_23250_4127# VSS.t34 nfet_03v3 ad=0.56p pd=2.56u as=0.56p ps=2.56u w=2u l=1u
X759 a_23540_3547# vbn.t449 a_23250_2967# VSS.t35 nfet_03v3 ad=0.56p pd=2.56u as=0.56p ps=2.56u w=2u l=1u
X760 a_23250_1807# vbn.t402 a_23540_2387# VSS.t37 nfet_03v3 ad=0.56p pd=2.56u as=0.56p ps=2.56u w=2u l=1u
X761 a_28216_2387# vbn.t258 a_27926_2967# VSS.t36 nfet_03v3 ad=0.56p pd=2.56u as=0.9p ps=4.9u w=2u l=1u
X762 vbn.t5 vbnf.t0 VSS.t1 ppolyf_u_1k r_width=1u r_length=0.97023m
X763 a_23540_5867# vbn.t577 a_23250_6447# VSS.t30 nfet_03v3 ad=0.56p pd=2.56u as=0.56p ps=2.56u w=2u l=1u
X764 a_23540_4707# vbn.t132 a_23250_4127# VSS.t33 nfet_03v3 ad=0.56p pd=2.56u as=0.9p ps=4.9u w=2u l=1u
X765 net3 vbn.t815 a_23540_1227# VSS.t25 nfet_03v3 ad=0.56p pd=2.56u as=0.56p ps=2.56u w=2u l=1u
X766 a_23540_2387# vbn.t848 a_23250_2967# VSS.t36 nfet_03v3 ad=0.56p pd=2.56u as=0.56p ps=2.56u w=2u l=1u
X767 a_23250_1807# vbn.t839 a_23540_2387# VSS.t37 nfet_03v3 ad=0.56p pd=2.56u as=0.56p ps=2.56u w=2u l=1u
X768 a_23540_7027# vbn.t617 a_23250_6447# VSS.t29 nfet_03v3 ad=0.56p pd=2.56u as=0.56p ps=2.56u w=2u l=1u
X769 a_23250_4127# vbn.t478 a_23540_3547# VSS.t34 nfet_03v3 ad=0.56p pd=2.56u as=0.56p ps=2.56u w=2u l=1u
X770 a_23250_2967# vbn.t454 a_23540_3547# VSS.t35 nfet_03v3 ad=0.56p pd=2.56u as=0.56p ps=2.56u w=2u l=1u
X771 vbn.t27 vbn.t26 a_28216_8187# VSS.t26 nfet_03v3 ad=0.56p pd=2.56u as=0.56p ps=2.56u w=2u l=1u
X772 a_23540_7027# vbn.t190 a_23250_7607# VSS.t28 nfet_03v3 ad=0.56p pd=2.56u as=0.56p ps=2.56u w=2u l=1u
X773 net1 vbn.t692 a_23540_8187# VSS.t26 nfet_03v3 ad=0.56p pd=2.56u as=0.56p ps=2.56u w=2u l=1u
X774 a_23540_8187# vbn.t669 a_23250_7607# VSS.t27 nfet_03v3 ad=0.56p pd=2.56u as=0.56p ps=2.56u w=2u l=1u
X775 a_28216_5867# vbn.t300 a_27926_6447# VSS.t30 nfet_03v3 ad=0.56p pd=2.56u as=0.9p ps=4.9u w=2u l=1u
X776 a_23540_4707# vbn.t499 a_23250_4127# VSS.t33 nfet_03v3 ad=0.56p pd=2.56u as=0.56p ps=2.56u w=2u l=1u
X777 a_23250_2967# vbn.t452 a_23540_3547# VSS.t35 nfet_03v3 ad=0.56p pd=2.56u as=0.56p ps=2.56u w=2u l=1u
X778 a_23250_2967# vbn.t428 a_23540_2387# VSS.t36 nfet_03v3 ad=0.56p pd=2.56u as=0.56p ps=2.56u w=2u l=1u
X779 a_23250_1807# vbn.t360 a_23540_1227# VSS.t38 nfet_03v3 ad=0.56p pd=2.56u as=0.56p ps=2.56u w=2u l=1u
X780 a_23540_2387# vbn.t405 a_23250_1807# VSS.t37 nfet_03v3 ad=0.56p pd=2.56u as=0.9p ps=4.9u w=2u l=1u
X781 a_23540_8187# vbn.t230 net1 VSS.t26 nfet_03v3 ad=0.56p pd=2.56u as=0.9p ps=4.9u w=2u l=1u
X782 a_23540_5867# vbn.t932 a_23250_6447# VSS.t30 nfet_03v3 ad=0.56p pd=2.56u as=0.56p ps=2.56u w=2u l=1u
X783 a_23250_5287# vbn.t913 a_23540_4707# VSS.t25 nfet_03v3 ad=0.56p pd=2.56u as=0.56p ps=2.56u w=2u l=1u
X784 a_23250_2967# vbn.t863 a_23540_3547# VSS.t35 nfet_03v3 ad=0.56p pd=2.56u as=0.56p ps=2.56u w=2u l=1u
X785 a_23540_2387# vbn.t844 a_23250_1807# VSS.t24 nfet_03v3 ad=0.56p pd=2.56u as=0.56p ps=2.56u w=2u l=1u
X786 a_23250_6447# vbn.t622 a_23540_7027# VSS.t29 nfet_03v3 ad=0.56p pd=2.56u as=0.56p ps=2.56u w=2u l=1u
X787 a_27926_4127# vbn.t750 a_28216_3547# VSS.t34 nfet_03v3 ad=0.56p pd=2.56u as=0.56p ps=2.56u w=2u l=1u
X788 a_23250_7607# vbn.t674 a_23540_8187# VSS.t27 nfet_03v3 ad=0.56p pd=2.56u as=0.56p ps=2.56u w=2u l=1u
X789 VSS.t50 vbn.t234 a_28216_1227# VSS.t39 nfet_03v3 ad=0.56p pd=2.56u as=0.56p ps=2.56u w=2u l=1u
X790 a_23250_2967# vbn.t851 a_23540_2387# VSS.t36 nfet_03v3 ad=0.56p pd=2.56u as=0.56p ps=2.56u w=2u l=1u
X791 a_23250_6447# vbn.t620 a_23540_7027# VSS.t29 nfet_03v3 ad=0.56p pd=2.56u as=0.56p ps=2.56u w=2u l=1u
X792 a_23250_6447# vbn.t596 a_23540_5867# VSS.t30 nfet_03v3 ad=0.56p pd=2.56u as=0.56p ps=2.56u w=2u l=1u
X793 a_23250_4127# vbn.t504 a_23540_4707# VSS.t33 nfet_03v3 ad=0.56p pd=2.56u as=0.56p ps=2.56u w=2u l=1u
X794 a_23540_3547# vbn.t457 a_23250_2967# VSS.t35 nfet_03v3 ad=0.56p pd=2.56u as=0.56p ps=2.56u w=2u l=1u
X795 net3 vbn.t328 a_23540_1227# VSS.t39 nfet_03v3 ad=0.56p pd=2.56u as=0.56p ps=2.56u w=2u l=1u
X796 a_23250_5287# vbn.t556 a_23540_5867# VSS.t31 nfet_03v3 ad=0.56p pd=2.56u as=0.56p ps=2.56u w=2u l=1u
X797 a_23540_8187# vbn.t695 net1 VSS.t26 nfet_03v3 ad=0.56p pd=2.56u as=0.56p ps=2.56u w=2u l=1u
X798 a_23250_6447# vbn.t947 a_23540_7027# VSS.t29 nfet_03v3 ad=0.56p pd=2.56u as=0.56p ps=2.56u w=2u l=1u
X799 a_23540_1227# vbn.t48 net3 VSS.t39 nfet_03v3 ad=0.56p pd=2.56u as=0.9p ps=4.9u w=2u l=1u
X800 a_27926_7607# vbn.t799 a_28216_8187# VSS.t27 nfet_03v3 ad=0.56p pd=2.56u as=0.56p ps=2.56u w=2u l=1u
X801 a_23250_2967# vbn.t91 a_23540_3547# VSS.t35 nfet_03v3 ad=0.9p pd=4.9u as=0.56p ps=2.56u w=2u l=1u
X802 a_23250_6447# vbn.t935 a_23540_5867# VSS.t30 nfet_03v3 ad=0.56p pd=2.56u as=0.56p ps=2.56u w=2u l=1u
X803 a_23540_3547# vbn.t866 a_23250_2967# VSS.t35 nfet_03v3 ad=0.56p pd=2.56u as=0.56p ps=2.56u w=2u l=1u
X804 a_23540_2387# vbn.t856 a_23250_2967# VSS.t36 nfet_03v3 ad=0.56p pd=2.56u as=0.56p ps=2.56u w=2u l=1u
X805 a_23540_7027# vbn.t625 a_23250_6447# VSS.t29 nfet_03v3 ad=0.56p pd=2.56u as=0.56p ps=2.56u w=2u l=1u
X806 a_28216_1227# vbn.t721 a_27926_1807# VSS.t38 nfet_03v3 ad=0.9p pd=4.9u as=0.56p ps=2.56u w=2u l=1u
X807 net1 vbn.t700 a_23540_8187# VSS.t26 nfet_03v3 ad=0.56p pd=2.56u as=0.56p ps=2.56u w=2u l=1u
X808 a_23540_3547# vbn.t106 a_23250_4127# VSS.t34 nfet_03v3 ad=0.56p pd=2.56u as=0.56p ps=2.56u w=2u l=1u
X809 a_27926_5287# vbn.t283 a_28216_4707# VSS.t32 nfet_03v3 ad=0.56p pd=2.56u as=0.56p ps=2.56u w=2u l=1u
X810 a_23250_5287# vbn.t524 a_23540_4707# VSS.t32 nfet_03v3 ad=0.56p pd=2.56u as=0.56p ps=2.56u w=2u l=1u
X811 a_27926_7607# vbn.t313 a_28216_7027# VSS.t28 nfet_03v3 ad=0.56p pd=2.56u as=0.56p ps=2.56u w=2u l=1u
X812 a_23540_1227# vbn.t832 a_23250_1807# VSS.t22 nfet_03v3 ad=0.56p pd=2.56u as=0.9p ps=4.9u w=2u l=1u
X813 a_23540_4707# vbn.t507 a_23250_4127# VSS.t33 nfet_03v3 ad=0.56p pd=2.56u as=0.56p ps=2.56u w=2u l=1u
X814 a_23540_1227# vbn.t331 net3 VSS.t39 nfet_03v3 ad=0.56p pd=2.56u as=0.56p ps=2.56u w=2u l=1u
X815 a_23540_3547# vbn.t96 a_23250_2967# VSS.t35 nfet_03v3 ad=0.56p pd=2.56u as=0.56p ps=2.56u w=2u l=1u
X816 a_23540_2387# vbn.t86 a_23250_2967# VSS.t36 nfet_03v3 ad=0.56p pd=2.56u as=0.56p ps=2.56u w=2u l=1u
X817 a_23540_4707# vbn.t146 a_23250_5287# VSS.t32 nfet_03v3 ad=0.56p pd=2.56u as=0.9p ps=4.9u w=2u l=1u
X818 a_23250_6447# vbn.t175 a_23540_7027# VSS.t29 nfet_03v3 ad=0.9p pd=4.9u as=0.56p ps=2.56u w=2u l=1u
X819 a_23250_7607# vbn.t959 a_23540_7027# VSS.t28 nfet_03v3 ad=0.9p pd=4.9u as=0.56p ps=2.56u w=2u l=1u
X820 a_23540_7027# vbn.t950 a_23250_6447# VSS.t29 nfet_03v3 ad=0.56p pd=2.56u as=0.56p ps=2.56u w=2u l=1u
X821 a_23540_5867# vbn.t940 a_23250_6447# VSS.t30 nfet_03v3 ad=0.56p pd=2.56u as=0.56p ps=2.56u w=2u l=1u
X822 a_27926_1807# vbn.t239 a_28216_1227# VSS.t38 nfet_03v3 ad=0.56p pd=2.56u as=0.56p ps=2.56u w=2u l=1u
X823 a_28216_5867# vbn.t770 a_27926_5287# VSS.t31 nfet_03v3 ad=0.9p pd=4.9u as=0.56p ps=2.56u w=2u l=1u
X824 a_23540_8187# vbn.t204 a_23250_7607# VSS.t27 nfet_03v3 ad=0.56p pd=2.56u as=0.56p ps=2.56u w=2u l=1u
X825 a_23540_5867# vbn.t930 a_23250_5287# VSS.t22 nfet_03v3 ad=0.56p pd=2.56u as=0.9p ps=4.9u w=2u l=1u
X826 net3 vbn.t336 a_23540_1227# VSS.t39 nfet_03v3 ad=0.56p pd=2.56u as=0.56p ps=2.56u w=2u l=1u
X827 a_28216_4707# vbn.t760 a_27926_4127# VSS.t33 nfet_03v3 ad=0.56p pd=2.56u as=0.56p ps=2.56u w=2u l=1u
X828 a_23540_8187# vbn.t703 net1 VSS.t26 nfet_03v3 ad=0.56p pd=2.56u as=0.56p ps=2.56u w=2u l=1u
X829 a_23250_2967# vbn.t101 a_23540_3547# VSS.t35 nfet_03v3 ad=0.56p pd=2.56u as=0.56p ps=2.56u w=2u l=1u
X830 a_23250_1807# vbn.t388 a_23540_2387# VSS.t37 nfet_03v3 ad=0.56p pd=2.56u as=0.56p ps=2.56u w=2u l=1u
X831 a_23540_4707# vbn.t527 a_23250_5287# VSS.t32 nfet_03v3 ad=0.56p pd=2.56u as=0.56p ps=2.56u w=2u l=1u
X832 a_23540_3547# vbn.t435 a_23250_2967# VSS.t35 nfet_03v3 ad=0.56p pd=2.56u as=0.56p ps=2.56u w=2u l=1u
X833 a_23540_2387# vbn.t411 a_23250_2967# VSS.t36 nfet_03v3 ad=0.56p pd=2.56u as=0.56p ps=2.56u w=2u l=1u
X834 a_23540_5867# vbn.t170 a_23250_6447# VSS.t30 nfet_03v3 ad=0.56p pd=2.56u as=0.56p ps=2.56u w=2u l=1u
X835 a_23540_7027# vbn.t180 a_23250_6447# VSS.t29 nfet_03v3 ad=0.56p pd=2.56u as=0.56p ps=2.56u w=2u l=1u
X836 a_28216_2387# vbn.t254 a_27926_2967# VSS.t36 nfet_03v3 ad=0.56p pd=2.56u as=0.56p ps=2.56u w=2u l=1u
X837 a_23250_2967# vbn.t99 a_23540_3547# VSS.t35 nfet_03v3 ad=0.56p pd=2.56u as=0.56p ps=2.56u w=2u l=1u
X838 a_23250_2967# vbn.t89 a_23540_2387# VSS.t36 nfet_03v3 ad=0.56p pd=2.56u as=0.56p ps=2.56u w=2u l=1u
X839 a_27926_5287# vbn.t288 a_28216_5867# VSS.t31 nfet_03v3 ad=0.56p pd=2.56u as=0.56p ps=2.56u w=2u l=1u
X840 a_23250_6447# vbn.t185 a_23540_7027# VSS.t29 nfet_03v3 ad=0.56p pd=2.56u as=0.56p ps=2.56u w=2u l=1u
X841 a_28216_8187# vbn.t10 vbn.t11 VSS.t26 nfet_03v3 ad=0.56p pd=2.56u as=0.56p ps=2.56u w=2u l=1u
X842 a_23540_7027# vbn.t603 a_23250_6447# VSS.t29 nfet_03v3 ad=0.56p pd=2.56u as=0.56p ps=2.56u w=2u l=1u
X843 a_23540_5867# vbn.t579 a_23250_6447# VSS.t30 nfet_03v3 ad=0.56p pd=2.56u as=0.56p ps=2.56u w=2u l=1u
X844 a_23250_5287# vbn.t532 a_23540_4707# VSS.t32 nfet_03v3 ad=0.56p pd=2.56u as=0.56p ps=2.56u w=2u l=1u
X845 a_27926_4127# vbn.t271 a_28216_3547# VSS.t34 nfet_03v3 ad=0.56p pd=2.56u as=0.56p ps=2.56u w=2u l=1u
X846 a_23250_7607# vbn.t656 a_23540_7027# VSS.t28 nfet_03v3 ad=0.56p pd=2.56u as=0.56p ps=2.56u w=2u l=1u
X847 a_23540_1227# vbn.t339 net3 VSS.t39 nfet_03v3 ad=0.56p pd=2.56u as=0.56p ps=2.56u w=2u l=1u
X848 a_23250_1807# vbn.t362 a_23540_1227# VSS.t38 nfet_03v3 ad=0.56p pd=2.56u as=0.56p ps=2.56u w=2u l=1u
X849 a_28216_7027# vbn.t797 a_27926_7607# VSS.t28 nfet_03v3 ad=0.56p pd=2.56u as=0.9p ps=4.9u w=2u l=1u
X850 a_23250_4127# vbn.t123 a_23540_4707# VSS.t33 nfet_03v3 ad=0.56p pd=2.56u as=0.56p ps=2.56u w=2u l=1u
X851 a_28216_5867# vbn.t296 a_27926_6447# VSS.t30 nfet_03v3 ad=0.56p pd=2.56u as=0.56p ps=2.56u w=2u l=1u
X852 a_23250_2967# vbn.t414 a_23540_2387# VSS.t36 nfet_03v3 ad=0.56p pd=2.56u as=0.56p ps=2.56u w=2u l=1u
X853 a_23250_6447# vbn.t173 a_23540_5867# VSS.t30 nfet_03v3 ad=0.56p pd=2.56u as=0.56p ps=2.56u w=2u l=1u
X854 a_23250_6447# vbn.t183 a_23540_7027# VSS.t29 nfet_03v3 ad=0.56p pd=2.56u as=0.56p ps=2.56u w=2u l=1u
X855 a_23540_7027# vbn.t192 a_23250_7607# VSS.t28 nfet_03v3 ad=0.56p pd=2.56u as=0.56p ps=2.56u w=2u l=1u
X856 a_23250_4127# vbn.t875 a_23540_3547# VSS.t34 nfet_03v3 ad=0.9p pd=4.9u as=0.56p ps=2.56u w=2u l=1u
X857 a_28216_2387# vbn.t728 a_27926_1807# VSS.t37 nfet_03v3 ad=0.9p pd=4.9u as=0.56p ps=2.56u w=2u l=1u
X858 VSS.t19 vbnf.t2 VSS.t19 VSS.t18 nfet_03v3 ad=13.7592p pd=49.7u as=0 ps=0 w=49.14u l=10u
X859 a_23250_7607# vbn.t967 a_23540_7027# VSS.t28 nfet_03v3 ad=0.56p pd=2.56u as=0.56p ps=2.56u w=2u l=1u
X860 a_27926_7607# vbn.t320 a_28216_8187# VSS.t27 nfet_03v3 ad=0.56p pd=2.56u as=0.56p ps=2.56u w=2u l=1u
X861 a_23540_2387# vbn.t846 a_23250_1807# VSS.t22 nfet_03v3 ad=0.56p pd=2.56u as=0.9p ps=4.9u w=2u l=1u
X862 a_28216_1227# vbn.t718 VSS.t42 VSS.t39 nfet_03v3 ad=0.56p pd=2.56u as=0.56p ps=2.56u w=2u l=1u
X863 a_23250_4127# vbn.t490 a_23540_4707# VSS.t33 nfet_03v3 ad=0.9p pd=4.9u as=0.56p ps=2.56u w=2u l=1u
X864 a_23540_2387# vbn.t419 a_23250_2967# VSS.t36 nfet_03v3 ad=0.56p pd=2.56u as=0.56p ps=2.56u w=2u l=1u
X865 a_23250_6447# vbn.t582 a_23540_5867# VSS.t30 nfet_03v3 ad=0.56p pd=2.56u as=0.56p ps=2.56u w=2u l=1u
X866 a_23250_5287# vbn.t558 a_23540_5867# VSS.t31 nfet_03v3 ad=0.56p pd=2.56u as=0.56p ps=2.56u w=2u l=1u
X867 a_23540_4707# vbn.t535 a_23250_5287# VSS.t32 nfet_03v3 ad=0.56p pd=2.56u as=0.56p ps=2.56u w=2u l=1u
X868 net1 vbn.t221 a_23540_8187# VSS.t26 nfet_03v3 ad=0.56p pd=2.56u as=0.56p ps=2.56u w=2u l=1u
X869 a_23250_7607# vbn.t973 a_23540_8187# VSS.t27 nfet_03v3 ad=0.9p pd=4.9u as=0.56p ps=2.56u w=2u l=1u
X870 a_23540_3547# vbn.t459 a_23250_2967# VSS.t35 nfet_03v3 ad=0.56p pd=2.56u as=0.56p ps=2.56u w=2u l=1u
X871 a_23540_4707# vbn.t126 a_23250_4127# VSS.t33 nfet_03v3 ad=0.56p pd=2.56u as=0.56p ps=2.56u w=2u l=1u
X872 net4 VSS.t57 VSS.t56 nplus_u r_width=2u r_length=100u
X873 a_27926_1807# vbn.t246 a_28216_2387# VSS.t37 nfet_03v3 ad=0.56p pd=2.56u as=0.56p ps=2.56u w=2u l=1u
X874 a_23250_7607# vbn.t195 a_23540_7027# VSS.t28 nfet_03v3 ad=0.56p pd=2.56u as=0.56p ps=2.56u w=2u l=1u
X875 a_23540_5867# vbn.t587 a_23250_6447# VSS.t30 nfet_03v3 ad=0.56p pd=2.56u as=0.56p ps=2.56u w=2u l=1u
X876 a_23250_7607# vbn.t634 a_23540_7027# VSS.t28 nfet_03v3 ad=0.56p pd=2.56u as=0.56p ps=2.56u w=2u l=1u
X877 a_28216_4707# vbn.t767 a_27926_5287# VSS.t32 nfet_03v3 ad=0.56p pd=2.56u as=0.56p ps=2.56u w=2u l=1u
X878 net1 vbn.t686 a_23540_8187# VSS.t26 nfet_03v3 ad=0.9p pd=4.9u as=0.56p ps=2.56u w=2u l=1u
X879 a_23540_4707# vbn.t511 a_23250_4127# VSS.t33 nfet_03v3 ad=0.56p pd=2.56u as=0.56p ps=2.56u w=2u l=1u
X880 a_23250_4127# vbn.t488 a_23540_3547# VSS.t34 nfet_03v3 ad=0.56p pd=2.56u as=0.56p ps=2.56u w=2u l=1u
X881 a_23540_3547# vbn.t868 a_23250_2967# VSS.t35 nfet_03v3 ad=0.56p pd=2.56u as=0.56p ps=2.56u w=2u l=1u
X882 a_28216_1227# vbn.t723 a_27926_1807# VSS.t38 nfet_03v3 ad=0.56p pd=2.56u as=0.56p ps=2.56u w=2u l=1u
X883 a_23540_7027# vbn.t627 a_23250_6447# VSS.t29 nfet_03v3 ad=0.56p pd=2.56u as=0.56p ps=2.56u w=2u l=1u
X884 a_23540_7027# vbn.t200 a_23250_7607# VSS.t28 nfet_03v3 ad=0.56p pd=2.56u as=0.56p ps=2.56u w=2u l=1u
X885 a_28216_3547# vbn.t755 a_27926_4127# VSS.t34 nfet_03v3 ad=0.56p pd=2.56u as=0.9p ps=4.9u w=2u l=1u
X886 a_23250_7607# vbn.t632 a_23540_7027# VSS.t28 nfet_03v3 ad=0.56p pd=2.56u as=0.56p ps=2.56u w=2u l=1u
X887 a_23540_3547# vbn.t108 a_23250_4127# VSS.t34 nfet_03v3 ad=0.56p pd=2.56u as=0.56p ps=2.56u w=2u l=1u
X888 net3 vbn.t39 a_23540_1227# VSS.t39 nfet_03v3 ad=0.56p pd=2.56u as=0.56p ps=2.56u w=2u l=1u
X889 a_23540_8187# vbn.t224 net1 VSS.t26 nfet_03v3 ad=0.56p pd=2.56u as=0.56p ps=2.56u w=2u l=1u
X890 a_23540_4707# vbn.t509 a_23250_4127# VSS.t33 nfet_03v3 ad=0.56p pd=2.56u as=0.56p ps=2.56u w=2u l=1u
X891 a_23250_4127# vbn.t883 a_23540_3547# VSS.t34 nfet_03v3 ad=0.56p pd=2.56u as=0.56p ps=2.56u w=2u l=1u
X892 a_23250_2967# vbn.t873 a_23540_3547# VSS.t23 nfet_03v3 ad=0.56p pd=2.56u as=0.56p ps=2.56u w=2u l=1u
X893 a_23540_7027# vbn.t952 a_23250_6447# VSS.t29 nfet_03v3 ad=0.56p pd=2.56u as=0.56p ps=2.56u w=2u l=1u
X894 a_23540_4707# vbn.t892 a_23250_4127# VSS.t33 nfet_03v3 ad=0.56p pd=2.56u as=0.56p ps=2.56u w=2u l=1u
X895 a_27926_2967# vbn.t738 a_28216_2387# VSS.t36 nfet_03v3 ad=0.56p pd=2.56u as=0.56p ps=2.56u w=2u l=1u
X896 a_23540_8187# vbn.t707 net1 VSS.t26 nfet_03v3 ad=0.56p pd=2.56u as=0.56p ps=2.56u w=2u l=1u
X897 a_23250_7607# vbn.t684 a_23540_8187# VSS.t27 nfet_03v3 ad=0.56p pd=2.56u as=0.56p ps=2.56u w=2u l=1u
X898 a_23540_7027# vbn.t637 a_23250_7607# VSS.t28 nfet_03v3 ad=0.56p pd=2.56u as=0.56p ps=2.56u w=2u l=1u
X899 net3 vbn.t322 a_23540_1227# VSS.t39 nfet_03v3 ad=0.9p pd=4.9u as=0.56p ps=2.56u w=2u l=1u
X900 a_23250_1807# vbn.t390 a_23540_2387# VSS.t37 nfet_03v3 ad=0.56p pd=2.56u as=0.56p ps=2.56u w=2u l=1u
X901 a_28216_8187# vbn.t804 a_27926_7607# VSS.t27 nfet_03v3 ad=0.56p pd=2.56u as=0.9p ps=4.9u w=2u l=1u
X902 a_28216_5867# vbn.t772 a_27926_5287# VSS.t31 nfet_03v3 ad=0.56p pd=2.56u as=0.56p ps=2.56u w=2u l=1u
X903 a_23250_5287# vbn.t137 a_23540_4707# VSS.t32 nfet_03v3 ad=0.56p pd=2.56u as=0.56p ps=2.56u w=2u l=1u
X904 a_23250_4127# vbn.t514 a_23540_4707# VSS.t33 nfet_03v3 ad=0.56p pd=2.56u as=0.56p ps=2.56u w=2u l=1u
X905 a_23540_8187# vbn.t206 a_23250_7607# VSS.t27 nfet_03v3 ad=0.56p pd=2.56u as=0.56p ps=2.56u w=2u l=1u
X906 a_27926_1807# vbn.t726 a_28216_1227# VSS.t38 nfet_03v3 ad=0.56p pd=2.56u as=0.56p ps=2.56u w=2u l=1u
X907 a_28216_2387# vbn.t256 a_27926_2967# VSS.t36 nfet_03v3 ad=0.56p pd=2.56u as=0.56p ps=2.56u w=2u l=1u
X908 a_28216_3547# vbn.t259 a_27926_2967# VSS.t35 nfet_03v3 ad=0.9p pd=4.9u as=0.56p ps=2.56u w=2u l=1u
X909 VDD.t15 net1 vbn.t4 VDD.t14 pfet_03v3 ad=6.3p pd=28.9u as=3.92p ps=14.56u w=14u l=14u
X910 a_23540_8187# vbn.t705 net1 VSS.t26 nfet_03v3 ad=0.56p pd=2.56u as=0.56p ps=2.56u w=2u l=1u
X911 a_23250_4127# vbn.t111 a_23540_3547# VSS.t34 nfet_03v3 ad=0.56p pd=2.56u as=0.56p ps=2.56u w=2u l=1u
X912 a_23250_1807# vbn.t51 a_23540_1227# VSS.t38 nfet_03v3 ad=0.56p pd=2.56u as=0.56p ps=2.56u w=2u l=1u
X913 a_23540_1227# vbn.t42 net3 VSS.t39 nfet_03v3 ad=0.56p pd=2.56u as=0.56p ps=2.56u w=2u l=1u
X914 a_23250_6447# vbn.t957 a_23540_7027# VSS.t23 nfet_03v3 ad=0.56p pd=2.56u as=0.56p ps=2.56u w=2u l=1u
X915 VSS.t11 vbnf.t6 VSS.t11 VSS.t10 nfet_03v3 ad=13.7592p pd=49.7u as=0 ps=0 w=49.14u l=10u
X916 a_23540_8187# vbn.t990 net1 VSS.t26 nfet_03v3 ad=0.56p pd=2.56u as=0.56p ps=2.56u w=2u l=1u
X917 a_23250_7607# vbn.t981 a_23540_8187# VSS.t27 nfet_03v3 ad=0.56p pd=2.56u as=0.56p ps=2.56u w=2u l=1u
X918 a_23250_4127# vbn.t466 a_23540_3547# VSS.t34 nfet_03v3 ad=0.56p pd=2.56u as=0.56p ps=2.56u w=2u l=1u
X919 a_27926_6447# vbn.t780 a_28216_5867# VSS.t30 nfet_03v3 ad=0.56p pd=2.56u as=0.56p ps=2.56u w=2u l=1u
X920 a_23250_5287# vbn.t518 a_23540_4707# VSS.t32 nfet_03v3 ad=0.9p pd=4.9u as=0.56p ps=2.56u w=2u l=1u
X921 a_23250_4127# vbn.t895 a_23540_4707# VSS.t33 nfet_03v3 ad=0.56p pd=2.56u as=0.56p ps=2.56u w=2u l=1u
X922 a_28216_5867# vbn.t298 a_27926_6447# VSS.t30 nfet_03v3 ad=0.56p pd=2.56u as=0.56p ps=2.56u w=2u l=1u
X923 a_28216_7027# vbn.t301 a_27926_6447# VSS.t29 nfet_03v3 ad=0.9p pd=4.9u as=0.56p ps=2.56u w=2u l=1u
X924 a_23540_1227# vbn.t343 net3 VSS.t39 nfet_03v3 ad=0.56p pd=2.56u as=0.56p ps=2.56u w=2u l=1u
X925 net1 vbn.t710 a_23540_8187# VSS.t26 nfet_03v3 ad=0.56p pd=2.56u as=0.56p ps=2.56u w=2u l=1u
X926 a_23250_4127# vbn.t464 a_23540_3547# VSS.t34 nfet_03v3 ad=0.56p pd=2.56u as=0.56p ps=2.56u w=2u l=1u
X927 a_23540_3547# vbn.t116 a_23250_4127# VSS.t34 nfet_03v3 ad=0.56p pd=2.56u as=0.56p ps=2.56u w=2u l=1u
X928 a_27926_5287# vbn.t775 a_28216_5867# VSS.t31 nfet_03v3 ad=0.56p pd=2.56u as=0.56p ps=2.56u w=2u l=1u
X929 a_23540_4707# vbn.t140 a_23250_5287# VSS.t32 nfet_03v3 ad=0.56p pd=2.56u as=0.56p ps=2.56u w=2u l=1u
X930 a_23250_5287# vbn.t149 a_23540_5867# VSS.t31 nfet_03v3 ad=0.56p pd=2.56u as=0.56p ps=2.56u w=2u l=1u
X931 a_23540_4707# vbn.t517 a_23250_4127# VSS.t33 nfet_03v3 ad=0.56p pd=2.56u as=0.9p ps=4.9u w=2u l=1u
X932 a_23250_7607# vbn.t209 a_23540_8187# VSS.t27 nfet_03v3 ad=0.56p pd=2.56u as=0.56p ps=2.56u w=2u l=1u
X933 a_23540_1227# vbn.t341 net3 VSS.t39 nfet_03v3 ad=0.56p pd=2.56u as=0.56p ps=2.56u w=2u l=1u
X934 a_23250_7607# vbn.t662 a_23540_8187# VSS.t27 nfet_03v3 ad=0.56p pd=2.56u as=0.56p ps=2.56u w=2u l=1u
X935 a_23540_4707# vbn.t900 a_23250_4127# VSS.t24 nfet_03v3 ad=0.56p pd=2.56u as=0.56p ps=2.56u w=2u l=1u
X936 a_23250_7607# vbn.t969 a_23540_7027# VSS.t25 nfet_03v3 ad=0.56p pd=2.56u as=0.56p ps=2.56u w=2u l=1u
X937 a_23540_1227# vbn.t808 net3 VSS.t39 nfet_03v3 ad=0.56p pd=2.56u as=0.56p ps=2.56u w=2u l=1u
X938 net1 vbn.t993 a_23540_8187# VSS.t26 nfet_03v3 ad=0.56p pd=2.56u as=0.56p ps=2.56u w=2u l=1u
X939 a_23540_4707# vbn.t539 a_23250_5287# VSS.t32 nfet_03v3 ad=0.56p pd=2.56u as=0.56p ps=2.56u w=2u l=1u
X940 a_23540_3547# vbn.t469 a_23250_4127# VSS.t34 nfet_03v3 ad=0.56p pd=2.56u as=0.56p ps=2.56u w=2u l=1u
X941 a_23540_1227# vbn.t353 a_23250_1807# VSS.t38 nfet_03v3 ad=0.56p pd=2.56u as=0.56p ps=2.56u w=2u l=1u
X942 a_28216_2387# vbn.t730 a_27926_1807# VSS.t37 nfet_03v3 ad=0.56p pd=2.56u as=0.56p ps=2.56u w=2u l=1u
X943 a_23540_8187# vbn.t214 a_23250_7607# VSS.t27 nfet_03v3 ad=0.56p pd=2.56u as=0.56p ps=2.56u w=2u l=1u
X944 a_23250_7607# vbn.t660 a_23540_8187# VSS.t27 nfet_03v3 ad=0.56p pd=2.56u as=0.56p ps=2.56u w=2u l=1u
X945 net3 vbn.t346 a_23540_1227# VSS.t39 nfet_03v3 ad=0.56p pd=2.56u as=0.56p ps=2.56u w=2u l=1u
X946 a_23540_8187# vbn.t713 net1 VSS.t26 nfet_03v3 ad=0.56p pd=2.56u as=0.9p ps=4.9u w=2u l=1u
X947 a_23540_4707# vbn.t537 a_23250_5287# VSS.t32 nfet_03v3 ad=0.56p pd=2.56u as=0.56p ps=2.56u w=2u l=1u
X948 a_23540_3547# vbn.t445 a_23250_2967# VSS.t35 nfet_03v3 ad=0.56p pd=2.56u as=0.56p ps=2.56u w=2u l=1u
X949 a_23540_2387# vbn.t421 a_23250_2967# VSS.t36 nfet_03v3 ad=0.56p pd=2.56u as=0.56p ps=2.56u w=2u l=1u
X950 a_28216_1227# vbn.t244 a_27926_1807# VSS.t38 nfet_03v3 ad=0.56p pd=2.56u as=0.9p ps=4.9u w=2u l=1u
X951 a_23540_8187# vbn.t998 net1 VSS.t24 nfet_03v3 ad=0.56p pd=2.56u as=0.56p ps=2.56u w=2u l=1u
X952 a_23540_4707# vbn.t906 a_23250_5287# VSS.t32 nfet_03v3 ad=0.56p pd=2.56u as=0.56p ps=2.56u w=2u l=1u
X953 a_23540_8187# vbn.t665 a_23250_7607# VSS.t27 nfet_03v3 ad=0.56p pd=2.56u as=0.56p ps=2.56u w=2u l=1u
X954 a_23540_5867# vbn.t549 a_23250_5287# VSS.t31 nfet_03v3 ad=0.56p pd=2.56u as=0.56p ps=2.56u w=2u l=1u
X955 a_23540_1227# vbn.t820 a_23250_1807# VSS.t38 nfet_03v3 ad=0.56p pd=2.56u as=0.56p ps=2.56u w=2u l=1u
X956 net3 vbn.t811 a_23540_1227# VSS.t39 nfet_03v3 ad=0.56p pd=2.56u as=0.56p ps=2.56u w=2u l=1u
X957 a_27926_7607# vbn.t311 a_28216_7027# VSS.t28 nfet_03v3 ad=0.56p pd=2.56u as=0.56p ps=2.56u w=2u l=1u
X958 a_23250_7607# vbn.t636 a_23540_7027# VSS.t28 nfet_03v3 ad=0.56p pd=2.56u as=0.56p ps=2.56u w=2u l=1u
X959 a_23540_7027# vbn.t613 a_23250_6447# VSS.t29 nfet_03v3 ad=0.56p pd=2.56u as=0.56p ps=2.56u w=2u l=1u
X960 a_23540_5867# vbn.t589 a_23250_6447# VSS.t30 nfet_03v3 ad=0.56p pd=2.56u as=0.56p ps=2.56u w=2u l=1u
X961 a_23250_5287# vbn.t542 a_23540_4707# VSS.t32 nfet_03v3 ad=0.56p pd=2.56u as=0.56p ps=2.56u w=2u l=1u
X962 a_23250_2967# vbn.t450 a_23540_3547# VSS.t35 nfet_03v3 ad=0.56p pd=2.56u as=0.56p ps=2.56u w=2u l=1u
X963 a_23250_2967# vbn.t426 a_23540_2387# VSS.t36 nfet_03v3 ad=0.56p pd=2.56u as=0.56p ps=2.56u w=2u l=1u
X964 a_27926_1807# vbn.t733 a_28216_2387# VSS.t37 nfet_03v3 ad=0.56p pd=2.56u as=0.56p ps=2.56u w=2u l=1u
X965 a_23250_1807# vbn.t65 a_23540_2387# VSS.t37 nfet_03v3 ad=0.56p pd=2.56u as=0.56p ps=2.56u w=2u l=1u
X966 a_28216_5867# vbn.t293 a_27926_5287# VSS.t31 nfet_03v3 ad=0.56p pd=2.56u as=0.9p ps=4.9u w=2u l=1u
X967 a_23540_1227# vbn.t349 net3 VSS.t39 nfet_03v3 ad=0.56p pd=2.56u as=0.9p ps=4.9u w=2u l=1u
X968 a_23250_1807# vbn.t372 a_23540_1227# VSS.t38 nfet_03v3 ad=0.56p pd=2.56u as=0.56p ps=2.56u w=2u l=1u
X969 a_23250_2967# vbn.t424 a_23540_2387# VSS.t36 nfet_03v3 ad=0.56p pd=2.56u as=0.56p ps=2.56u w=2u l=1u
X970 a_23540_7027# vbn.t202 a_23250_7607# VSS.t28 nfet_03v3 ad=0.56p pd=2.56u as=0.9p ps=4.9u w=2u l=1u
X971 VSS.t5 vbnf.t9 VSS.t5 VSS.t4 nfet_03v3 ad=13.7592p pd=49.7u as=0 ps=0 w=49.14u l=10u
X972 a_23250_4127# vbn.t885 a_23540_3547# VSS.t25 nfet_03v3 ad=0.56p pd=2.56u as=0.56p ps=2.56u w=2u l=1u
X973 a_23540_1227# vbn.t816 net3 VSS.t24 nfet_03v3 ad=0.56p pd=2.56u as=0.56p ps=2.56u w=2u l=1u
X974 a_23540_5867# vbn.t918 a_23250_5287# VSS.t31 nfet_03v3 ad=0.56p pd=2.56u as=0.56p ps=2.56u w=2u l=1u
X975 a_23250_5287# vbn.t909 a_23540_4707# VSS.t32 nfet_03v3 ad=0.56p pd=2.56u as=0.56p ps=2.56u w=2u l=1u
X976 a_23250_2967# vbn.t849 a_23540_2387# VSS.t36 nfet_03v3 ad=0.56p pd=2.56u as=0.56p ps=2.56u w=2u l=1u
X977 a_23250_6447# vbn.t618 a_23540_7027# VSS.t29 nfet_03v3 ad=0.56p pd=2.56u as=0.56p ps=2.56u w=2u l=1u
X978 a_23250_6447# vbn.t594 a_23540_5867# VSS.t30 nfet_03v3 ad=0.56p pd=2.56u as=0.56p ps=2.56u w=2u l=1u
X979 a_27926_2967# vbn.t743 a_28216_3547# VSS.t35 nfet_03v3 ad=0.56p pd=2.56u as=0.56p ps=2.56u w=2u l=1u
X980 a_23250_1807# vbn.t823 a_23540_1227# VSS.t38 nfet_03v3 ad=0.56p pd=2.56u as=0.56p ps=2.56u w=2u l=1u
X981 a_23540_7027# vbn.t639 a_23250_7607# VSS.t28 nfet_03v3 ad=0.56p pd=2.56u as=0.56p ps=2.56u w=2u l=1u
X982 a_23250_6447# vbn.t592 a_23540_5867# VSS.t30 nfet_03v3 ad=0.56p pd=2.56u as=0.56p ps=2.56u w=2u l=1u
X983 a_23250_5287# vbn.t568 a_23540_5867# VSS.t31 nfet_03v3 ad=0.56p pd=2.56u as=0.56p ps=2.56u w=2u l=1u
X984 a_23540_4707# vbn.t545 a_23250_5287# VSS.t32 nfet_03v3 ad=0.56p pd=2.56u as=0.9p ps=4.9u w=2u l=1u
X985 a_23250_4127# vbn.t500 a_23540_4707# VSS.t33 nfet_03v3 ad=0.56p pd=2.56u as=0.56p ps=2.56u w=2u l=1u
X986 a_23540_2387# vbn.t429 a_23250_2967# VSS.t36 nfet_03v3 ad=0.56p pd=2.56u as=0.56p ps=2.56u w=2u l=1u
X987 a_23250_6447# vbn.t933 a_23540_5867# VSS.t30 nfet_03v3 ad=0.56p pd=2.56u as=0.56p ps=2.56u w=2u l=1u
X988 a_23540_4707# vbn.t914 a_23250_5287# VSS.t24 nfet_03v3 ad=0.56p pd=2.56u as=0.56p ps=2.56u w=2u l=1u
X989 a_23250_7607# vbn.t983 a_23540_8187# VSS.t25 nfet_03v3 ad=0.56p pd=2.56u as=0.56p ps=2.56u w=2u l=1u
X990 a_27926_6447# vbn.t785 a_28216_7027# VSS.t29 nfet_03v3 ad=0.56p pd=2.56u as=0.56p ps=2.56u w=2u l=1u
X991 a_23540_2387# vbn.t381 a_23250_1807# VSS.t37 nfet_03v3 ad=0.56p pd=2.56u as=0.56p ps=2.56u w=2u l=1u
X992 a_23540_1227# vbn.t828 a_23250_1807# VSS.t38 nfet_03v3 ad=0.56p pd=2.56u as=0.56p ps=2.56u w=2u l=1u
X993 a_23250_2967# vbn.t77 a_23540_2387# VSS.t36 nfet_03v3 ad=0.9p pd=4.9u as=0.56p ps=2.56u w=2u l=1u
X994 a_27926_4127# vbn.t269 a_28216_3547# VSS.t34 nfet_03v3 ad=0.56p pd=2.56u as=0.56p ps=2.56u w=2u l=1u
X995 a_23250_5287# vbn.t921 a_23540_5867# VSS.t31 nfet_03v3 ad=0.56p pd=2.56u as=0.56p ps=2.56u w=2u l=1u
X996 a_23540_2387# vbn.t852 a_23250_2967# VSS.t36 nfet_03v3 ad=0.56p pd=2.56u as=0.56p ps=2.56u w=2u l=1u
X997 a_23250_7607# vbn.t644 a_23540_7027# VSS.t28 nfet_03v3 ad=0.56p pd=2.56u as=0.56p ps=2.56u w=2u l=1u
X998 a_23540_5867# vbn.t597 a_23250_6447# VSS.t30 nfet_03v3 ad=0.56p pd=2.56u as=0.56p ps=2.56u w=2u l=1u
X999 net1 vbn.t696 a_23540_8187# VSS.t26 nfet_03v3 ad=0.56p pd=2.56u as=0.56p ps=2.56u w=2u l=1u
X1000 a_23250_4127# vbn.t468 a_23540_3547# VSS.t34 nfet_03v3 ad=0.56p pd=2.56u as=0.56p ps=2.56u w=2u l=1u
X1001 a_23540_3547# vbn.t92 a_23250_2967# VSS.t35 nfet_03v3 ad=0.56p pd=2.56u as=0.56p ps=2.56u w=2u l=1u
X1002 a_28216_2387# vbn.t251 a_27926_1807# VSS.t37 nfet_03v3 ad=0.56p pd=2.56u as=0.9p ps=4.9u w=2u l=1u
X1003 a_23540_1227# vbn.t58 a_23250_1807# VSS.t38 nfet_03v3 ad=0.56p pd=2.56u as=0.56p ps=2.56u w=2u l=1u
R0 vbnf.n0 vbnf.t1 23.4616
R1 vbnf.n8 vbnf.t10 22.2744
R2 vbnf.n7 vbnf.t9 22.2744
R3 vbnf.n6 vbnf.t8 22.2744
R4 vbnf.n5 vbnf.t7 22.2744
R5 vbnf.n4 vbnf.t6 22.2744
R6 vbnf.n3 vbnf.t5 22.2744
R7 vbnf.n2 vbnf.t4 22.2744
R8 vbnf.n1 vbnf.t3 22.2744
R9 vbnf.n0 vbnf.t2 22.2744
R10 vbnf.n9 vbnf.t0 7.56062
R11 vbnf vbnf.n9 6.55629
R12 vbnf.n1 vbnf.n0 1.18772
R13 vbnf.n2 vbnf.n1 1.18772
R14 vbnf.n3 vbnf.n2 1.18772
R15 vbnf.n4 vbnf.n3 1.18772
R16 vbnf.n5 vbnf.n4 1.18772
R17 vbnf.n6 vbnf.n5 1.18772
R18 vbnf.n7 vbnf.n6 1.18772
R19 vbnf.n8 vbnf.n7 1.18772
R20 vbnf.n9 vbnf.n8 0.591977
R21 vbn.n159 vbn.t34 49.3877
R22 vbn.n143 vbn.n142 41.4329
R23 vbn.n136 vbn.n135 41.4329
R24 vbn.n108 vbn.n107 41.4329
R25 vbn.n101 vbn.n100 41.4329
R26 vbn.n86 vbn.t5 21.6952
R27 vbn.t49 vbn.t35 21.1705
R28 vbn.t63 vbn.t49 21.1705
R29 vbn.t77 vbn.t63 21.1705
R30 vbn.t91 vbn.t77 21.1705
R31 vbn.t105 vbn.t91 21.1705
R32 vbn.t119 vbn.t105 21.1705
R33 vbn.t133 vbn.t119 21.1705
R34 vbn.t147 vbn.t133 21.1705
R35 vbn.t161 vbn.t147 21.1705
R36 vbn.t175 vbn.t161 21.1705
R37 vbn.t189 vbn.t175 21.1705
R38 vbn.t203 vbn.t189 21.1705
R39 vbn.t217 vbn.t203 21.1705
R40 vbn.t50 vbn.t36 21.1705
R41 vbn.t64 vbn.t50 21.1705
R42 vbn.t78 vbn.t64 21.1705
R43 vbn.t92 vbn.t78 21.1705
R44 vbn.t106 vbn.t92 21.1705
R45 vbn.t120 vbn.t106 21.1705
R46 vbn.t134 vbn.t120 21.1705
R47 vbn.t148 vbn.t134 21.1705
R48 vbn.t162 vbn.t148 21.1705
R49 vbn.t176 vbn.t162 21.1705
R50 vbn.t190 vbn.t176 21.1705
R51 vbn.t204 vbn.t190 21.1705
R52 vbn.t218 vbn.t204 21.1705
R53 vbn.t51 vbn.t37 21.1705
R54 vbn.t65 vbn.t51 21.1705
R55 vbn.t79 vbn.t65 21.1705
R56 vbn.t93 vbn.t79 21.1705
R57 vbn.t107 vbn.t93 21.1705
R58 vbn.t121 vbn.t107 21.1705
R59 vbn.t135 vbn.t121 21.1705
R60 vbn.t149 vbn.t135 21.1705
R61 vbn.t163 vbn.t149 21.1705
R62 vbn.t177 vbn.t163 21.1705
R63 vbn.t191 vbn.t177 21.1705
R64 vbn.t205 vbn.t191 21.1705
R65 vbn.t219 vbn.t205 21.1705
R66 vbn.t52 vbn.t38 21.1705
R67 vbn.t66 vbn.t52 21.1705
R68 vbn.t80 vbn.t66 21.1705
R69 vbn.t94 vbn.t80 21.1705
R70 vbn.t108 vbn.t94 21.1705
R71 vbn.t122 vbn.t108 21.1705
R72 vbn.t136 vbn.t122 21.1705
R73 vbn.t150 vbn.t136 21.1705
R74 vbn.t164 vbn.t150 21.1705
R75 vbn.t178 vbn.t164 21.1705
R76 vbn.t192 vbn.t178 21.1705
R77 vbn.t206 vbn.t192 21.1705
R78 vbn.t220 vbn.t206 21.1705
R79 vbn.t53 vbn.t39 21.1705
R80 vbn.t67 vbn.t53 21.1705
R81 vbn.t81 vbn.t67 21.1705
R82 vbn.t95 vbn.t81 21.1705
R83 vbn.t109 vbn.t95 21.1705
R84 vbn.t123 vbn.t109 21.1705
R85 vbn.t137 vbn.t123 21.1705
R86 vbn.t151 vbn.t137 21.1705
R87 vbn.t165 vbn.t151 21.1705
R88 vbn.t179 vbn.t165 21.1705
R89 vbn.t193 vbn.t179 21.1705
R90 vbn.t207 vbn.t193 21.1705
R91 vbn.t221 vbn.t207 21.1705
R92 vbn.t54 vbn.t40 21.1705
R93 vbn.t68 vbn.t54 21.1705
R94 vbn.t82 vbn.t68 21.1705
R95 vbn.t96 vbn.t82 21.1705
R96 vbn.t110 vbn.t96 21.1705
R97 vbn.t124 vbn.t110 21.1705
R98 vbn.t138 vbn.t124 21.1705
R99 vbn.t152 vbn.t138 21.1705
R100 vbn.t166 vbn.t152 21.1705
R101 vbn.t180 vbn.t166 21.1705
R102 vbn.t194 vbn.t180 21.1705
R103 vbn.t208 vbn.t194 21.1705
R104 vbn.t222 vbn.t208 21.1705
R105 vbn.t55 vbn.t41 21.1705
R106 vbn.t69 vbn.t55 21.1705
R107 vbn.t83 vbn.t69 21.1705
R108 vbn.t97 vbn.t83 21.1705
R109 vbn.t111 vbn.t97 21.1705
R110 vbn.t125 vbn.t111 21.1705
R111 vbn.t139 vbn.t125 21.1705
R112 vbn.t153 vbn.t139 21.1705
R113 vbn.t167 vbn.t153 21.1705
R114 vbn.t181 vbn.t167 21.1705
R115 vbn.t195 vbn.t181 21.1705
R116 vbn.t209 vbn.t195 21.1705
R117 vbn.t223 vbn.t209 21.1705
R118 vbn.t56 vbn.t42 21.1705
R119 vbn.t70 vbn.t56 21.1705
R120 vbn.t84 vbn.t70 21.1705
R121 vbn.t98 vbn.t84 21.1705
R122 vbn.t112 vbn.t98 21.1705
R123 vbn.t126 vbn.t112 21.1705
R124 vbn.t140 vbn.t126 21.1705
R125 vbn.t154 vbn.t140 21.1705
R126 vbn.t168 vbn.t154 21.1705
R127 vbn.t182 vbn.t168 21.1705
R128 vbn.t196 vbn.t182 21.1705
R129 vbn.t210 vbn.t196 21.1705
R130 vbn.t224 vbn.t210 21.1705
R131 vbn.t57 vbn.t43 21.1705
R132 vbn.t71 vbn.t57 21.1705
R133 vbn.t85 vbn.t71 21.1705
R134 vbn.t99 vbn.t85 21.1705
R135 vbn.t113 vbn.t99 21.1705
R136 vbn.t127 vbn.t113 21.1705
R137 vbn.t141 vbn.t127 21.1705
R138 vbn.t155 vbn.t141 21.1705
R139 vbn.t169 vbn.t155 21.1705
R140 vbn.t183 vbn.t169 21.1705
R141 vbn.t197 vbn.t183 21.1705
R142 vbn.t211 vbn.t197 21.1705
R143 vbn.t225 vbn.t211 21.1705
R144 vbn.t58 vbn.t44 21.1705
R145 vbn.t72 vbn.t58 21.1705
R146 vbn.t86 vbn.t72 21.1705
R147 vbn.t100 vbn.t86 21.1705
R148 vbn.t114 vbn.t100 21.1705
R149 vbn.t128 vbn.t114 21.1705
R150 vbn.t142 vbn.t128 21.1705
R151 vbn.t156 vbn.t142 21.1705
R152 vbn.t170 vbn.t156 21.1705
R153 vbn.t184 vbn.t170 21.1705
R154 vbn.t198 vbn.t184 21.1705
R155 vbn.t212 vbn.t198 21.1705
R156 vbn.t226 vbn.t212 21.1705
R157 vbn.t59 vbn.t45 21.1705
R158 vbn.t73 vbn.t59 21.1705
R159 vbn.t87 vbn.t73 21.1705
R160 vbn.t101 vbn.t87 21.1705
R161 vbn.t115 vbn.t101 21.1705
R162 vbn.t129 vbn.t115 21.1705
R163 vbn.t143 vbn.t129 21.1705
R164 vbn.t157 vbn.t143 21.1705
R165 vbn.t171 vbn.t157 21.1705
R166 vbn.t185 vbn.t171 21.1705
R167 vbn.t199 vbn.t185 21.1705
R168 vbn.t213 vbn.t199 21.1705
R169 vbn.t227 vbn.t213 21.1705
R170 vbn.t60 vbn.t46 21.1705
R171 vbn.t74 vbn.t60 21.1705
R172 vbn.t88 vbn.t74 21.1705
R173 vbn.t102 vbn.t88 21.1705
R174 vbn.t116 vbn.t102 21.1705
R175 vbn.t130 vbn.t116 21.1705
R176 vbn.t144 vbn.t130 21.1705
R177 vbn.t158 vbn.t144 21.1705
R178 vbn.t172 vbn.t158 21.1705
R179 vbn.t186 vbn.t172 21.1705
R180 vbn.t200 vbn.t186 21.1705
R181 vbn.t214 vbn.t200 21.1705
R182 vbn.t228 vbn.t214 21.1705
R183 vbn.t61 vbn.t47 21.1705
R184 vbn.t75 vbn.t61 21.1705
R185 vbn.t89 vbn.t75 21.1705
R186 vbn.t103 vbn.t89 21.1705
R187 vbn.t117 vbn.t103 21.1705
R188 vbn.t131 vbn.t117 21.1705
R189 vbn.t145 vbn.t131 21.1705
R190 vbn.t159 vbn.t145 21.1705
R191 vbn.t173 vbn.t159 21.1705
R192 vbn.t187 vbn.t173 21.1705
R193 vbn.t201 vbn.t187 21.1705
R194 vbn.t215 vbn.t201 21.1705
R195 vbn.t229 vbn.t215 21.1705
R196 vbn.t62 vbn.t48 21.1705
R197 vbn.t76 vbn.t62 21.1705
R198 vbn.t90 vbn.t76 21.1705
R199 vbn.t104 vbn.t90 21.1705
R200 vbn.t118 vbn.t104 21.1705
R201 vbn.t132 vbn.t118 21.1705
R202 vbn.t146 vbn.t132 21.1705
R203 vbn.t160 vbn.t146 21.1705
R204 vbn.t174 vbn.t160 21.1705
R205 vbn.t188 vbn.t174 21.1705
R206 vbn.t202 vbn.t188 21.1705
R207 vbn.t216 vbn.t202 21.1705
R208 vbn.t230 vbn.t216 21.1705
R209 vbn.t238 vbn.t231 21.1705
R210 vbn.t245 vbn.t238 21.1705
R211 vbn.t252 vbn.t245 21.1705
R212 vbn.t259 vbn.t252 21.1705
R213 vbn.t266 vbn.t259 21.1705
R214 vbn.t273 vbn.t266 21.1705
R215 vbn.t280 vbn.t273 21.1705
R216 vbn.t287 vbn.t280 21.1705
R217 vbn.t294 vbn.t287 21.1705
R218 vbn.t301 vbn.t294 21.1705
R219 vbn.t308 vbn.t301 21.1705
R220 vbn.t315 vbn.t308 21.1705
R221 vbn.t32 vbn.t315 21.1705
R222 vbn.t239 vbn.t232 21.1705
R223 vbn.t246 vbn.t239 21.1705
R224 vbn.t253 vbn.t246 21.1705
R225 vbn.t260 vbn.t253 21.1705
R226 vbn.t267 vbn.t260 21.1705
R227 vbn.t274 vbn.t267 21.1705
R228 vbn.t281 vbn.t274 21.1705
R229 vbn.t288 vbn.t281 21.1705
R230 vbn.t295 vbn.t288 21.1705
R231 vbn.t302 vbn.t295 21.1705
R232 vbn.t309 vbn.t302 21.1705
R233 vbn.t316 vbn.t309 21.1705
R234 vbn.t30 vbn.t316 21.1705
R235 vbn.t240 vbn.t233 21.1705
R236 vbn.t247 vbn.t240 21.1705
R237 vbn.t254 vbn.t247 21.1705
R238 vbn.t261 vbn.t254 21.1705
R239 vbn.t268 vbn.t261 21.1705
R240 vbn.t275 vbn.t268 21.1705
R241 vbn.t282 vbn.t275 21.1705
R242 vbn.t289 vbn.t282 21.1705
R243 vbn.t296 vbn.t289 21.1705
R244 vbn.t303 vbn.t296 21.1705
R245 vbn.t310 vbn.t303 21.1705
R246 vbn.t317 vbn.t310 21.1705
R247 vbn.t28 vbn.t317 21.1705
R248 vbn.t241 vbn.t234 21.1705
R249 vbn.t248 vbn.t241 21.1705
R250 vbn.t255 vbn.t248 21.1705
R251 vbn.t262 vbn.t255 21.1705
R252 vbn.t269 vbn.t262 21.1705
R253 vbn.t276 vbn.t269 21.1705
R254 vbn.t283 vbn.t276 21.1705
R255 vbn.t290 vbn.t283 21.1705
R256 vbn.t297 vbn.t290 21.1705
R257 vbn.t304 vbn.t297 21.1705
R258 vbn.t311 vbn.t304 21.1705
R259 vbn.t318 vbn.t311 21.1705
R260 vbn.t26 vbn.t318 21.1705
R261 vbn.t242 vbn.t235 21.1705
R262 vbn.t249 vbn.t242 21.1705
R263 vbn.t256 vbn.t249 21.1705
R264 vbn.t263 vbn.t256 21.1705
R265 vbn.t270 vbn.t263 21.1705
R266 vbn.t277 vbn.t270 21.1705
R267 vbn.t284 vbn.t277 21.1705
R268 vbn.t291 vbn.t284 21.1705
R269 vbn.t298 vbn.t291 21.1705
R270 vbn.t305 vbn.t298 21.1705
R271 vbn.t312 vbn.t305 21.1705
R272 vbn.t319 vbn.t312 21.1705
R273 vbn.t24 vbn.t319 21.1705
R274 vbn.t243 vbn.t236 21.1705
R275 vbn.t250 vbn.t243 21.1705
R276 vbn.t257 vbn.t250 21.1705
R277 vbn.t264 vbn.t257 21.1705
R278 vbn.t271 vbn.t264 21.1705
R279 vbn.t278 vbn.t271 21.1705
R280 vbn.t285 vbn.t278 21.1705
R281 vbn.t292 vbn.t285 21.1705
R282 vbn.t299 vbn.t292 21.1705
R283 vbn.t306 vbn.t299 21.1705
R284 vbn.t313 vbn.t306 21.1705
R285 vbn.t320 vbn.t313 21.1705
R286 vbn.t22 vbn.t320 21.1705
R287 vbn.t244 vbn.t237 21.1705
R288 vbn.t251 vbn.t244 21.1705
R289 vbn.t258 vbn.t251 21.1705
R290 vbn.t265 vbn.t258 21.1705
R291 vbn.t272 vbn.t265 21.1705
R292 vbn.t279 vbn.t272 21.1705
R293 vbn.t286 vbn.t279 21.1705
R294 vbn.t293 vbn.t286 21.1705
R295 vbn.t300 vbn.t293 21.1705
R296 vbn.t307 vbn.t300 21.1705
R297 vbn.t314 vbn.t307 21.1705
R298 vbn.t321 vbn.t314 21.1705
R299 vbn.t20 vbn.t321 21.1705
R300 vbn.t350 vbn.t322 21.1705
R301 vbn.t378 vbn.t350 21.1705
R302 vbn.t406 vbn.t378 21.1705
R303 vbn.t434 vbn.t406 21.1705
R304 vbn.t462 vbn.t434 21.1705
R305 vbn.t490 vbn.t462 21.1705
R306 vbn.t518 vbn.t490 21.1705
R307 vbn.t546 vbn.t518 21.1705
R308 vbn.t574 vbn.t546 21.1705
R309 vbn.t602 vbn.t574 21.1705
R310 vbn.t630 vbn.t602 21.1705
R311 vbn.t658 vbn.t630 21.1705
R312 vbn.t686 vbn.t658 21.1705
R313 vbn.t351 vbn.t323 21.1705
R314 vbn.t379 vbn.t351 21.1705
R315 vbn.t407 vbn.t379 21.1705
R316 vbn.t435 vbn.t407 21.1705
R317 vbn.t463 vbn.t435 21.1705
R318 vbn.t491 vbn.t463 21.1705
R319 vbn.t519 vbn.t491 21.1705
R320 vbn.t547 vbn.t519 21.1705
R321 vbn.t575 vbn.t547 21.1705
R322 vbn.t603 vbn.t575 21.1705
R323 vbn.t631 vbn.t603 21.1705
R324 vbn.t659 vbn.t631 21.1705
R325 vbn.t687 vbn.t659 21.1705
R326 vbn.t352 vbn.t324 21.1705
R327 vbn.t380 vbn.t352 21.1705
R328 vbn.t408 vbn.t380 21.1705
R329 vbn.t436 vbn.t408 21.1705
R330 vbn.t464 vbn.t436 21.1705
R331 vbn.t492 vbn.t464 21.1705
R332 vbn.t520 vbn.t492 21.1705
R333 vbn.t548 vbn.t520 21.1705
R334 vbn.t576 vbn.t548 21.1705
R335 vbn.t604 vbn.t576 21.1705
R336 vbn.t632 vbn.t604 21.1705
R337 vbn.t660 vbn.t632 21.1705
R338 vbn.t688 vbn.t660 21.1705
R339 vbn.t353 vbn.t325 21.1705
R340 vbn.t381 vbn.t353 21.1705
R341 vbn.t409 vbn.t381 21.1705
R342 vbn.t437 vbn.t409 21.1705
R343 vbn.t465 vbn.t437 21.1705
R344 vbn.t493 vbn.t465 21.1705
R345 vbn.t521 vbn.t493 21.1705
R346 vbn.t549 vbn.t521 21.1705
R347 vbn.t577 vbn.t549 21.1705
R348 vbn.t605 vbn.t577 21.1705
R349 vbn.t633 vbn.t605 21.1705
R350 vbn.t661 vbn.t633 21.1705
R351 vbn.t689 vbn.t661 21.1705
R352 vbn.t354 vbn.t326 21.1705
R353 vbn.t382 vbn.t354 21.1705
R354 vbn.t410 vbn.t382 21.1705
R355 vbn.t438 vbn.t410 21.1705
R356 vbn.t466 vbn.t438 21.1705
R357 vbn.t494 vbn.t466 21.1705
R358 vbn.t522 vbn.t494 21.1705
R359 vbn.t550 vbn.t522 21.1705
R360 vbn.t578 vbn.t550 21.1705
R361 vbn.t606 vbn.t578 21.1705
R362 vbn.t634 vbn.t606 21.1705
R363 vbn.t662 vbn.t634 21.1705
R364 vbn.t690 vbn.t662 21.1705
R365 vbn.t355 vbn.t327 21.1705
R366 vbn.t383 vbn.t355 21.1705
R367 vbn.t411 vbn.t383 21.1705
R368 vbn.t439 vbn.t411 21.1705
R369 vbn.t467 vbn.t439 21.1705
R370 vbn.t495 vbn.t467 21.1705
R371 vbn.t523 vbn.t495 21.1705
R372 vbn.t551 vbn.t523 21.1705
R373 vbn.t579 vbn.t551 21.1705
R374 vbn.t607 vbn.t579 21.1705
R375 vbn.t635 vbn.t607 21.1705
R376 vbn.t663 vbn.t635 21.1705
R377 vbn.t691 vbn.t663 21.1705
R378 vbn.t356 vbn.t328 21.1705
R379 vbn.t384 vbn.t356 21.1705
R380 vbn.t412 vbn.t384 21.1705
R381 vbn.t440 vbn.t412 21.1705
R382 vbn.t468 vbn.t440 21.1705
R383 vbn.t496 vbn.t468 21.1705
R384 vbn.t524 vbn.t496 21.1705
R385 vbn.t552 vbn.t524 21.1705
R386 vbn.t580 vbn.t552 21.1705
R387 vbn.t608 vbn.t580 21.1705
R388 vbn.t636 vbn.t608 21.1705
R389 vbn.t664 vbn.t636 21.1705
R390 vbn.t692 vbn.t664 21.1705
R391 vbn.t357 vbn.t329 21.1705
R392 vbn.t385 vbn.t357 21.1705
R393 vbn.t413 vbn.t385 21.1705
R394 vbn.t441 vbn.t413 21.1705
R395 vbn.t469 vbn.t441 21.1705
R396 vbn.t497 vbn.t469 21.1705
R397 vbn.t525 vbn.t497 21.1705
R398 vbn.t553 vbn.t525 21.1705
R399 vbn.t581 vbn.t553 21.1705
R400 vbn.t609 vbn.t581 21.1705
R401 vbn.t637 vbn.t609 21.1705
R402 vbn.t665 vbn.t637 21.1705
R403 vbn.t693 vbn.t665 21.1705
R404 vbn.t358 vbn.t330 21.1705
R405 vbn.t386 vbn.t358 21.1705
R406 vbn.t414 vbn.t386 21.1705
R407 vbn.t442 vbn.t414 21.1705
R408 vbn.t470 vbn.t442 21.1705
R409 vbn.t498 vbn.t470 21.1705
R410 vbn.t526 vbn.t498 21.1705
R411 vbn.t554 vbn.t526 21.1705
R412 vbn.t582 vbn.t554 21.1705
R413 vbn.t610 vbn.t582 21.1705
R414 vbn.t638 vbn.t610 21.1705
R415 vbn.t666 vbn.t638 21.1705
R416 vbn.t694 vbn.t666 21.1705
R417 vbn.t359 vbn.t331 21.1705
R418 vbn.t387 vbn.t359 21.1705
R419 vbn.t415 vbn.t387 21.1705
R420 vbn.t443 vbn.t415 21.1705
R421 vbn.t471 vbn.t443 21.1705
R422 vbn.t499 vbn.t471 21.1705
R423 vbn.t527 vbn.t499 21.1705
R424 vbn.t555 vbn.t527 21.1705
R425 vbn.t583 vbn.t555 21.1705
R426 vbn.t611 vbn.t583 21.1705
R427 vbn.t639 vbn.t611 21.1705
R428 vbn.t667 vbn.t639 21.1705
R429 vbn.t695 vbn.t667 21.1705
R430 vbn.t360 vbn.t332 21.1705
R431 vbn.t388 vbn.t360 21.1705
R432 vbn.t416 vbn.t388 21.1705
R433 vbn.t444 vbn.t416 21.1705
R434 vbn.t472 vbn.t444 21.1705
R435 vbn.t500 vbn.t472 21.1705
R436 vbn.t528 vbn.t500 21.1705
R437 vbn.t556 vbn.t528 21.1705
R438 vbn.t584 vbn.t556 21.1705
R439 vbn.t612 vbn.t584 21.1705
R440 vbn.t640 vbn.t612 21.1705
R441 vbn.t668 vbn.t640 21.1705
R442 vbn.t696 vbn.t668 21.1705
R443 vbn.t361 vbn.t333 21.1705
R444 vbn.t389 vbn.t361 21.1705
R445 vbn.t417 vbn.t389 21.1705
R446 vbn.t445 vbn.t417 21.1705
R447 vbn.t473 vbn.t445 21.1705
R448 vbn.t501 vbn.t473 21.1705
R449 vbn.t529 vbn.t501 21.1705
R450 vbn.t557 vbn.t529 21.1705
R451 vbn.t585 vbn.t557 21.1705
R452 vbn.t613 vbn.t585 21.1705
R453 vbn.t641 vbn.t613 21.1705
R454 vbn.t669 vbn.t641 21.1705
R455 vbn.t697 vbn.t669 21.1705
R456 vbn.t362 vbn.t334 21.1705
R457 vbn.t390 vbn.t362 21.1705
R458 vbn.t418 vbn.t390 21.1705
R459 vbn.t446 vbn.t418 21.1705
R460 vbn.t474 vbn.t446 21.1705
R461 vbn.t502 vbn.t474 21.1705
R462 vbn.t530 vbn.t502 21.1705
R463 vbn.t558 vbn.t530 21.1705
R464 vbn.t586 vbn.t558 21.1705
R465 vbn.t614 vbn.t586 21.1705
R466 vbn.t642 vbn.t614 21.1705
R467 vbn.t670 vbn.t642 21.1705
R468 vbn.t698 vbn.t670 21.1705
R469 vbn.t363 vbn.t335 21.1705
R470 vbn.t391 vbn.t363 21.1705
R471 vbn.t419 vbn.t391 21.1705
R472 vbn.t447 vbn.t419 21.1705
R473 vbn.t475 vbn.t447 21.1705
R474 vbn.t503 vbn.t475 21.1705
R475 vbn.t531 vbn.t503 21.1705
R476 vbn.t559 vbn.t531 21.1705
R477 vbn.t587 vbn.t559 21.1705
R478 vbn.t615 vbn.t587 21.1705
R479 vbn.t643 vbn.t615 21.1705
R480 vbn.t671 vbn.t643 21.1705
R481 vbn.t699 vbn.t671 21.1705
R482 vbn.t364 vbn.t336 21.1705
R483 vbn.t392 vbn.t364 21.1705
R484 vbn.t420 vbn.t392 21.1705
R485 vbn.t448 vbn.t420 21.1705
R486 vbn.t476 vbn.t448 21.1705
R487 vbn.t504 vbn.t476 21.1705
R488 vbn.t532 vbn.t504 21.1705
R489 vbn.t560 vbn.t532 21.1705
R490 vbn.t588 vbn.t560 21.1705
R491 vbn.t616 vbn.t588 21.1705
R492 vbn.t644 vbn.t616 21.1705
R493 vbn.t672 vbn.t644 21.1705
R494 vbn.t700 vbn.t672 21.1705
R495 vbn.t365 vbn.t337 21.1705
R496 vbn.t393 vbn.t365 21.1705
R497 vbn.t421 vbn.t393 21.1705
R498 vbn.t449 vbn.t421 21.1705
R499 vbn.t477 vbn.t449 21.1705
R500 vbn.t505 vbn.t477 21.1705
R501 vbn.t533 vbn.t505 21.1705
R502 vbn.t561 vbn.t533 21.1705
R503 vbn.t589 vbn.t561 21.1705
R504 vbn.t617 vbn.t589 21.1705
R505 vbn.t645 vbn.t617 21.1705
R506 vbn.t673 vbn.t645 21.1705
R507 vbn.t701 vbn.t673 21.1705
R508 vbn.t366 vbn.t338 21.1705
R509 vbn.t394 vbn.t366 21.1705
R510 vbn.t422 vbn.t394 21.1705
R511 vbn.t450 vbn.t422 21.1705
R512 vbn.t478 vbn.t450 21.1705
R513 vbn.t506 vbn.t478 21.1705
R514 vbn.t534 vbn.t506 21.1705
R515 vbn.t562 vbn.t534 21.1705
R516 vbn.t590 vbn.t562 21.1705
R517 vbn.t618 vbn.t590 21.1705
R518 vbn.t646 vbn.t618 21.1705
R519 vbn.t674 vbn.t646 21.1705
R520 vbn.t702 vbn.t674 21.1705
R521 vbn.t367 vbn.t339 21.1705
R522 vbn.t395 vbn.t367 21.1705
R523 vbn.t423 vbn.t395 21.1705
R524 vbn.t451 vbn.t423 21.1705
R525 vbn.t479 vbn.t451 21.1705
R526 vbn.t507 vbn.t479 21.1705
R527 vbn.t535 vbn.t507 21.1705
R528 vbn.t563 vbn.t535 21.1705
R529 vbn.t591 vbn.t563 21.1705
R530 vbn.t619 vbn.t591 21.1705
R531 vbn.t647 vbn.t619 21.1705
R532 vbn.t675 vbn.t647 21.1705
R533 vbn.t703 vbn.t675 21.1705
R534 vbn.t368 vbn.t340 21.1705
R535 vbn.t396 vbn.t368 21.1705
R536 vbn.t424 vbn.t396 21.1705
R537 vbn.t452 vbn.t424 21.1705
R538 vbn.t480 vbn.t452 21.1705
R539 vbn.t508 vbn.t480 21.1705
R540 vbn.t536 vbn.t508 21.1705
R541 vbn.t564 vbn.t536 21.1705
R542 vbn.t592 vbn.t564 21.1705
R543 vbn.t620 vbn.t592 21.1705
R544 vbn.t648 vbn.t620 21.1705
R545 vbn.t676 vbn.t648 21.1705
R546 vbn.t704 vbn.t676 21.1705
R547 vbn.t369 vbn.t341 21.1705
R548 vbn.t397 vbn.t369 21.1705
R549 vbn.t425 vbn.t397 21.1705
R550 vbn.t453 vbn.t425 21.1705
R551 vbn.t481 vbn.t453 21.1705
R552 vbn.t509 vbn.t481 21.1705
R553 vbn.t537 vbn.t509 21.1705
R554 vbn.t565 vbn.t537 21.1705
R555 vbn.t593 vbn.t565 21.1705
R556 vbn.t621 vbn.t593 21.1705
R557 vbn.t649 vbn.t621 21.1705
R558 vbn.t677 vbn.t649 21.1705
R559 vbn.t705 vbn.t677 21.1705
R560 vbn.t370 vbn.t342 21.1705
R561 vbn.t398 vbn.t370 21.1705
R562 vbn.t426 vbn.t398 21.1705
R563 vbn.t454 vbn.t426 21.1705
R564 vbn.t482 vbn.t454 21.1705
R565 vbn.t510 vbn.t482 21.1705
R566 vbn.t538 vbn.t510 21.1705
R567 vbn.t566 vbn.t538 21.1705
R568 vbn.t594 vbn.t566 21.1705
R569 vbn.t622 vbn.t594 21.1705
R570 vbn.t650 vbn.t622 21.1705
R571 vbn.t678 vbn.t650 21.1705
R572 vbn.t706 vbn.t678 21.1705
R573 vbn.t371 vbn.t343 21.1705
R574 vbn.t399 vbn.t371 21.1705
R575 vbn.t427 vbn.t399 21.1705
R576 vbn.t455 vbn.t427 21.1705
R577 vbn.t483 vbn.t455 21.1705
R578 vbn.t511 vbn.t483 21.1705
R579 vbn.t539 vbn.t511 21.1705
R580 vbn.t567 vbn.t539 21.1705
R581 vbn.t595 vbn.t567 21.1705
R582 vbn.t623 vbn.t595 21.1705
R583 vbn.t651 vbn.t623 21.1705
R584 vbn.t679 vbn.t651 21.1705
R585 vbn.t707 vbn.t679 21.1705
R586 vbn.t372 vbn.t344 21.1705
R587 vbn.t400 vbn.t372 21.1705
R588 vbn.t428 vbn.t400 21.1705
R589 vbn.t456 vbn.t428 21.1705
R590 vbn.t484 vbn.t456 21.1705
R591 vbn.t512 vbn.t484 21.1705
R592 vbn.t540 vbn.t512 21.1705
R593 vbn.t568 vbn.t540 21.1705
R594 vbn.t596 vbn.t568 21.1705
R595 vbn.t624 vbn.t596 21.1705
R596 vbn.t652 vbn.t624 21.1705
R597 vbn.t680 vbn.t652 21.1705
R598 vbn.t708 vbn.t680 21.1705
R599 vbn.t373 vbn.t345 21.1705
R600 vbn.t401 vbn.t373 21.1705
R601 vbn.t429 vbn.t401 21.1705
R602 vbn.t457 vbn.t429 21.1705
R603 vbn.t485 vbn.t457 21.1705
R604 vbn.t513 vbn.t485 21.1705
R605 vbn.t541 vbn.t513 21.1705
R606 vbn.t569 vbn.t541 21.1705
R607 vbn.t597 vbn.t569 21.1705
R608 vbn.t625 vbn.t597 21.1705
R609 vbn.t653 vbn.t625 21.1705
R610 vbn.t681 vbn.t653 21.1705
R611 vbn.t709 vbn.t681 21.1705
R612 vbn.t374 vbn.t346 21.1705
R613 vbn.t402 vbn.t374 21.1705
R614 vbn.t430 vbn.t402 21.1705
R615 vbn.t458 vbn.t430 21.1705
R616 vbn.t486 vbn.t458 21.1705
R617 vbn.t514 vbn.t486 21.1705
R618 vbn.t542 vbn.t514 21.1705
R619 vbn.t570 vbn.t542 21.1705
R620 vbn.t598 vbn.t570 21.1705
R621 vbn.t626 vbn.t598 21.1705
R622 vbn.t654 vbn.t626 21.1705
R623 vbn.t682 vbn.t654 21.1705
R624 vbn.t710 vbn.t682 21.1705
R625 vbn.t375 vbn.t347 21.1705
R626 vbn.t403 vbn.t375 21.1705
R627 vbn.t431 vbn.t403 21.1705
R628 vbn.t459 vbn.t431 21.1705
R629 vbn.t487 vbn.t459 21.1705
R630 vbn.t515 vbn.t487 21.1705
R631 vbn.t543 vbn.t515 21.1705
R632 vbn.t571 vbn.t543 21.1705
R633 vbn.t599 vbn.t571 21.1705
R634 vbn.t627 vbn.t599 21.1705
R635 vbn.t655 vbn.t627 21.1705
R636 vbn.t683 vbn.t655 21.1705
R637 vbn.t711 vbn.t683 21.1705
R638 vbn.t376 vbn.t348 21.1705
R639 vbn.t404 vbn.t376 21.1705
R640 vbn.t432 vbn.t404 21.1705
R641 vbn.t460 vbn.t432 21.1705
R642 vbn.t488 vbn.t460 21.1705
R643 vbn.t516 vbn.t488 21.1705
R644 vbn.t544 vbn.t516 21.1705
R645 vbn.t572 vbn.t544 21.1705
R646 vbn.t600 vbn.t572 21.1705
R647 vbn.t628 vbn.t600 21.1705
R648 vbn.t656 vbn.t628 21.1705
R649 vbn.t684 vbn.t656 21.1705
R650 vbn.t712 vbn.t684 21.1705
R651 vbn.t377 vbn.t349 21.1705
R652 vbn.t405 vbn.t377 21.1705
R653 vbn.t433 vbn.t405 21.1705
R654 vbn.t461 vbn.t433 21.1705
R655 vbn.t489 vbn.t461 21.1705
R656 vbn.t517 vbn.t489 21.1705
R657 vbn.t545 vbn.t517 21.1705
R658 vbn.t573 vbn.t545 21.1705
R659 vbn.t601 vbn.t573 21.1705
R660 vbn.t629 vbn.t601 21.1705
R661 vbn.t657 vbn.t629 21.1705
R662 vbn.t685 vbn.t657 21.1705
R663 vbn.t713 vbn.t685 21.1705
R664 vbn.t721 vbn.t714 21.1705
R665 vbn.t728 vbn.t721 21.1705
R666 vbn.t735 vbn.t728 21.1705
R667 vbn.t742 vbn.t735 21.1705
R668 vbn.t749 vbn.t742 21.1705
R669 vbn.t756 vbn.t749 21.1705
R670 vbn.t763 vbn.t756 21.1705
R671 vbn.t770 vbn.t763 21.1705
R672 vbn.t777 vbn.t770 21.1705
R673 vbn.t784 vbn.t777 21.1705
R674 vbn.t791 vbn.t784 21.1705
R675 vbn.t798 vbn.t791 21.1705
R676 vbn.t18 vbn.t798 21.1705
R677 vbn.t722 vbn.t715 21.1705
R678 vbn.t729 vbn.t722 21.1705
R679 vbn.t736 vbn.t729 21.1705
R680 vbn.t743 vbn.t736 21.1705
R681 vbn.t750 vbn.t743 21.1705
R682 vbn.t757 vbn.t750 21.1705
R683 vbn.t764 vbn.t757 21.1705
R684 vbn.t771 vbn.t764 21.1705
R685 vbn.t778 vbn.t771 21.1705
R686 vbn.t785 vbn.t778 21.1705
R687 vbn.t792 vbn.t785 21.1705
R688 vbn.t799 vbn.t792 21.1705
R689 vbn.t16 vbn.t799 21.1705
R690 vbn.t723 vbn.t716 21.1705
R691 vbn.t730 vbn.t723 21.1705
R692 vbn.t737 vbn.t730 21.1705
R693 vbn.t744 vbn.t737 21.1705
R694 vbn.t751 vbn.t744 21.1705
R695 vbn.t758 vbn.t751 21.1705
R696 vbn.t765 vbn.t758 21.1705
R697 vbn.t772 vbn.t765 21.1705
R698 vbn.t779 vbn.t772 21.1705
R699 vbn.t786 vbn.t779 21.1705
R700 vbn.t793 vbn.t786 21.1705
R701 vbn.t800 vbn.t793 21.1705
R702 vbn.t14 vbn.t800 21.1705
R703 vbn.t724 vbn.t717 21.1705
R704 vbn.t731 vbn.t724 21.1705
R705 vbn.t738 vbn.t731 21.1705
R706 vbn.t745 vbn.t738 21.1705
R707 vbn.t752 vbn.t745 21.1705
R708 vbn.t759 vbn.t752 21.1705
R709 vbn.t766 vbn.t759 21.1705
R710 vbn.t773 vbn.t766 21.1705
R711 vbn.t780 vbn.t773 21.1705
R712 vbn.t787 vbn.t780 21.1705
R713 vbn.t794 vbn.t787 21.1705
R714 vbn.t801 vbn.t794 21.1705
R715 vbn.t12 vbn.t801 21.1705
R716 vbn.t725 vbn.t718 21.1705
R717 vbn.t732 vbn.t725 21.1705
R718 vbn.t739 vbn.t732 21.1705
R719 vbn.t746 vbn.t739 21.1705
R720 vbn.t753 vbn.t746 21.1705
R721 vbn.t760 vbn.t753 21.1705
R722 vbn.t767 vbn.t760 21.1705
R723 vbn.t774 vbn.t767 21.1705
R724 vbn.t781 vbn.t774 21.1705
R725 vbn.t788 vbn.t781 21.1705
R726 vbn.t795 vbn.t788 21.1705
R727 vbn.t802 vbn.t795 21.1705
R728 vbn.t10 vbn.t802 21.1705
R729 vbn.t726 vbn.t719 21.1705
R730 vbn.t733 vbn.t726 21.1705
R731 vbn.t740 vbn.t733 21.1705
R732 vbn.t747 vbn.t740 21.1705
R733 vbn.t754 vbn.t747 21.1705
R734 vbn.t761 vbn.t754 21.1705
R735 vbn.t768 vbn.t761 21.1705
R736 vbn.t775 vbn.t768 21.1705
R737 vbn.t782 vbn.t775 21.1705
R738 vbn.t789 vbn.t782 21.1705
R739 vbn.t796 vbn.t789 21.1705
R740 vbn.t803 vbn.t796 21.1705
R741 vbn.t8 vbn.t803 21.1705
R742 vbn.t727 vbn.t720 21.1705
R743 vbn.t734 vbn.t727 21.1705
R744 vbn.t741 vbn.t734 21.1705
R745 vbn.t748 vbn.t741 21.1705
R746 vbn.t755 vbn.t748 21.1705
R747 vbn.t762 vbn.t755 21.1705
R748 vbn.t769 vbn.t762 21.1705
R749 vbn.t776 vbn.t769 21.1705
R750 vbn.t783 vbn.t776 21.1705
R751 vbn.t790 vbn.t783 21.1705
R752 vbn.t797 vbn.t790 21.1705
R753 vbn.t804 vbn.t797 21.1705
R754 vbn.t6 vbn.t804 21.1705
R755 vbn.t819 vbn.t805 21.1705
R756 vbn.t833 vbn.t819 21.1705
R757 vbn.t847 vbn.t833 21.1705
R758 vbn.t861 vbn.t847 21.1705
R759 vbn.t875 vbn.t861 21.1705
R760 vbn.t889 vbn.t875 21.1705
R761 vbn.t903 vbn.t889 21.1705
R762 vbn.t917 vbn.t903 21.1705
R763 vbn.t931 vbn.t917 21.1705
R764 vbn.t945 vbn.t931 21.1705
R765 vbn.t959 vbn.t945 21.1705
R766 vbn.t973 vbn.t959 21.1705
R767 vbn.t987 vbn.t973 21.1705
R768 vbn.t820 vbn.t806 21.1705
R769 vbn.t834 vbn.t820 21.1705
R770 vbn.t848 vbn.t834 21.1705
R771 vbn.t862 vbn.t848 21.1705
R772 vbn.t876 vbn.t862 21.1705
R773 vbn.t890 vbn.t876 21.1705
R774 vbn.t904 vbn.t890 21.1705
R775 vbn.t918 vbn.t904 21.1705
R776 vbn.t932 vbn.t918 21.1705
R777 vbn.t946 vbn.t932 21.1705
R778 vbn.t960 vbn.t946 21.1705
R779 vbn.t974 vbn.t960 21.1705
R780 vbn.t988 vbn.t974 21.1705
R781 vbn.t821 vbn.t807 21.1705
R782 vbn.t835 vbn.t821 21.1705
R783 vbn.t849 vbn.t835 21.1705
R784 vbn.t863 vbn.t849 21.1705
R785 vbn.t877 vbn.t863 21.1705
R786 vbn.t891 vbn.t877 21.1705
R787 vbn.t905 vbn.t891 21.1705
R788 vbn.t919 vbn.t905 21.1705
R789 vbn.t933 vbn.t919 21.1705
R790 vbn.t947 vbn.t933 21.1705
R791 vbn.t961 vbn.t947 21.1705
R792 vbn.t975 vbn.t961 21.1705
R793 vbn.t989 vbn.t975 21.1705
R794 vbn.t822 vbn.t808 21.1705
R795 vbn.t836 vbn.t822 21.1705
R796 vbn.t850 vbn.t836 21.1705
R797 vbn.t864 vbn.t850 21.1705
R798 vbn.t878 vbn.t864 21.1705
R799 vbn.t892 vbn.t878 21.1705
R800 vbn.t906 vbn.t892 21.1705
R801 vbn.t920 vbn.t906 21.1705
R802 vbn.t934 vbn.t920 21.1705
R803 vbn.t948 vbn.t934 21.1705
R804 vbn.t962 vbn.t948 21.1705
R805 vbn.t976 vbn.t962 21.1705
R806 vbn.t990 vbn.t976 21.1705
R807 vbn.t823 vbn.t809 21.1705
R808 vbn.t837 vbn.t823 21.1705
R809 vbn.t851 vbn.t837 21.1705
R810 vbn.t865 vbn.t851 21.1705
R811 vbn.t879 vbn.t865 21.1705
R812 vbn.t893 vbn.t879 21.1705
R813 vbn.t907 vbn.t893 21.1705
R814 vbn.t921 vbn.t907 21.1705
R815 vbn.t935 vbn.t921 21.1705
R816 vbn.t949 vbn.t935 21.1705
R817 vbn.t963 vbn.t949 21.1705
R818 vbn.t977 vbn.t963 21.1705
R819 vbn.t991 vbn.t977 21.1705
R820 vbn.t824 vbn.t810 21.1705
R821 vbn.t838 vbn.t824 21.1705
R822 vbn.t852 vbn.t838 21.1705
R823 vbn.t866 vbn.t852 21.1705
R824 vbn.t880 vbn.t866 21.1705
R825 vbn.t894 vbn.t880 21.1705
R826 vbn.t908 vbn.t894 21.1705
R827 vbn.t922 vbn.t908 21.1705
R828 vbn.t936 vbn.t922 21.1705
R829 vbn.t950 vbn.t936 21.1705
R830 vbn.t964 vbn.t950 21.1705
R831 vbn.t978 vbn.t964 21.1705
R832 vbn.t992 vbn.t978 21.1705
R833 vbn.t825 vbn.t811 21.1705
R834 vbn.t839 vbn.t825 21.1705
R835 vbn.t853 vbn.t839 21.1705
R836 vbn.t867 vbn.t853 21.1705
R837 vbn.t881 vbn.t867 21.1705
R838 vbn.t895 vbn.t881 21.1705
R839 vbn.t909 vbn.t895 21.1705
R840 vbn.t923 vbn.t909 21.1705
R841 vbn.t937 vbn.t923 21.1705
R842 vbn.t951 vbn.t937 21.1705
R843 vbn.t965 vbn.t951 21.1705
R844 vbn.t979 vbn.t965 21.1705
R845 vbn.t993 vbn.t979 21.1705
R846 vbn.t826 vbn.t812 21.1705
R847 vbn.t840 vbn.t826 21.1705
R848 vbn.t854 vbn.t840 21.1705
R849 vbn.t868 vbn.t854 21.1705
R850 vbn.t882 vbn.t868 21.1705
R851 vbn.t896 vbn.t882 21.1705
R852 vbn.t910 vbn.t896 21.1705
R853 vbn.t924 vbn.t910 21.1705
R854 vbn.t938 vbn.t924 21.1705
R855 vbn.t952 vbn.t938 21.1705
R856 vbn.t966 vbn.t952 21.1705
R857 vbn.t980 vbn.t966 21.1705
R858 vbn.t994 vbn.t980 21.1705
R859 vbn.t827 vbn.t813 21.1705
R860 vbn.t841 vbn.t827 21.1705
R861 vbn.t855 vbn.t841 21.1705
R862 vbn.t869 vbn.t855 21.1705
R863 vbn.t883 vbn.t869 21.1705
R864 vbn.t897 vbn.t883 21.1705
R865 vbn.t911 vbn.t897 21.1705
R866 vbn.t925 vbn.t911 21.1705
R867 vbn.t939 vbn.t925 21.1705
R868 vbn.t953 vbn.t939 21.1705
R869 vbn.t967 vbn.t953 21.1705
R870 vbn.t981 vbn.t967 21.1705
R871 vbn.t995 vbn.t981 21.1705
R872 vbn.t828 vbn.t814 21.1705
R873 vbn.t842 vbn.t828 21.1705
R874 vbn.t856 vbn.t842 21.1705
R875 vbn.t870 vbn.t856 21.1705
R876 vbn.t884 vbn.t870 21.1705
R877 vbn.t898 vbn.t884 21.1705
R878 vbn.t912 vbn.t898 21.1705
R879 vbn.t926 vbn.t912 21.1705
R880 vbn.t940 vbn.t926 21.1705
R881 vbn.t954 vbn.t940 21.1705
R882 vbn.t968 vbn.t954 21.1705
R883 vbn.t982 vbn.t968 21.1705
R884 vbn.t996 vbn.t982 21.1705
R885 vbn.t829 vbn.t815 21.1705
R886 vbn.t843 vbn.t829 21.1705
R887 vbn.t857 vbn.t843 21.1705
R888 vbn.t871 vbn.t857 21.1705
R889 vbn.t885 vbn.t871 21.1705
R890 vbn.t899 vbn.t885 21.1705
R891 vbn.t913 vbn.t899 21.1705
R892 vbn.t927 vbn.t913 21.1705
R893 vbn.t941 vbn.t927 21.1705
R894 vbn.t955 vbn.t941 21.1705
R895 vbn.t969 vbn.t955 21.1705
R896 vbn.t983 vbn.t969 21.1705
R897 vbn.t997 vbn.t983 21.1705
R898 vbn.t830 vbn.t816 21.1705
R899 vbn.t844 vbn.t830 21.1705
R900 vbn.t858 vbn.t844 21.1705
R901 vbn.t872 vbn.t858 21.1705
R902 vbn.t886 vbn.t872 21.1705
R903 vbn.t900 vbn.t886 21.1705
R904 vbn.t914 vbn.t900 21.1705
R905 vbn.t928 vbn.t914 21.1705
R906 vbn.t942 vbn.t928 21.1705
R907 vbn.t956 vbn.t942 21.1705
R908 vbn.t970 vbn.t956 21.1705
R909 vbn.t984 vbn.t970 21.1705
R910 vbn.t998 vbn.t984 21.1705
R911 vbn.t831 vbn.t817 21.1705
R912 vbn.t845 vbn.t831 21.1705
R913 vbn.t859 vbn.t845 21.1705
R914 vbn.t873 vbn.t859 21.1705
R915 vbn.t887 vbn.t873 21.1705
R916 vbn.t901 vbn.t887 21.1705
R917 vbn.t915 vbn.t901 21.1705
R918 vbn.t929 vbn.t915 21.1705
R919 vbn.t943 vbn.t929 21.1705
R920 vbn.t957 vbn.t943 21.1705
R921 vbn.t971 vbn.t957 21.1705
R922 vbn.t985 vbn.t971 21.1705
R923 vbn.t999 vbn.t985 21.1705
R924 vbn.t832 vbn.t818 21.1705
R925 vbn.t846 vbn.t832 21.1705
R926 vbn.t860 vbn.t846 21.1705
R927 vbn.t874 vbn.t860 21.1705
R928 vbn.t888 vbn.t874 21.1705
R929 vbn.t902 vbn.t888 21.1705
R930 vbn.t916 vbn.t902 21.1705
R931 vbn.t930 vbn.t916 21.1705
R932 vbn.t944 vbn.t930 21.1705
R933 vbn.t958 vbn.t944 21.1705
R934 vbn.t972 vbn.t958 21.1705
R935 vbn.t986 vbn.t972 21.1705
R936 vbn.t1000 vbn.t986 21.1705
R937 vbn.n156 vbn.t217 15.0385
R938 vbn.n155 vbn.t218 15.0385
R939 vbn.n154 vbn.t219 15.0385
R940 vbn.n153 vbn.t220 15.0385
R941 vbn.n152 vbn.t221 15.0385
R942 vbn.n151 vbn.t222 15.0385
R943 vbn.n150 vbn.t223 15.0385
R944 vbn.n149 vbn.t224 15.0385
R945 vbn.n148 vbn.t225 15.0385
R946 vbn.n147 vbn.t226 15.0385
R947 vbn.n146 vbn.t227 15.0385
R948 vbn.n145 vbn.t228 15.0385
R949 vbn.n144 vbn.t229 15.0385
R950 vbn.n143 vbn.t230 15.0385
R951 vbn.n142 vbn.t32 15.0385
R952 vbn.n141 vbn.t30 15.0385
R953 vbn.n140 vbn.t28 15.0385
R954 vbn.n139 vbn.t26 15.0385
R955 vbn.n138 vbn.t24 15.0385
R956 vbn.n137 vbn.t22 15.0385
R957 vbn.n136 vbn.t20 15.0385
R958 vbn.n135 vbn.t686 15.0385
R959 vbn.n134 vbn.t687 15.0385
R960 vbn.n133 vbn.t688 15.0385
R961 vbn.n132 vbn.t689 15.0385
R962 vbn.n131 vbn.t690 15.0385
R963 vbn.n130 vbn.t691 15.0385
R964 vbn.n129 vbn.t692 15.0385
R965 vbn.n128 vbn.t693 15.0385
R966 vbn.n127 vbn.t694 15.0385
R967 vbn.n126 vbn.t695 15.0385
R968 vbn.n125 vbn.t696 15.0385
R969 vbn.n124 vbn.t697 15.0385
R970 vbn.n123 vbn.t698 15.0385
R971 vbn.n122 vbn.t699 15.0385
R972 vbn.n121 vbn.t700 15.0385
R973 vbn.n120 vbn.t701 15.0385
R974 vbn.n119 vbn.t702 15.0385
R975 vbn.n118 vbn.t703 15.0385
R976 vbn.n117 vbn.t704 15.0385
R977 vbn.n116 vbn.t705 15.0385
R978 vbn.n115 vbn.t706 15.0385
R979 vbn.n114 vbn.t707 15.0385
R980 vbn.n113 vbn.t708 15.0385
R981 vbn.n112 vbn.t709 15.0385
R982 vbn.n111 vbn.t710 15.0385
R983 vbn.n110 vbn.t711 15.0385
R984 vbn.n109 vbn.t712 15.0385
R985 vbn.n108 vbn.t713 15.0385
R986 vbn.n107 vbn.t18 15.0385
R987 vbn.n106 vbn.t16 15.0385
R988 vbn.n105 vbn.t14 15.0385
R989 vbn.n104 vbn.t12 15.0385
R990 vbn.n103 vbn.t10 15.0385
R991 vbn.n102 vbn.t8 15.0385
R992 vbn.n101 vbn.t6 15.0385
R993 vbn.n100 vbn.t987 15.0385
R994 vbn.n99 vbn.t988 15.0385
R995 vbn.n98 vbn.t989 15.0385
R996 vbn.n97 vbn.t990 15.0385
R997 vbn.n96 vbn.t991 15.0385
R998 vbn.n95 vbn.t992 15.0385
R999 vbn.n94 vbn.t993 15.0385
R1000 vbn.n93 vbn.t994 15.0385
R1001 vbn.n92 vbn.t995 15.0385
R1002 vbn.n91 vbn.t996 15.0385
R1003 vbn.n90 vbn.t997 15.0385
R1004 vbn.n89 vbn.t998 15.0385
R1005 vbn.n88 vbn.t999 15.0385
R1006 vbn.n87 vbn.t1000 15.0385
R1007 vbn.n9 vbn.n8 11.1598
R1008 vbn.n77 vbn.n76 11.1598
R1009 vbn.n156 vbn.n155 11.0491
R1010 vbn.n155 vbn.n154 11.0491
R1011 vbn.n154 vbn.n153 11.0491
R1012 vbn.n153 vbn.n152 11.0491
R1013 vbn.n152 vbn.n151 11.0491
R1014 vbn.n151 vbn.n150 11.0491
R1015 vbn.n150 vbn.n149 11.0491
R1016 vbn.n149 vbn.n148 11.0491
R1017 vbn.n148 vbn.n147 11.0491
R1018 vbn.n147 vbn.n146 11.0491
R1019 vbn.n146 vbn.n145 11.0491
R1020 vbn.n145 vbn.n144 11.0491
R1021 vbn.n144 vbn.n143 11.0491
R1022 vbn.n142 vbn.n141 11.0491
R1023 vbn.n141 vbn.n140 11.0491
R1024 vbn.n140 vbn.n139 11.0491
R1025 vbn.n139 vbn.n138 11.0491
R1026 vbn.n138 vbn.n137 11.0491
R1027 vbn.n137 vbn.n136 11.0491
R1028 vbn.n135 vbn.n134 11.0491
R1029 vbn.n134 vbn.n133 11.0491
R1030 vbn.n133 vbn.n132 11.0491
R1031 vbn.n132 vbn.n131 11.0491
R1032 vbn.n131 vbn.n130 11.0491
R1033 vbn.n130 vbn.n129 11.0491
R1034 vbn.n129 vbn.n128 11.0491
R1035 vbn.n128 vbn.n127 11.0491
R1036 vbn.n127 vbn.n126 11.0491
R1037 vbn.n126 vbn.n125 11.0491
R1038 vbn.n125 vbn.n124 11.0491
R1039 vbn.n124 vbn.n123 11.0491
R1040 vbn.n123 vbn.n122 11.0491
R1041 vbn.n122 vbn.n121 11.0491
R1042 vbn.n121 vbn.n120 11.0491
R1043 vbn.n120 vbn.n119 11.0491
R1044 vbn.n119 vbn.n118 11.0491
R1045 vbn.n118 vbn.n117 11.0491
R1046 vbn.n117 vbn.n116 11.0491
R1047 vbn.n116 vbn.n115 11.0491
R1048 vbn.n115 vbn.n114 11.0491
R1049 vbn.n114 vbn.n113 11.0491
R1050 vbn.n113 vbn.n112 11.0491
R1051 vbn.n112 vbn.n111 11.0491
R1052 vbn.n111 vbn.n110 11.0491
R1053 vbn.n110 vbn.n109 11.0491
R1054 vbn.n109 vbn.n108 11.0491
R1055 vbn.n107 vbn.n106 11.0491
R1056 vbn.n106 vbn.n105 11.0491
R1057 vbn.n105 vbn.n104 11.0491
R1058 vbn.n104 vbn.n103 11.0491
R1059 vbn.n103 vbn.n102 11.0491
R1060 vbn.n102 vbn.n101 11.0491
R1061 vbn.n100 vbn.n99 11.0491
R1062 vbn.n99 vbn.n98 11.0491
R1063 vbn.n98 vbn.n97 11.0491
R1064 vbn.n97 vbn.n96 11.0491
R1065 vbn.n96 vbn.n95 11.0491
R1066 vbn.n95 vbn.n94 11.0491
R1067 vbn.n94 vbn.n93 11.0491
R1068 vbn.n93 vbn.n92 11.0491
R1069 vbn.n92 vbn.n91 11.0491
R1070 vbn.n91 vbn.n90 11.0491
R1071 vbn.n90 vbn.n89 11.0491
R1072 vbn.n89 vbn.n88 11.0491
R1073 vbn.n88 vbn.n87 11.0491
R1074 vbn.n88 vbn.n85 8.0005
R1075 vbn.n89 vbn.n84 8.0005
R1076 vbn.n90 vbn.n83 8.0005
R1077 vbn.n91 vbn.n82 8.0005
R1078 vbn.n92 vbn.n81 8.0005
R1079 vbn.n93 vbn.n80 8.0005
R1080 vbn.n94 vbn.n79 8.0005
R1081 vbn.n95 vbn.n78 8.0005
R1082 vbn.n96 vbn.n75 8.0005
R1083 vbn.n97 vbn.n74 8.0005
R1084 vbn.n98 vbn.n73 8.0005
R1085 vbn.n99 vbn.n72 8.0005
R1086 vbn.n100 vbn.n71 8.0005
R1087 vbn.n101 vbn.n69 8.0005
R1088 vbn.n102 vbn.n68 8.0005
R1089 vbn.n103 vbn.n65 8.0005
R1090 vbn.n104 vbn.n64 8.0005
R1091 vbn.n105 vbn.n61 8.0005
R1092 vbn.n106 vbn.n60 8.0005
R1093 vbn.n107 vbn.n57 8.0005
R1094 vbn.n108 vbn.n56 8.0005
R1095 vbn.n109 vbn.n55 8.0005
R1096 vbn.n110 vbn.n54 8.0005
R1097 vbn.n111 vbn.n53 8.0005
R1098 vbn.n112 vbn.n52 8.0005
R1099 vbn.n113 vbn.n51 8.0005
R1100 vbn.n114 vbn.n50 8.0005
R1101 vbn.n115 vbn.n49 8.0005
R1102 vbn.n116 vbn.n48 8.0005
R1103 vbn.n117 vbn.n47 8.0005
R1104 vbn.n118 vbn.n46 8.0005
R1105 vbn.n119 vbn.n45 8.0005
R1106 vbn.n120 vbn.n44 8.0005
R1107 vbn.n121 vbn.n43 8.0005
R1108 vbn.n122 vbn.n42 8.0005
R1109 vbn.n123 vbn.n41 8.0005
R1110 vbn.n124 vbn.n40 8.0005
R1111 vbn.n125 vbn.n39 8.0005
R1112 vbn.n126 vbn.n38 8.0005
R1113 vbn.n127 vbn.n37 8.0005
R1114 vbn.n128 vbn.n36 8.0005
R1115 vbn.n129 vbn.n35 8.0005
R1116 vbn.n130 vbn.n34 8.0005
R1117 vbn.n131 vbn.n33 8.0005
R1118 vbn.n132 vbn.n32 8.0005
R1119 vbn.n133 vbn.n31 8.0005
R1120 vbn.n134 vbn.n30 8.0005
R1121 vbn.n135 vbn.n29 8.0005
R1122 vbn.n136 vbn.n27 8.0005
R1123 vbn.n137 vbn.n26 8.0005
R1124 vbn.n138 vbn.n23 8.0005
R1125 vbn.n139 vbn.n22 8.0005
R1126 vbn.n140 vbn.n19 8.0005
R1127 vbn.n141 vbn.n18 8.0005
R1128 vbn.n142 vbn.n15 8.0005
R1129 vbn.n143 vbn.n14 8.0005
R1130 vbn.n144 vbn.n13 8.0005
R1131 vbn.n145 vbn.n12 8.0005
R1132 vbn.n146 vbn.n11 8.0005
R1133 vbn.n147 vbn.n10 8.0005
R1134 vbn.n148 vbn.n7 8.0005
R1135 vbn.n149 vbn.n6 8.0005
R1136 vbn.n150 vbn.n5 8.0005
R1137 vbn.n151 vbn.n4 8.0005
R1138 vbn.n152 vbn.n3 8.0005
R1139 vbn.n153 vbn.n2 8.0005
R1140 vbn.n154 vbn.n1 8.0005
R1141 vbn.n155 vbn.n0 8.0005
R1142 vbn.n157 vbn.n156 5.56684
R1143 vbn.n87 vbn.n86 5.56684
R1144 vbn.n158 vbn.t0 5.15158
R1145 vbn.n159 vbn.n158 4.69589
R1146 vbn.n70 vbn.t7 2.70867
R1147 vbn.n28 vbn.t21 2.70867
R1148 vbn.n67 vbn.n66 1.87392
R1149 vbn.n63 vbn.n62 1.87392
R1150 vbn.n59 vbn.n58 1.87392
R1151 vbn.n25 vbn.n24 1.87392
R1152 vbn.n21 vbn.n20 1.87392
R1153 vbn.n17 vbn.n16 1.87392
R1154 vbn.n158 vbn.n157 0.967396
R1155 vbn.n66 vbn.t11 0.8825
R1156 vbn.n66 vbn.t9 0.8825
R1157 vbn.n62 vbn.t15 0.8825
R1158 vbn.n62 vbn.t13 0.8825
R1159 vbn.n58 vbn.t19 0.8825
R1160 vbn.n58 vbn.t17 0.8825
R1161 vbn.n24 vbn.t25 0.8825
R1162 vbn.n24 vbn.t23 0.8825
R1163 vbn.n20 vbn.t29 0.8825
R1164 vbn.n20 vbn.t27 0.8825
R1165 vbn.n16 vbn.t33 0.8825
R1166 vbn.n16 vbn.t31 0.8825
R1167 vbn.n57 vbn.n56 0.73471
R1168 vbn.n15 vbn.n14 0.73471
R1169 vbn vbn.n159 0.644711
R1170 vbn.n71 vbn.n70 0.525799
R1171 vbn.n29 vbn.n28 0.525799
R1172 vbn.n86 vbn.n85 0.47793
R1173 vbn.n157 vbn.n0 0.47793
R1174 vbn.n72 vbn.n71 0.369974
R1175 vbn.n73 vbn.n72 0.369974
R1176 vbn.n74 vbn.n73 0.369974
R1177 vbn.n75 vbn.n74 0.369974
R1178 vbn.n79 vbn.n78 0.369974
R1179 vbn.n80 vbn.n79 0.369974
R1180 vbn.n81 vbn.n80 0.369974
R1181 vbn.n82 vbn.n81 0.369974
R1182 vbn.n83 vbn.n82 0.369974
R1183 vbn.n84 vbn.n83 0.369974
R1184 vbn.n85 vbn.n84 0.369974
R1185 vbn.n30 vbn.n29 0.369974
R1186 vbn.n31 vbn.n30 0.369974
R1187 vbn.n32 vbn.n31 0.369974
R1188 vbn.n33 vbn.n32 0.369974
R1189 vbn.n34 vbn.n33 0.369974
R1190 vbn.n35 vbn.n34 0.369974
R1191 vbn.n36 vbn.n35 0.369974
R1192 vbn.n37 vbn.n36 0.369974
R1193 vbn.n38 vbn.n37 0.369974
R1194 vbn.n39 vbn.n38 0.369974
R1195 vbn.n40 vbn.n39 0.369974
R1196 vbn.n41 vbn.n40 0.369974
R1197 vbn.n42 vbn.n41 0.369974
R1198 vbn.n43 vbn.n42 0.369974
R1199 vbn.n44 vbn.n43 0.369974
R1200 vbn.n45 vbn.n44 0.369974
R1201 vbn.n46 vbn.n45 0.369974
R1202 vbn.n47 vbn.n46 0.369974
R1203 vbn.n48 vbn.n47 0.369974
R1204 vbn.n49 vbn.n48 0.369974
R1205 vbn.n50 vbn.n49 0.369974
R1206 vbn.n51 vbn.n50 0.369974
R1207 vbn.n52 vbn.n51 0.369974
R1208 vbn.n53 vbn.n52 0.369974
R1209 vbn.n54 vbn.n53 0.369974
R1210 vbn.n55 vbn.n54 0.369974
R1211 vbn.n56 vbn.n55 0.369974
R1212 vbn.n1 vbn.n0 0.369974
R1213 vbn.n2 vbn.n1 0.369974
R1214 vbn.n3 vbn.n2 0.369974
R1215 vbn.n4 vbn.n3 0.369974
R1216 vbn.n5 vbn.n4 0.369974
R1217 vbn.n6 vbn.n5 0.369974
R1218 vbn.n7 vbn.n6 0.369974
R1219 vbn.n11 vbn.n10 0.369974
R1220 vbn.n12 vbn.n11 0.369974
R1221 vbn.n13 vbn.n12 0.369974
R1222 vbn.n14 vbn.n13 0.369974
R1223 vbn.n77 vbn.n75 0.194711
R1224 vbn.n10 vbn.n9 0.194711
R1225 vbn.n78 vbn.n77 0.175763
R1226 vbn.n9 vbn.n7 0.175763
R1227 vbn.n59 vbn.n57 0.15751
R1228 vbn.n17 vbn.n15 0.15751
R1229 vbn.n61 vbn.n60 0.142318
R1230 vbn.n65 vbn.n64 0.142318
R1231 vbn.n69 vbn.n68 0.142318
R1232 vbn.n19 vbn.n18 0.142318
R1233 vbn.n23 vbn.n22 0.142318
R1234 vbn.n27 vbn.n26 0.142318
R1235 vbn.n8 vbn.t4 0.1405
R1236 vbn.n8 vbn.t1 0.1405
R1237 vbn.n76 vbn.t2 0.1405
R1238 vbn.n76 vbn.t3 0.1405
R1239 vbn.n60 vbn.n59 0.0714091
R1240 vbn.n63 vbn.n61 0.0714091
R1241 vbn.n64 vbn.n63 0.0714091
R1242 vbn.n67 vbn.n65 0.0714091
R1243 vbn.n68 vbn.n67 0.0714091
R1244 vbn.n18 vbn.n17 0.0714091
R1245 vbn.n21 vbn.n19 0.0714091
R1246 vbn.n22 vbn.n21 0.0714091
R1247 vbn.n25 vbn.n23 0.0714091
R1248 vbn.n26 vbn.n25 0.0714091
R1249 vbn.n70 vbn.n69 0.0700455
R1250 vbn.n28 vbn.n27 0.0700455
R1251 VDD.t12 VDD.t14 877.638
R1252 VDD.t10 VDD.t12 877.638
R1253 VDD.t8 VDD.t10 877.638
R1254 VDD.t6 VDD.t0 877.638
R1255 VDD.t0 VDD.t4 877.638
R1256 VDD.t4 VDD.t2 877.638
R1257 VDD.t14 VDD.t16 608.198
R1258 VDD.n78 VDD.t6 525.919
R1259 VDD.n78 VDD.t8 351.719
R1260 VDD.n33 VDD.t17 9.78053
R1261 VDD.n126 VDD.t3 2.10633
R1262 VDD.n34 VDD.t15 2.10633
R1263 VDD.n8 VDD.n7 1.97383
R1264 VDD.n17 VDD.n16 1.97383
R1265 VDD.n58 VDD.n25 1.97383
R1266 VDD VDD.n126 1.52994
R1267 VDD.n125 VDD.n0 1.5005
R1268 VDD.n124 VDD.n123 1.5005
R1269 VDD.n122 VDD.n1 1.5005
R1270 VDD.n121 VDD.n120 1.5005
R1271 VDD.n119 VDD.n2 1.5005
R1272 VDD.n118 VDD.n117 1.5005
R1273 VDD.n116 VDD.n3 1.5005
R1274 VDD.n115 VDD.n114 1.5005
R1275 VDD.n113 VDD.n4 1.5005
R1276 VDD.n112 VDD.n111 1.5005
R1277 VDD.n110 VDD.n5 1.5005
R1278 VDD.n109 VDD.n108 1.5005
R1279 VDD.n107 VDD.n6 1.5005
R1280 VDD.n106 VDD.n105 1.5005
R1281 VDD.n104 VDD.n103 1.5005
R1282 VDD.n102 VDD.n9 1.5005
R1283 VDD.n101 VDD.n100 1.5005
R1284 VDD.n99 VDD.n10 1.5005
R1285 VDD.n98 VDD.n97 1.5005
R1286 VDD.n96 VDD.n11 1.5005
R1287 VDD.n95 VDD.n94 1.5005
R1288 VDD.n93 VDD.n12 1.5005
R1289 VDD.n92 VDD.n91 1.5005
R1290 VDD.n90 VDD.n13 1.5005
R1291 VDD.n89 VDD.n88 1.5005
R1292 VDD.n87 VDD.n14 1.5005
R1293 VDD.n86 VDD.n85 1.5005
R1294 VDD.n84 VDD.n15 1.5005
R1295 VDD.n83 VDD.n82 1.5005
R1296 VDD.n81 VDD.n80 1.5005
R1297 VDD.n77 VDD.n18 1.5005
R1298 VDD.n76 VDD.n75 1.5005
R1299 VDD.n74 VDD.n19 1.5005
R1300 VDD.n73 VDD.n72 1.5005
R1301 VDD.n71 VDD.n20 1.5005
R1302 VDD.n70 VDD.n69 1.5005
R1303 VDD.n68 VDD.n21 1.5005
R1304 VDD.n67 VDD.n66 1.5005
R1305 VDD.n65 VDD.n22 1.5005
R1306 VDD.n64 VDD.n63 1.5005
R1307 VDD.n62 VDD.n23 1.5005
R1308 VDD.n61 VDD.n60 1.5005
R1309 VDD.n59 VDD.n24 1.5005
R1310 VDD.n57 VDD.n56 1.5005
R1311 VDD.n55 VDD.n26 1.5005
R1312 VDD.n54 VDD.n53 1.5005
R1313 VDD.n52 VDD.n27 1.5005
R1314 VDD.n51 VDD.n50 1.5005
R1315 VDD.n49 VDD.n28 1.5005
R1316 VDD.n48 VDD.n47 1.5005
R1317 VDD.n46 VDD.n29 1.5005
R1318 VDD.n45 VDD.n44 1.5005
R1319 VDD.n43 VDD.n30 1.5005
R1320 VDD.n42 VDD.n41 1.5005
R1321 VDD.n40 VDD.n31 1.5005
R1322 VDD.n39 VDD.n38 1.5005
R1323 VDD.n37 VDD.n32 1.5005
R1324 VDD.n36 VDD.n35 1.5005
R1325 VDD.n36 VDD.n33 0.617768
R1326 VDD.n7 VDD.t1 0.1405
R1327 VDD.n7 VDD.t5 0.1405
R1328 VDD.n16 VDD.t9 0.1405
R1329 VDD.n16 VDD.t7 0.1405
R1330 VDD.n25 VDD.t13 0.1405
R1331 VDD.n25 VDD.t11 0.1405
R1332 VDD.n34 VDD.n33 0.0851699
R1333 VDD.n35 VDD.n32 0.0755
R1334 VDD.n39 VDD.n32 0.0755
R1335 VDD.n40 VDD.n39 0.0755
R1336 VDD.n41 VDD.n40 0.0755
R1337 VDD.n41 VDD.n30 0.0755
R1338 VDD.n45 VDD.n30 0.0755
R1339 VDD.n46 VDD.n45 0.0755
R1340 VDD.n47 VDD.n46 0.0755
R1341 VDD.n47 VDD.n28 0.0755
R1342 VDD.n51 VDD.n28 0.0755
R1343 VDD.n52 VDD.n51 0.0755
R1344 VDD.n53 VDD.n52 0.0755
R1345 VDD.n53 VDD.n26 0.0755
R1346 VDD.n57 VDD.n26 0.0755
R1347 VDD.n60 VDD.n59 0.0755
R1348 VDD.n60 VDD.n23 0.0755
R1349 VDD.n64 VDD.n23 0.0755
R1350 VDD.n65 VDD.n64 0.0755
R1351 VDD.n66 VDD.n65 0.0755
R1352 VDD.n66 VDD.n21 0.0755
R1353 VDD.n70 VDD.n21 0.0755
R1354 VDD.n71 VDD.n70 0.0755
R1355 VDD.n72 VDD.n71 0.0755
R1356 VDD.n72 VDD.n19 0.0755
R1357 VDD.n76 VDD.n19 0.0755
R1358 VDD.n77 VDD.n76 0.0755
R1359 VDD.n80 VDD.n77 0.0755
R1360 VDD.n84 VDD.n83 0.0755
R1361 VDD.n85 VDD.n84 0.0755
R1362 VDD.n85 VDD.n14 0.0755
R1363 VDD.n89 VDD.n14 0.0755
R1364 VDD.n90 VDD.n89 0.0755
R1365 VDD.n91 VDD.n90 0.0755
R1366 VDD.n91 VDD.n12 0.0755
R1367 VDD.n95 VDD.n12 0.0755
R1368 VDD.n96 VDD.n95 0.0755
R1369 VDD.n97 VDD.n96 0.0755
R1370 VDD.n97 VDD.n10 0.0755
R1371 VDD.n101 VDD.n10 0.0755
R1372 VDD.n102 VDD.n101 0.0755
R1373 VDD.n103 VDD.n102 0.0755
R1374 VDD.n107 VDD.n106 0.0755
R1375 VDD.n108 VDD.n107 0.0755
R1376 VDD.n108 VDD.n5 0.0755
R1377 VDD.n112 VDD.n5 0.0755
R1378 VDD.n113 VDD.n112 0.0755
R1379 VDD.n114 VDD.n113 0.0755
R1380 VDD.n114 VDD.n3 0.0755
R1381 VDD.n118 VDD.n3 0.0755
R1382 VDD.n119 VDD.n118 0.0755
R1383 VDD.n120 VDD.n119 0.0755
R1384 VDD.n120 VDD.n1 0.0755
R1385 VDD.n124 VDD.n1 0.0755
R1386 VDD.n125 VDD.n124 0.0755
R1387 VDD.n37 VDD.n36 0.0755
R1388 VDD.n38 VDD.n37 0.0755
R1389 VDD.n38 VDD.n31 0.0755
R1390 VDD.n42 VDD.n31 0.0755
R1391 VDD.n43 VDD.n42 0.0755
R1392 VDD.n44 VDD.n43 0.0755
R1393 VDD.n44 VDD.n29 0.0755
R1394 VDD.n48 VDD.n29 0.0755
R1395 VDD.n49 VDD.n48 0.0755
R1396 VDD.n50 VDD.n49 0.0755
R1397 VDD.n50 VDD.n27 0.0755
R1398 VDD.n54 VDD.n27 0.0755
R1399 VDD.n55 VDD.n54 0.0755
R1400 VDD.n56 VDD.n55 0.0755
R1401 VDD.n56 VDD.n24 0.0755
R1402 VDD.n61 VDD.n24 0.0755
R1403 VDD.n62 VDD.n61 0.0755
R1404 VDD.n63 VDD.n62 0.0755
R1405 VDD.n63 VDD.n22 0.0755
R1406 VDD.n67 VDD.n22 0.0755
R1407 VDD.n68 VDD.n67 0.0755
R1408 VDD.n69 VDD.n68 0.0755
R1409 VDD.n69 VDD.n20 0.0755
R1410 VDD.n73 VDD.n20 0.0755
R1411 VDD.n74 VDD.n73 0.0755
R1412 VDD.n75 VDD.n74 0.0755
R1413 VDD.n75 VDD.n18 0.0755
R1414 VDD.n81 VDD.n18 0.0755
R1415 VDD.n82 VDD.n81 0.0755
R1416 VDD.n82 VDD.n15 0.0755
R1417 VDD.n86 VDD.n15 0.0755
R1418 VDD.n87 VDD.n86 0.0755
R1419 VDD.n88 VDD.n87 0.0755
R1420 VDD.n88 VDD.n13 0.0755
R1421 VDD.n92 VDD.n13 0.0755
R1422 VDD.n93 VDD.n92 0.0755
R1423 VDD.n94 VDD.n93 0.0755
R1424 VDD.n94 VDD.n11 0.0755
R1425 VDD.n98 VDD.n11 0.0755
R1426 VDD.n99 VDD.n98 0.0755
R1427 VDD.n100 VDD.n99 0.0755
R1428 VDD.n100 VDD.n9 0.0755
R1429 VDD.n104 VDD.n9 0.0755
R1430 VDD.n105 VDD.n104 0.0755
R1431 VDD.n105 VDD.n6 0.0755
R1432 VDD.n109 VDD.n6 0.0755
R1433 VDD.n110 VDD.n109 0.0755
R1434 VDD.n111 VDD.n110 0.0755
R1435 VDD.n111 VDD.n4 0.0755
R1436 VDD.n115 VDD.n4 0.0755
R1437 VDD.n116 VDD.n115 0.0755
R1438 VDD.n117 VDD.n116 0.0755
R1439 VDD.n117 VDD.n2 0.0755
R1440 VDD.n121 VDD.n2 0.0755
R1441 VDD.n122 VDD.n121 0.0755
R1442 VDD.n123 VDD.n122 0.0755
R1443 VDD.n123 VDD.n0 0.0755
R1444 VDD.n126 VDD.n125 0.0666875
R1445 VDD.n59 VDD.n58 0.05975
R1446 VDD VDD.n0 0.054875
R1447 VDD.n79 VDD.n17 0.0546875
R1448 VDD.n106 VDD.n8 0.05075
R1449 VDD.n79 VDD.n78 0.0497188
R1450 VDD.n35 VDD.n34 0.0261875
R1451 VDD.n103 VDD.n8 0.02525
R1452 VDD.n83 VDD.n17 0.01775
R1453 VDD.n58 VDD.n57 0.01625
R1454 VDD.n80 VDD.n79 0.0040625
R1455 VSS.n180 VSS.t0 218239
R1456 VSS.n181 VSS.n180 110414
R1457 VSS.n180 VSS.t22 13788.8
R1458 VSS.n181 VSS.t56 2740.85
R1459 VSS.t18 VSS.t20 498.873
R1460 VSS.t16 VSS.t18 498.873
R1461 VSS.t14 VSS.t16 498.873
R1462 VSS.t12 VSS.t14 498.873
R1463 VSS.t8 VSS.t10 498.873
R1464 VSS.t6 VSS.t8 498.873
R1465 VSS.t4 VSS.t6 498.873
R1466 VSS.t2 VSS.t4 498.873
R1467 VSS.t1 VSS.t20 397.305
R1468 VSS.t1 VSS.t10 336.125
R1469 VSS.n51 VSS.t1 181.881
R1470 VSS.t1 VSS.t2 155.899
R1471 VSS.t39 VSS.t56 129.654
R1472 VSS.t24 VSS.t25 114.37
R1473 VSS.t23 VSS.t24 114.37
R1474 VSS.t22 VSS.t23 114.37
R1475 VSS.t1 VSS.t12 94.7203
R1476 VSS.t28 VSS.t27 81.1211
R1477 VSS.t29 VSS.t28 81.1211
R1478 VSS.t30 VSS.t29 81.1211
R1479 VSS.t31 VSS.t30 81.1211
R1480 VSS.t32 VSS.t31 81.1211
R1481 VSS.t33 VSS.t34 81.1211
R1482 VSS.t35 VSS.t36 81.1211
R1483 VSS.t36 VSS.t37 81.1211
R1484 VSS.t37 VSS.t38 81.1211
R1485 VSS.t38 VSS.t39 81.1211
R1486 VSS.n180 VSS.n51 70.3908
R1487 VSS.n178 VSS.t35 56.7849
R1488 VSS.t54 VSS.t26 53.1485
R1489 VSS.t25 VSS.n179 50.2204
R1490 VSS.n55 VSS.t32 40.5608
R1491 VSS.n179 VSS.t33 31.6096
R1492 VSS.n56 VSS.t58 31.5873
R1493 VSS.t27 VSS.t54 27.9731
R1494 VSS.t34 VSS.n178 24.3367
R1495 VSS.t26 VSS.t0 13.1476
R1496 VSS.n179 VSS.n55 8.95174
R1497 VSS.n92 VSS.n55 6.27865
R1498 VSS.n83 VSS.n55 6.27865
R1499 VSS.n71 VSS.n55 6.27865
R1500 VSS.n63 VSS.n55 6.27865
R1501 VSS.n189 VSS.n51 5.56918
R1502 VSS.n177 VSS.n176 5.1679
R1503 VSS.n177 VSS.n56 5.0855
R1504 VSS.n57 VSS.t57 3.58511
R1505 VSS.n65 VSS.t47 3.44407
R1506 VSS.n86 VSS.t40 3.44407
R1507 VSS.n56 VSS.t55 2.88275
R1508 VSS.n195 VSS.n48 2.59037
R1509 VSS.n47 VSS.n31 2.59037
R1510 VSS.n213 VSS.n28 2.59037
R1511 VSS.n221 VSS.n25 2.59037
R1512 VSS.n42 VSS.n21 2.59037
R1513 VSS.n239 VSS.n18 2.59037
R1514 VSS.n39 VSS.n14 2.59037
R1515 VSS.n256 VSS.n11 2.59037
R1516 VSS.n36 VSS.n7 2.59037
R1517 VSS.n274 VSS.n4 2.59037
R1518 VSS.n282 VSS.n1 2.59037
R1519 VSS.n68 VSS.n66 2.54182
R1520 VSS.n89 VSS.n87 2.54182
R1521 VSS.t3 VSS.n1 2.51913
R1522 VSS.n48 VSS.t21 2.51913
R1523 VSS.n47 VSS.n46 2.48516
R1524 VSS.n45 VSS.n28 2.48516
R1525 VSS.n44 VSS.n25 2.48516
R1526 VSS.n43 VSS.n42 2.48516
R1527 VSS.n41 VSS.n18 2.48516
R1528 VSS.n40 VSS.n39 2.48516
R1529 VSS.n38 VSS.n11 2.48516
R1530 VSS.n37 VSS.n36 2.48516
R1531 VSS.n35 VSS.n4 2.48516
R1532 VSS.n68 VSS.n67 1.90242
R1533 VSS.n89 VSS.n88 1.90242
R1534 VSS.n65 VSS.n64 1.87392
R1535 VSS.n86 VSS.n85 1.87392
R1536 VSS VSS.n282 1.55056
R1537 VSS.n281 VSS.n0 1.5005
R1538 VSS.n280 VSS.n279 1.5005
R1539 VSS.n278 VSS.n2 1.5005
R1540 VSS.n277 VSS.n276 1.5005
R1541 VSS.n275 VSS.n3 1.5005
R1542 VSS.n273 VSS.n272 1.5005
R1543 VSS.n271 VSS.n5 1.5005
R1544 VSS.n270 VSS.n269 1.5005
R1545 VSS.n268 VSS.n6 1.5005
R1546 VSS.n267 VSS.n266 1.5005
R1547 VSS.n265 VSS.n264 1.5005
R1548 VSS.n263 VSS.n8 1.5005
R1549 VSS.n262 VSS.n261 1.5005
R1550 VSS.n260 VSS.n9 1.5005
R1551 VSS.n259 VSS.n258 1.5005
R1552 VSS.n257 VSS.n10 1.5005
R1553 VSS.n255 VSS.n254 1.5005
R1554 VSS.n253 VSS.n12 1.5005
R1555 VSS.n252 VSS.n251 1.5005
R1556 VSS.n250 VSS.n13 1.5005
R1557 VSS.n249 VSS.n248 1.5005
R1558 VSS.n247 VSS.n246 1.5005
R1559 VSS.n245 VSS.n15 1.5005
R1560 VSS.n244 VSS.n243 1.5005
R1561 VSS.n242 VSS.n16 1.5005
R1562 VSS.n241 VSS.n240 1.5005
R1563 VSS.n238 VSS.n17 1.5005
R1564 VSS.n237 VSS.n236 1.5005
R1565 VSS.n235 VSS.n19 1.5005
R1566 VSS.n234 VSS.n233 1.5005
R1567 VSS.n232 VSS.n20 1.5005
R1568 VSS.n231 VSS.n230 1.5005
R1569 VSS.n229 VSS.n228 1.5005
R1570 VSS.n227 VSS.n22 1.5005
R1571 VSS.n226 VSS.n225 1.5005
R1572 VSS.n224 VSS.n23 1.5005
R1573 VSS.n223 VSS.n222 1.5005
R1574 VSS.n220 VSS.n24 1.5005
R1575 VSS.n219 VSS.n218 1.5005
R1576 VSS.n217 VSS.n26 1.5005
R1577 VSS.n216 VSS.n215 1.5005
R1578 VSS.n214 VSS.n27 1.5005
R1579 VSS.n212 VSS.n211 1.5005
R1580 VSS.n210 VSS.n29 1.5005
R1581 VSS.n209 VSS.n208 1.5005
R1582 VSS.n207 VSS.n30 1.5005
R1583 VSS.n206 VSS.n205 1.5005
R1584 VSS.n204 VSS.n203 1.5005
R1585 VSS.n202 VSS.n32 1.5005
R1586 VSS.n201 VSS.n200 1.5005
R1587 VSS.n199 VSS.n33 1.5005
R1588 VSS.n198 VSS.n197 1.5005
R1589 VSS.n196 VSS.n34 1.5005
R1590 VSS.n194 VSS.n193 1.5005
R1591 VSS.n192 VSS.n49 1.5005
R1592 VSS.n191 VSS.n190 1.5005
R1593 VSS.n188 VSS.n50 1.5005
R1594 VSS.n187 VSS.n186 1.5005
R1595 VSS.n185 VSS.n52 1.5005
R1596 VSS.n184 VSS.n183 1.5005
R1597 VSS.n54 VSS.n53 1.5005
R1598 VSS.n97 VSS.n96 1.5005
R1599 VSS.n99 VSS.n98 1.5005
R1600 VSS.n100 VSS.n95 1.5005
R1601 VSS.n102 VSS.n101 1.5005
R1602 VSS.n103 VSS.n94 1.5005
R1603 VSS.n105 VSS.n104 1.5005
R1604 VSS.n106 VSS.n93 1.5005
R1605 VSS.n108 VSS.n107 1.5005
R1606 VSS.n110 VSS.n109 1.5005
R1607 VSS.n111 VSS.n91 1.5005
R1608 VSS.n113 VSS.n112 1.5005
R1609 VSS.n115 VSS.n114 1.5005
R1610 VSS.n116 VSS.n84 1.5005
R1611 VSS.n118 VSS.n117 1.5005
R1612 VSS.n120 VSS.n119 1.5005
R1613 VSS.n121 VSS.n82 1.5005
R1614 VSS.n123 VSS.n122 1.5005
R1615 VSS.n124 VSS.n81 1.5005
R1616 VSS.n126 VSS.n125 1.5005
R1617 VSS.n127 VSS.n80 1.5005
R1618 VSS.n129 VSS.n128 1.5005
R1619 VSS.n130 VSS.n79 1.5005
R1620 VSS.n132 VSS.n131 1.5005
R1621 VSS.n133 VSS.n78 1.5005
R1622 VSS.n135 VSS.n134 1.5005
R1623 VSS.n136 VSS.n77 1.5005
R1624 VSS.n138 VSS.n137 1.5005
R1625 VSS.n139 VSS.n76 1.5005
R1626 VSS.n141 VSS.n140 1.5005
R1627 VSS.n142 VSS.n75 1.5005
R1628 VSS.n144 VSS.n143 1.5005
R1629 VSS.n145 VSS.n74 1.5005
R1630 VSS.n147 VSS.n146 1.5005
R1631 VSS.n148 VSS.n73 1.5005
R1632 VSS.n150 VSS.n149 1.5005
R1633 VSS.n151 VSS.n72 1.5005
R1634 VSS.n153 VSS.n152 1.5005
R1635 VSS.n155 VSS.n154 1.5005
R1636 VSS.n156 VSS.n70 1.5005
R1637 VSS.n158 VSS.n157 1.5005
R1638 VSS.n160 VSS.n159 1.5005
R1639 VSS.n161 VSS.n62 1.5005
R1640 VSS.n163 VSS.n162 1.5005
R1641 VSS.n164 VSS.n61 1.5005
R1642 VSS.n166 VSS.n165 1.5005
R1643 VSS.n167 VSS.n60 1.5005
R1644 VSS.n169 VSS.n168 1.5005
R1645 VSS.n170 VSS.n59 1.5005
R1646 VSS.n172 VSS.n171 1.5005
R1647 VSS.n173 VSS.n58 1.5005
R1648 VSS.n175 VSS.n174 1.5005
R1649 VSS.n66 VSS.t53 0.8825
R1650 VSS.n66 VSS.t52 0.8825
R1651 VSS.n64 VSS.t49 0.8825
R1652 VSS.n64 VSS.t48 0.8825
R1653 VSS.n67 VSS.t51 0.8825
R1654 VSS.n67 VSS.t50 0.8825
R1655 VSS.n87 VSS.t46 0.8825
R1656 VSS.n87 VSS.t45 0.8825
R1657 VSS.n85 VSS.t42 0.8825
R1658 VSS.n85 VSS.t41 0.8825
R1659 VSS.n88 VSS.t44 0.8825
R1660 VSS.n88 VSS.t43 0.8825
R1661 VSS.n69 VSS.n68 0.85325
R1662 VSS.n90 VSS.n89 0.85325
R1663 VSS.n68 VSS.n65 0.668395
R1664 VSS.n89 VSS.n86 0.668395
R1665 VSS.n176 VSS.n175 0.364386
R1666 VSS.n47 VSS.n28 0.2381
R1667 VSS.n28 VSS.n25 0.2381
R1668 VSS.n42 VSS.n25 0.2381
R1669 VSS.n42 VSS.n18 0.2381
R1670 VSS.n39 VSS.n18 0.2381
R1671 VSS.n39 VSS.n11 0.2381
R1672 VSS.n36 VSS.n11 0.2381
R1673 VSS.n36 VSS.n4 0.2381
R1674 VSS.n48 VSS.n47 0.237763
R1675 VSS.n4 VSS.n1 0.237763
R1676 VSS.n176 VSS.n57 0.150782
R1677 VSS.n178 VSS.n177 0.12143
R1678 VSS.n174 VSS.n173 0.0755
R1679 VSS.n173 VSS.n172 0.0755
R1680 VSS.n172 VSS.n59 0.0755
R1681 VSS.n168 VSS.n59 0.0755
R1682 VSS.n168 VSS.n167 0.0755
R1683 VSS.n167 VSS.n166 0.0755
R1684 VSS.n166 VSS.n61 0.0755
R1685 VSS.n162 VSS.n161 0.0755
R1686 VSS.n161 VSS.n160 0.0755
R1687 VSS.n157 VSS.n156 0.0755
R1688 VSS.n156 VSS.n155 0.0755
R1689 VSS.n152 VSS.n151 0.0755
R1690 VSS.n151 VSS.n150 0.0755
R1691 VSS.n150 VSS.n73 0.0755
R1692 VSS.n146 VSS.n73 0.0755
R1693 VSS.n146 VSS.n145 0.0755
R1694 VSS.n145 VSS.n144 0.0755
R1695 VSS.n144 VSS.n75 0.0755
R1696 VSS.n140 VSS.n75 0.0755
R1697 VSS.n140 VSS.n139 0.0755
R1698 VSS.n139 VSS.n138 0.0755
R1699 VSS.n138 VSS.n77 0.0755
R1700 VSS.n134 VSS.n77 0.0755
R1701 VSS.n134 VSS.n133 0.0755
R1702 VSS.n133 VSS.n132 0.0755
R1703 VSS.n132 VSS.n79 0.0755
R1704 VSS.n128 VSS.n79 0.0755
R1705 VSS.n128 VSS.n127 0.0755
R1706 VSS.n127 VSS.n126 0.0755
R1707 VSS.n126 VSS.n81 0.0755
R1708 VSS.n122 VSS.n81 0.0755
R1709 VSS.n122 VSS.n121 0.0755
R1710 VSS.n121 VSS.n120 0.0755
R1711 VSS.n117 VSS.n116 0.0755
R1712 VSS.n116 VSS.n115 0.0755
R1713 VSS.n112 VSS.n111 0.0755
R1714 VSS.n111 VSS.n110 0.0755
R1715 VSS.n107 VSS.n106 0.0755
R1716 VSS.n106 VSS.n105 0.0755
R1717 VSS.n105 VSS.n94 0.0755
R1718 VSS.n101 VSS.n94 0.0755
R1719 VSS.n101 VSS.n100 0.0755
R1720 VSS.n100 VSS.n99 0.0755
R1721 VSS.n99 VSS.n96 0.0755
R1722 VSS.n96 VSS.n54 0.0755
R1723 VSS.n183 VSS.n54 0.0755
R1724 VSS.n187 VSS.n52 0.0755
R1725 VSS.n188 VSS.n187 0.0755
R1726 VSS.n190 VSS.n49 0.0755
R1727 VSS.n194 VSS.n49 0.0755
R1728 VSS.n197 VSS.n196 0.0755
R1729 VSS.n197 VSS.n33 0.0755
R1730 VSS.n201 VSS.n33 0.0755
R1731 VSS.n202 VSS.n201 0.0755
R1732 VSS.n203 VSS.n202 0.0755
R1733 VSS.n207 VSS.n206 0.0755
R1734 VSS.n208 VSS.n207 0.0755
R1735 VSS.n208 VSS.n29 0.0755
R1736 VSS.n212 VSS.n29 0.0755
R1737 VSS.n215 VSS.n214 0.0755
R1738 VSS.n215 VSS.n26 0.0755
R1739 VSS.n219 VSS.n26 0.0755
R1740 VSS.n220 VSS.n219 0.0755
R1741 VSS.n222 VSS.n23 0.0755
R1742 VSS.n226 VSS.n23 0.0755
R1743 VSS.n227 VSS.n226 0.0755
R1744 VSS.n228 VSS.n227 0.0755
R1745 VSS.n232 VSS.n231 0.0755
R1746 VSS.n233 VSS.n232 0.0755
R1747 VSS.n233 VSS.n19 0.0755
R1748 VSS.n237 VSS.n19 0.0755
R1749 VSS.n238 VSS.n237 0.0755
R1750 VSS.n240 VSS.n16 0.0755
R1751 VSS.n244 VSS.n16 0.0755
R1752 VSS.n245 VSS.n244 0.0755
R1753 VSS.n246 VSS.n245 0.0755
R1754 VSS.n250 VSS.n249 0.0755
R1755 VSS.n251 VSS.n250 0.0755
R1756 VSS.n251 VSS.n12 0.0755
R1757 VSS.n255 VSS.n12 0.0755
R1758 VSS.n258 VSS.n257 0.0755
R1759 VSS.n258 VSS.n9 0.0755
R1760 VSS.n262 VSS.n9 0.0755
R1761 VSS.n263 VSS.n262 0.0755
R1762 VSS.n264 VSS.n263 0.0755
R1763 VSS.n268 VSS.n267 0.0755
R1764 VSS.n269 VSS.n268 0.0755
R1765 VSS.n269 VSS.n5 0.0755
R1766 VSS.n273 VSS.n5 0.0755
R1767 VSS.n276 VSS.n275 0.0755
R1768 VSS.n276 VSS.n2 0.0755
R1769 VSS.n280 VSS.n2 0.0755
R1770 VSS.n281 VSS.n280 0.0755
R1771 VSS.n175 VSS.n58 0.0755
R1772 VSS.n171 VSS.n58 0.0755
R1773 VSS.n171 VSS.n170 0.0755
R1774 VSS.n170 VSS.n169 0.0755
R1775 VSS.n169 VSS.n60 0.0755
R1776 VSS.n165 VSS.n60 0.0755
R1777 VSS.n165 VSS.n164 0.0755
R1778 VSS.n164 VSS.n163 0.0755
R1779 VSS.n163 VSS.n62 0.0755
R1780 VSS.n159 VSS.n62 0.0755
R1781 VSS.n159 VSS.n158 0.0755
R1782 VSS.n158 VSS.n70 0.0755
R1783 VSS.n154 VSS.n70 0.0755
R1784 VSS.n154 VSS.n153 0.0755
R1785 VSS.n153 VSS.n72 0.0755
R1786 VSS.n149 VSS.n72 0.0755
R1787 VSS.n149 VSS.n148 0.0755
R1788 VSS.n148 VSS.n147 0.0755
R1789 VSS.n147 VSS.n74 0.0755
R1790 VSS.n143 VSS.n74 0.0755
R1791 VSS.n143 VSS.n142 0.0755
R1792 VSS.n142 VSS.n141 0.0755
R1793 VSS.n141 VSS.n76 0.0755
R1794 VSS.n137 VSS.n76 0.0755
R1795 VSS.n137 VSS.n136 0.0755
R1796 VSS.n136 VSS.n135 0.0755
R1797 VSS.n135 VSS.n78 0.0755
R1798 VSS.n131 VSS.n78 0.0755
R1799 VSS.n131 VSS.n130 0.0755
R1800 VSS.n130 VSS.n129 0.0755
R1801 VSS.n129 VSS.n80 0.0755
R1802 VSS.n125 VSS.n80 0.0755
R1803 VSS.n125 VSS.n124 0.0755
R1804 VSS.n124 VSS.n123 0.0755
R1805 VSS.n123 VSS.n82 0.0755
R1806 VSS.n119 VSS.n82 0.0755
R1807 VSS.n119 VSS.n118 0.0755
R1808 VSS.n118 VSS.n84 0.0755
R1809 VSS.n114 VSS.n84 0.0755
R1810 VSS.n114 VSS.n113 0.0755
R1811 VSS.n113 VSS.n91 0.0755
R1812 VSS.n109 VSS.n91 0.0755
R1813 VSS.n109 VSS.n108 0.0755
R1814 VSS.n108 VSS.n93 0.0755
R1815 VSS.n104 VSS.n93 0.0755
R1816 VSS.n104 VSS.n103 0.0755
R1817 VSS.n103 VSS.n102 0.0755
R1818 VSS.n102 VSS.n95 0.0755
R1819 VSS.n98 VSS.n95 0.0755
R1820 VSS.n98 VSS.n97 0.0755
R1821 VSS.n97 VSS.n53 0.0755
R1822 VSS.n184 VSS.n53 0.0755
R1823 VSS.n185 VSS.n184 0.0755
R1824 VSS.n186 VSS.n185 0.0755
R1825 VSS.n186 VSS.n50 0.0755
R1826 VSS.n191 VSS.n50 0.0755
R1827 VSS.n192 VSS.n191 0.0755
R1828 VSS.n193 VSS.n192 0.0755
R1829 VSS.n193 VSS.n34 0.0755
R1830 VSS.n198 VSS.n34 0.0755
R1831 VSS.n199 VSS.n198 0.0755
R1832 VSS.n200 VSS.n199 0.0755
R1833 VSS.n200 VSS.n32 0.0755
R1834 VSS.n204 VSS.n32 0.0755
R1835 VSS.n205 VSS.n204 0.0755
R1836 VSS.n205 VSS.n30 0.0755
R1837 VSS.n209 VSS.n30 0.0755
R1838 VSS.n210 VSS.n209 0.0755
R1839 VSS.n211 VSS.n210 0.0755
R1840 VSS.n211 VSS.n27 0.0755
R1841 VSS.n216 VSS.n27 0.0755
R1842 VSS.n217 VSS.n216 0.0755
R1843 VSS.n218 VSS.n217 0.0755
R1844 VSS.n218 VSS.n24 0.0755
R1845 VSS.n223 VSS.n24 0.0755
R1846 VSS.n224 VSS.n223 0.0755
R1847 VSS.n225 VSS.n224 0.0755
R1848 VSS.n225 VSS.n22 0.0755
R1849 VSS.n229 VSS.n22 0.0755
R1850 VSS.n230 VSS.n229 0.0755
R1851 VSS.n230 VSS.n20 0.0755
R1852 VSS.n234 VSS.n20 0.0755
R1853 VSS.n235 VSS.n234 0.0755
R1854 VSS.n236 VSS.n235 0.0755
R1855 VSS.n236 VSS.n17 0.0755
R1856 VSS.n241 VSS.n17 0.0755
R1857 VSS.n242 VSS.n241 0.0755
R1858 VSS.n243 VSS.n242 0.0755
R1859 VSS.n243 VSS.n15 0.0755
R1860 VSS.n247 VSS.n15 0.0755
R1861 VSS.n248 VSS.n247 0.0755
R1862 VSS.n248 VSS.n13 0.0755
R1863 VSS.n252 VSS.n13 0.0755
R1864 VSS.n253 VSS.n252 0.0755
R1865 VSS.n254 VSS.n253 0.0755
R1866 VSS.n254 VSS.n10 0.0755
R1867 VSS.n259 VSS.n10 0.0755
R1868 VSS.n260 VSS.n259 0.0755
R1869 VSS.n261 VSS.n260 0.0755
R1870 VSS.n261 VSS.n8 0.0755
R1871 VSS.n265 VSS.n8 0.0755
R1872 VSS.n266 VSS.n265 0.0755
R1873 VSS.n266 VSS.n6 0.0755
R1874 VSS.n270 VSS.n6 0.0755
R1875 VSS.n271 VSS.n270 0.0755
R1876 VSS.n272 VSS.n271 0.0755
R1877 VSS.n272 VSS.n3 0.0755
R1878 VSS.n277 VSS.n3 0.0755
R1879 VSS.n278 VSS.n277 0.0755
R1880 VSS.n279 VSS.n278 0.0755
R1881 VSS.n279 VSS.n0 0.0755
R1882 VSS.n267 VSS.n7 0.071375
R1883 VSS.n228 VSS.n21 0.070625
R1884 VSS.n206 VSS.n31 0.068375
R1885 VSS.n174 VSS.n57 0.0659375
R1886 VSS.n155 VSS.n71 0.063875
R1887 VSS.n195 VSS.n194 0.0621875
R1888 VSS.n112 VSS.n90 0.062
R1889 VSS.n240 VSS.n239 0.059375
R1890 VSS.n256 VSS.n255 0.058625
R1891 VSS VSS.n0 0.054875
R1892 VSS.n110 VSS.n92 0.051875
R1893 VSS.n190 VSS.n189 0.051125
R1894 VSS.n275 VSS.n274 0.050375
R1895 VSS.n157 VSS.n69 0.05
R1896 VSS.n221 VSS.n220 0.049625
R1897 VSS.n214 VSS.n213 0.047375
R1898 VSS.n63 VSS.n61 0.046625
R1899 VSS.n282 VSS.n281 0.0460625
R1900 VSS.n117 VSS.n83 0.041375
R1901 VSS.n183 VSS.n182 0.0389375
R1902 VSS.n249 VSS.n14 0.038375
R1903 VSS.n246 VSS.n14 0.037625
R1904 VSS.n182 VSS.n52 0.0370625
R1905 VSS.n46 VSS.t21 0.0363974
R1906 VSS.n46 VSS.t19 0.0363974
R1907 VSS.t19 VSS.n45 0.0363974
R1908 VSS.n45 VSS.t17 0.0363974
R1909 VSS.t17 VSS.n44 0.0363974
R1910 VSS.n44 VSS.t15 0.0363974
R1911 VSS.t15 VSS.n43 0.0363974
R1912 VSS.n43 VSS.t13 0.0363974
R1913 VSS.t13 VSS.n41 0.0363974
R1914 VSS.n41 VSS.t11 0.0363974
R1915 VSS.t11 VSS.n40 0.0363974
R1916 VSS.n40 VSS.t9 0.0363974
R1917 VSS.t9 VSS.n38 0.0363974
R1918 VSS.n38 VSS.t7 0.0363974
R1919 VSS.t7 VSS.n37 0.0363974
R1920 VSS.n37 VSS.t5 0.0363974
R1921 VSS.t5 VSS.n35 0.0363974
R1922 VSS.n35 VSS.t3 0.0363974
R1923 VSS.n120 VSS.n83 0.034625
R1924 VSS.n162 VSS.n63 0.029375
R1925 VSS.n213 VSS.n212 0.028625
R1926 VSS.n222 VSS.n221 0.026375
R1927 VSS.n160 VSS.n69 0.026
R1928 VSS.n274 VSS.n273 0.025625
R1929 VSS.n189 VSS.n188 0.024875
R1930 VSS.n107 VSS.n92 0.024125
R1931 VSS.n182 VSS.n181 0.0210534
R1932 VSS.n257 VSS.n256 0.017375
R1933 VSS.n239 VSS.n238 0.016625
R1934 VSS.n115 VSS.n90 0.014
R1935 VSS.n196 VSS.n195 0.0138125
R1936 VSS.n152 VSS.n71 0.012125
R1937 VSS.n203 VSS.n31 0.007625
R1938 VSS.n231 VSS.n21 0.005375
R1939 VSS.n264 VSS.n7 0.004625
C0 a_27926_1807# a_23540_2387# 0.72603f
C1 a_28216_2387# vbn 3.49251f
C2 a_23540_5867# a_28216_4707# 0.00115f
C3 vctrl a_23540_3547# 0.01256f
C4 vbn a_23540_2387# 11.9387f
C5 a_23250_4127# a_23540_3547# 10.9862f
C6 a_23250_7607# vbn 13.2849f
C7 a_27926_1807# a_23250_2967# 0.00177f
C8 a_28216_2387# a_23540_2387# 3.97376f
C9 vbn a_27926_7607# 3.54873f
C10 a_23540_5867# a_27926_5287# 2.88648f
C11 a_28216_1227# vctrl 0.00174f
C12 vbn a_23250_2967# 13.2571f
C13 a_23540_4707# a_23540_3547# 0.01838f
C14 a_23540_8187# vbn 12.6636f
C15 a_23250_7607# a_27926_7607# 4.1149f
C16 a_28216_2387# a_23250_2967# 2.91652f
C17 a_23250_2967# a_23540_2387# 10.9859f
C18 a_23540_8187# a_23250_7607# 11.0477f
C19 a_23540_5867# a_28216_5867# 4.03621f
C20 a_23250_6447# a_27926_5287# 0.00177f
C21 a_27926_1807# vctrl 4.74781f
C22 a_23250_5287# a_23540_3547# 0
C23 a_23540_8187# a_27926_7607# 2.88648f
C24 a_23250_1807# a_23540_1227# 10.9861f
C25 a_27926_4127# a_27926_2967# 0.05596f
C26 vbn vctrl 1.86478f
C27 vbn a_23250_4127# 13.2616f
C28 a_23250_6447# a_28216_5867# 2.91652f
C29 a_28216_2387# vctrl 0.3277f
C30 net3 a_28216_1227# 0.05949f
C31 vctrl a_23540_2387# 8.43974f
C32 a_23250_4127# a_23540_2387# 0
C33 a_27926_4127# a_28216_3547# 2.37431f
C34 vbn a_23540_4707# 12.4223f
C35 vbn a_27926_6447# 3.48625f
C36 vctrl a_23250_2967# 0.07604f
C37 a_23250_4127# a_23250_2967# 0.18664f
C38 a_23250_7607# a_27926_6447# 0.00177f
C39 vbn a_23250_5287# 13.2616f
C40 net3 vbn 6.10627f
C41 vbn a_28216_7027# 3.49334f
C42 a_27926_7607# a_27926_6447# 0.05596f
C43 a_23540_4707# a_23250_2967# 0
C44 net3 a_23540_2387# 0.00101f
C45 a_23250_7607# a_28216_7027# 2.91652f
C46 vctrl a_23250_4127# 0.00108f
C47 a_27926_7607# a_28216_7027# 2.37431f
C48 net1 vbn 53.2906f
C49 a_23540_8187# a_28216_7027# 0.00115f
C50 a_28216_3547# a_27926_2967# 2.37452f
C51 a_23540_4707# a_23250_4127# 11.0476f
C52 net1 a_23250_7607# 0.17366f
C53 net1 a_27926_7607# 0
C54 a_23250_5287# a_23250_4127# 0.18664f
C55 net1 a_23540_8187# 9.66738f
C56 net3 vctrl 0.07808f
C57 a_23250_5287# a_23540_4707# 10.9862f
C58 a_28216_7027# a_27926_6447# 2.37452f
C59 a_28216_8187# VDD 0.00481f
C60 net2 VDD 0.05007f
C61 vbn a_28216_4707# 3.49251f
C62 vbn a_27926_5287# 3.48625f
C63 vbn a_28216_5867# 3.49251f
C64 a_23250_4127# a_28216_4707# 0.03482f
C65 a_23540_7027# a_23540_5867# 0.01838f
C66 a_23540_4707# a_28216_4707# 4.03621f
C67 a_23540_7027# a_23250_6447# 11.0476f
C68 a_23540_4707# a_27926_5287# 0.03322f
C69 a_23250_5287# a_28216_4707# 2.91652f
C70 a_27926_6447# a_27926_5287# 0.05596f
C71 a_23250_5287# a_27926_5287# 4.1149f
C72 a_27926_6447# a_28216_5867# 2.37431f
C73 a_27926_4127# a_23540_3547# 0.03322f
C74 a_23250_5287# a_28216_5867# 0.03482f
C75 a_28216_7027# a_28216_5867# 0.05596f
C76 a_23250_6447# a_23540_5867# 10.9862f
C77 a_23540_1227# a_28216_1227# 4.04491f
C78 a_23250_1807# a_23540_3547# 0
C79 a_27926_4127# vbn 3.48625f
C80 a_28216_8187# vbn 6.27374f
C81 net2 vbn 0.27863f
C82 a_23250_1807# a_28216_1227# 2.91652f
C83 a_23540_1227# a_27926_1807# 0.03322f
C84 a_27926_2967# a_23540_3547# 2.88648f
C85 a_28216_8187# a_23250_7607# 0.03482f
C86 net2 a_23250_7607# 0.01558f
C87 a_23540_1227# vbn 12.5272f
C88 a_28216_8187# a_27926_7607# 2.37452f
C89 a_23250_1807# a_27926_1807# 4.00658f
C90 vbn vbnf 0.01083f
C91 a_28216_3547# a_23540_3547# 4.03621f
C92 a_23540_1227# a_23540_2387# 0
C93 a_28216_8187# a_23540_8187# 4.07037f
C94 net2 a_23540_8187# 0.0117f
C95 a_23250_1807# vbn 13.1706f
C96 a_23250_1807# a_28216_2387# 0.0269f
C97 a_27926_1807# a_27926_2967# 0.05596f
C98 a_23250_1807# a_23540_2387# 10.222f
C99 a_27926_2967# vbn 3.48625f
C100 a_27926_4127# a_23250_4127# 4.1149f
C101 a_28216_2387# a_27926_2967# 2.37431f
C102 a_23250_1807# a_23250_2967# 0.17041f
C103 a_27926_2967# a_23540_2387# 0.03322f
C104 a_28216_3547# vbn 3.49251f
C105 a_27926_4127# a_23540_4707# 2.88648f
C106 a_23540_1227# vctrl 0.06613f
C107 a_28216_2387# a_28216_3547# 0.05596f
C108 a_27926_5287# a_28216_4707# 2.37431f
C109 vbnf vctrl 2.98467f
C110 a_27926_2967# a_23250_2967# 4.1149f
C111 a_27926_4127# a_23250_5287# 0.00177f
C112 a_23250_1807# vctrl 2.4556f
C113 a_28216_8187# a_28216_7027# 0.05596f
C114 a_28216_5867# a_28216_4707# 0.05596f
C115 a_28216_3547# a_23250_2967# 0.03482f
C116 net4 vbn 0.00346f
C117 net3 a_23540_1227# 12.307f
C118 a_27926_2967# vctrl 0
C119 a_27926_2967# a_23250_4127# 0.00177f
C120 a_28216_5867# a_27926_5287# 2.37452f
C121 net1 a_28216_8187# 1.20914f
C122 net1 net2 0.14595f
C123 vbn a_23540_7027# 12.4252f
C124 net3 a_23250_1807# 0.1968f
C125 a_28216_3547# a_23250_4127# 2.91652f
C126 a_23250_7607# a_23540_7027# 10.9862f
C127 a_27926_7607# a_23540_7027# 0.03322f
C128 a_28216_3547# a_23540_4707# 0.00115f
C129 a_23540_8187# a_23540_7027# 0.01838f
C130 vbn VDD 0.24761f
C131 vbn a_23540_5867# 12.4223f
C132 a_23250_7607# a_23540_5867# 0
C133 vbn a_23250_6447# 13.2616f
C134 net3 net4 0.09601f
C135 a_27926_6447# a_23540_7027# 2.88648f
C136 a_23540_8187# VDD 0.00193f
C137 a_23250_7607# a_23250_6447# 0.18664f
C138 a_23540_7027# a_23250_5287# 0
C139 a_28216_7027# a_23540_7027# 4.03621f
C140 a_23540_8187# a_23250_6447# 0
C141 a_27926_4127# a_28216_4707# 2.37452f
C142 a_23540_5867# a_23250_4127# 0
C143 a_27926_4127# a_27926_5287# 0.05596f
C144 a_23540_5867# a_23540_4707# 0.01838f
C145 a_27926_6447# a_23540_5867# 0.03322f
C146 a_23250_6447# a_23540_4707# 0
C147 a_23540_5867# a_23250_5287# 11.0476f
C148 a_27926_6447# a_23250_6447# 4.1149f
C149 a_23250_6447# a_23250_5287# 0.18664f
C150 a_28216_7027# a_23250_6447# 0.03482f
C151 net1 VDD 26.4536f
C152 a_28216_3547# a_28216_4707# 0.05596f
C153 vbn a_23540_3547# 12.4223f
C154 a_27926_1807# a_28216_1227# 2.37431f
C155 a_28216_2387# a_23540_3547# 0.00115f
C156 a_23540_3547# a_23540_2387# 0.01838f
C157 a_28216_1227# vbn 3.47973f
C158 a_28216_2387# a_28216_1227# 0.05596f
C159 a_28216_1227# a_23540_2387# 0
C160 a_23540_3547# a_23250_2967# 11.0476f
C161 a_23540_7027# a_28216_5867# 0.00115f
C162 a_27926_1807# vbn 3.27202f
C163 a_28216_2387# a_27926_1807# 2.34764f
C164 vctrl VSS 34.357f
C165 vbnf VSS 0.10095p
C166 vbn VSS 0.18972p
C167 VDD VSS 0.24728p
C168 a_28216_1227# VSS 3.92673f
C169 a_27926_1807# VSS 1.69719f
C170 a_28216_2387# VSS 1.65655f
C171 a_27926_2967# VSS 1.65198f
C172 a_28216_3547# VSS 1.65655f
C173 a_27926_4127# VSS 1.65198f
C174 a_28216_4707# VSS 1.65655f
C175 a_27926_5287# VSS 1.65198f
C176 a_28216_5867# VSS 1.65655f
C177 a_27926_6447# VSS 1.65198f
C178 a_28216_7027# VSS 1.65655f
C179 a_27926_7607# VSS 1.65198f
C180 a_28216_8187# VSS 2.25067f
C181 a_23540_1227# VSS 1.87337f
C182 a_23250_1807# VSS 3.9691f
C183 a_23540_2387# VSS 1.31364f
C184 a_23250_2967# VSS 3.9634f
C185 a_23540_3547# VSS 1.34623f
C186 a_23250_4127# VSS 3.96359f
C187 a_23540_4707# VSS 1.34623f
C188 a_23250_5287# VSS 3.96359f
C189 a_23540_5867# VSS 1.34623f
C190 a_23250_6447# VSS 3.96359f
C191 a_23540_7027# VSS 1.34623f
C192 a_23250_7607# VSS 3.95929f
C193 a_23540_8187# VSS 1.67149f
C194 net2 VSS 0.65251f
C195 net1 VSS 12.6032f
C196 net4 VSS 0.65403f
C197 net3 VSS 11.5332f
C198 VDD.n0 VSS 0.04239f
C199 VDD.t3 VSS 0.09757f
C200 VDD.n1 VSS 0.04914f
C201 VDD.n2 VSS 0.04914f
C202 VDD.n3 VSS 0.04914f
C203 VDD.n4 VSS 0.04914f
C204 VDD.n5 VSS 0.04914f
C205 VDD.n6 VSS 0.04914f
C206 VDD.t1 VSS 0.02007f
C207 VDD.t5 VSS 0.02007f
C208 VDD.n7 VSS 0.07848f
C209 VDD.n8 VSS 0.04305f
C210 VDD.n9 VSS 0.04914f
C211 VDD.n10 VSS 0.04914f
C212 VDD.n11 VSS 0.04914f
C213 VDD.n12 VSS 0.04914f
C214 VDD.n13 VSS 0.04914f
C215 VDD.n14 VSS 0.04914f
C216 VDD.n15 VSS 0.04914f
C217 VDD.t9 VSS 0.02007f
C218 VDD.t7 VSS 0.02007f
C219 VDD.n16 VSS 0.07848f
C220 VDD.n17 VSS 0.04188f
C221 VDD.n18 VSS 0.04914f
C222 VDD.n19 VSS 0.04914f
C223 VDD.n20 VSS 0.04914f
C224 VDD.n21 VSS 0.04914f
C225 VDD.n22 VSS 0.04914f
C226 VDD.n23 VSS 0.04914f
C227 VDD.n24 VSS 0.04914f
C228 VDD.t13 VSS 0.02007f
C229 VDD.t11 VSS 0.02007f
C230 VDD.n25 VSS 0.07848f
C231 VDD.n26 VSS 0.04914f
C232 VDD.n27 VSS 0.04914f
C233 VDD.n28 VSS 0.04914f
C234 VDD.n29 VSS 0.04914f
C235 VDD.n30 VSS 0.04914f
C236 VDD.n31 VSS 0.04914f
C237 VDD.n32 VSS 0.04914f
C238 VDD.t17 VSS 0.00263f
C239 VDD.n33 VSS 0.16585f
C240 VDD.t15 VSS 0.09757f
C241 VDD.n34 VSS 0.06282f
C242 VDD.n35 VSS 0.03299f
C243 VDD.n36 VSS 0.17501f
C244 VDD.n37 VSS 0.04914f
C245 VDD.n38 VSS 0.04914f
C246 VDD.n39 VSS 0.04914f
C247 VDD.n40 VSS 0.04914f
C248 VDD.n41 VSS 0.04914f
C249 VDD.n42 VSS 0.04914f
C250 VDD.n43 VSS 0.04914f
C251 VDD.n44 VSS 0.04914f
C252 VDD.n45 VSS 0.04914f
C253 VDD.n46 VSS 0.04914f
C254 VDD.n47 VSS 0.04914f
C255 VDD.n48 VSS 0.04914f
C256 VDD.n49 VSS 0.04914f
C257 VDD.n50 VSS 0.04914f
C258 VDD.n51 VSS 0.04914f
C259 VDD.n52 VSS 0.04914f
C260 VDD.n53 VSS 0.04914f
C261 VDD.n54 VSS 0.04914f
C262 VDD.n55 VSS 0.04914f
C263 VDD.n56 VSS 0.04914f
C264 VDD.n57 VSS 0.02973f
C265 VDD.n58 VSS 0.04305f
C266 VDD.n59 VSS 0.04398f
C267 VDD.n60 VSS 0.04914f
C268 VDD.n61 VSS 0.04914f
C269 VDD.n62 VSS 0.04914f
C270 VDD.n63 VSS 0.04914f
C271 VDD.n64 VSS 0.04914f
C272 VDD.n65 VSS 0.04914f
C273 VDD.n66 VSS 0.04914f
C274 VDD.n67 VSS 0.04914f
C275 VDD.n68 VSS 0.04914f
C276 VDD.n69 VSS 0.04914f
C277 VDD.n70 VSS 0.04914f
C278 VDD.n71 VSS 0.04914f
C279 VDD.n72 VSS 0.04914f
C280 VDD.n73 VSS 0.04914f
C281 VDD.n74 VSS 0.04914f
C282 VDD.n75 VSS 0.04914f
C283 VDD.n76 VSS 0.04914f
C284 VDD.n77 VSS 0.04914f
C285 VDD.t16 VSS 0.97579f
C286 VDD.t14 VSS 2.0934f
C287 VDD.t12 VSS 2.47301f
C288 VDD.t10 VSS 2.47301f
C289 VDD.t8 VSS 1.73204f
C290 VDD.t2 VSS 2.57832f
C291 VDD.t4 VSS 2.47301f
C292 VDD.t0 VSS 2.47301f
C293 VDD.t6 VSS 1.97747f
C294 VDD.n78 VSS 1.00247f
C295 VDD.n79 VSS -0.21511f
C296 VDD.n80 VSS 0.02574f
C297 VDD.n81 VSS 0.04914f
C298 VDD.n82 VSS 0.04914f
C299 VDD.n83 VSS 0.03022f
C300 VDD.n84 VSS 0.04914f
C301 VDD.n85 VSS 0.04914f
C302 VDD.n86 VSS 0.04914f
C303 VDD.n87 VSS 0.04914f
C304 VDD.n88 VSS 0.04914f
C305 VDD.n89 VSS 0.04914f
C306 VDD.n90 VSS 0.04914f
C307 VDD.n91 VSS 0.04914f
C308 VDD.n92 VSS 0.04914f
C309 VDD.n93 VSS 0.04914f
C310 VDD.n94 VSS 0.04914f
C311 VDD.n95 VSS 0.04914f
C312 VDD.n96 VSS 0.04914f
C313 VDD.n97 VSS 0.04914f
C314 VDD.n98 VSS 0.04914f
C315 VDD.n99 VSS 0.04914f
C316 VDD.n100 VSS 0.04914f
C317 VDD.n101 VSS 0.04914f
C318 VDD.n102 VSS 0.04914f
C319 VDD.n103 VSS 0.03268f
C320 VDD.n104 VSS 0.04914f
C321 VDD.n105 VSS 0.04914f
C322 VDD.n106 VSS 0.04103f
C323 VDD.n107 VSS 0.04914f
C324 VDD.n108 VSS 0.04914f
C325 VDD.n109 VSS 0.04914f
C326 VDD.n110 VSS 0.04914f
C327 VDD.n111 VSS 0.04914f
C328 VDD.n112 VSS 0.04914f
C329 VDD.n113 VSS 0.04914f
C330 VDD.n114 VSS 0.04914f
C331 VDD.n115 VSS 0.04914f
C332 VDD.n116 VSS 0.04914f
C333 VDD.n117 VSS 0.04914f
C334 VDD.n118 VSS 0.04914f
C335 VDD.n119 VSS 0.04914f
C336 VDD.n120 VSS 0.04914f
C337 VDD.n121 VSS 0.04914f
C338 VDD.n122 VSS 0.04914f
C339 VDD.n123 VSS 0.04914f
C340 VDD.n124 VSS 0.04914f
C341 VDD.n125 VSS 0.04626f
C342 VDD.n126 VSS 0.06119f
C343 vbn.t0 VSS 0.03393f
C344 vbn.n0 VSS 0.0655f
C345 vbn.t35 VSS 0.20005f
C346 vbn.t49 VSS 0.26133f
C347 vbn.t63 VSS 0.26133f
C348 vbn.t77 VSS 0.26133f
C349 vbn.t91 VSS 0.26133f
C350 vbn.t105 VSS 0.26133f
C351 vbn.t119 VSS 0.26133f
C352 vbn.t133 VSS 0.26133f
C353 vbn.t147 VSS 0.26133f
C354 vbn.t161 VSS 0.26133f
C355 vbn.t175 VSS 0.26133f
C356 vbn.t189 VSS 0.26133f
C357 vbn.t203 VSS 0.26133f
C358 vbn.t217 VSS 0.22348f
C359 vbn.t36 VSS 0.20005f
C360 vbn.t50 VSS 0.26133f
C361 vbn.t64 VSS 0.26133f
C362 vbn.t78 VSS 0.26133f
C363 vbn.t92 VSS 0.26133f
C364 vbn.t106 VSS 0.26133f
C365 vbn.t120 VSS 0.26133f
C366 vbn.t134 VSS 0.26133f
C367 vbn.t148 VSS 0.26133f
C368 vbn.t162 VSS 0.26133f
C369 vbn.t176 VSS 0.26133f
C370 vbn.t190 VSS 0.26133f
C371 vbn.t204 VSS 0.26133f
C372 vbn.t218 VSS 0.22348f
C373 vbn.n1 VSS 0.05342f
C374 vbn.t37 VSS 0.20005f
C375 vbn.t51 VSS 0.26133f
C376 vbn.t65 VSS 0.26133f
C377 vbn.t79 VSS 0.26133f
C378 vbn.t93 VSS 0.26133f
C379 vbn.t107 VSS 0.26133f
C380 vbn.t121 VSS 0.26133f
C381 vbn.t135 VSS 0.26133f
C382 vbn.t149 VSS 0.26133f
C383 vbn.t163 VSS 0.26133f
C384 vbn.t177 VSS 0.26133f
C385 vbn.t191 VSS 0.26133f
C386 vbn.t205 VSS 0.26133f
C387 vbn.t219 VSS 0.22348f
C388 vbn.n2 VSS 0.05342f
C389 vbn.t38 VSS 0.20005f
C390 vbn.t52 VSS 0.26133f
C391 vbn.t66 VSS 0.26133f
C392 vbn.t80 VSS 0.26133f
C393 vbn.t94 VSS 0.26133f
C394 vbn.t108 VSS 0.26133f
C395 vbn.t122 VSS 0.26133f
C396 vbn.t136 VSS 0.26133f
C397 vbn.t150 VSS 0.26133f
C398 vbn.t164 VSS 0.26133f
C399 vbn.t178 VSS 0.26133f
C400 vbn.t192 VSS 0.26133f
C401 vbn.t206 VSS 0.26133f
C402 vbn.t220 VSS 0.22348f
C403 vbn.n3 VSS 0.05342f
C404 vbn.t39 VSS 0.20005f
C405 vbn.t53 VSS 0.26133f
C406 vbn.t67 VSS 0.26133f
C407 vbn.t81 VSS 0.26133f
C408 vbn.t95 VSS 0.26133f
C409 vbn.t109 VSS 0.26133f
C410 vbn.t123 VSS 0.26133f
C411 vbn.t137 VSS 0.26133f
C412 vbn.t151 VSS 0.26133f
C413 vbn.t165 VSS 0.26133f
C414 vbn.t179 VSS 0.26133f
C415 vbn.t193 VSS 0.26133f
C416 vbn.t207 VSS 0.26133f
C417 vbn.t221 VSS 0.22348f
C418 vbn.n4 VSS 0.05342f
C419 vbn.t40 VSS 0.20005f
C420 vbn.t54 VSS 0.26133f
C421 vbn.t68 VSS 0.26133f
C422 vbn.t82 VSS 0.26133f
C423 vbn.t96 VSS 0.26133f
C424 vbn.t110 VSS 0.26133f
C425 vbn.t124 VSS 0.26133f
C426 vbn.t138 VSS 0.26133f
C427 vbn.t152 VSS 0.26133f
C428 vbn.t166 VSS 0.26133f
C429 vbn.t180 VSS 0.26133f
C430 vbn.t194 VSS 0.26133f
C431 vbn.t208 VSS 0.26133f
C432 vbn.t222 VSS 0.22348f
C433 vbn.n5 VSS 0.05342f
C434 vbn.t41 VSS 0.20005f
C435 vbn.t55 VSS 0.26133f
C436 vbn.t69 VSS 0.26133f
C437 vbn.t83 VSS 0.26133f
C438 vbn.t97 VSS 0.26133f
C439 vbn.t111 VSS 0.26133f
C440 vbn.t125 VSS 0.26133f
C441 vbn.t139 VSS 0.26133f
C442 vbn.t153 VSS 0.26133f
C443 vbn.t167 VSS 0.26133f
C444 vbn.t181 VSS 0.26133f
C445 vbn.t195 VSS 0.26133f
C446 vbn.t209 VSS 0.26133f
C447 vbn.t223 VSS 0.22348f
C448 vbn.n6 VSS 0.05342f
C449 vbn.t42 VSS 0.20005f
C450 vbn.t56 VSS 0.26133f
C451 vbn.t70 VSS 0.26133f
C452 vbn.t84 VSS 0.26133f
C453 vbn.t98 VSS 0.26133f
C454 vbn.t112 VSS 0.26133f
C455 vbn.t126 VSS 0.26133f
C456 vbn.t140 VSS 0.26133f
C457 vbn.t154 VSS 0.26133f
C458 vbn.t168 VSS 0.26133f
C459 vbn.t182 VSS 0.26133f
C460 vbn.t196 VSS 0.26133f
C461 vbn.t210 VSS 0.26133f
C462 vbn.t224 VSS 0.22348f
C463 vbn.n7 VSS 0.03938f
C464 vbn.t43 VSS 0.20005f
C465 vbn.t57 VSS 0.26133f
C466 vbn.t71 VSS 0.26133f
C467 vbn.t85 VSS 0.26133f
C468 vbn.t99 VSS 0.26133f
C469 vbn.t113 VSS 0.26133f
C470 vbn.t127 VSS 0.26133f
C471 vbn.t141 VSS 0.26133f
C472 vbn.t155 VSS 0.26133f
C473 vbn.t169 VSS 0.26133f
C474 vbn.t183 VSS 0.26133f
C475 vbn.t197 VSS 0.26133f
C476 vbn.t211 VSS 0.26133f
C477 vbn.t225 VSS 0.22348f
C478 vbn.t4 VSS 0.17662f
C479 vbn.t1 VSS 0.17662f
C480 vbn.n8 VSS 0.8422f
C481 vbn.n9 VSS 0.09848f
C482 vbn.n10 VSS 0.04075f
C483 vbn.t44 VSS 0.20005f
C484 vbn.t58 VSS 0.26133f
C485 vbn.t72 VSS 0.26133f
C486 vbn.t86 VSS 0.26133f
C487 vbn.t100 VSS 0.26133f
C488 vbn.t114 VSS 0.26133f
C489 vbn.t128 VSS 0.26133f
C490 vbn.t142 VSS 0.26133f
C491 vbn.t156 VSS 0.26133f
C492 vbn.t170 VSS 0.26133f
C493 vbn.t184 VSS 0.26133f
C494 vbn.t198 VSS 0.26133f
C495 vbn.t212 VSS 0.26133f
C496 vbn.t226 VSS 0.22348f
C497 vbn.n11 VSS 0.05342f
C498 vbn.t45 VSS 0.20005f
C499 vbn.t59 VSS 0.26133f
C500 vbn.t73 VSS 0.26133f
C501 vbn.t87 VSS 0.26133f
C502 vbn.t101 VSS 0.26133f
C503 vbn.t115 VSS 0.26133f
C504 vbn.t129 VSS 0.26133f
C505 vbn.t143 VSS 0.26133f
C506 vbn.t157 VSS 0.26133f
C507 vbn.t171 VSS 0.26133f
C508 vbn.t185 VSS 0.26133f
C509 vbn.t199 VSS 0.26133f
C510 vbn.t213 VSS 0.26133f
C511 vbn.t227 VSS 0.22348f
C512 vbn.n12 VSS 0.05342f
C513 vbn.t46 VSS 0.20005f
C514 vbn.t60 VSS 0.26133f
C515 vbn.t74 VSS 0.26133f
C516 vbn.t88 VSS 0.26133f
C517 vbn.t102 VSS 0.26133f
C518 vbn.t116 VSS 0.26133f
C519 vbn.t130 VSS 0.26133f
C520 vbn.t144 VSS 0.26133f
C521 vbn.t158 VSS 0.26133f
C522 vbn.t172 VSS 0.26133f
C523 vbn.t186 VSS 0.26133f
C524 vbn.t200 VSS 0.26133f
C525 vbn.t214 VSS 0.26133f
C526 vbn.t228 VSS 0.22348f
C527 vbn.n13 VSS 0.05342f
C528 vbn.t47 VSS 0.20005f
C529 vbn.t61 VSS 0.26133f
C530 vbn.t75 VSS 0.26133f
C531 vbn.t89 VSS 0.26133f
C532 vbn.t103 VSS 0.26133f
C533 vbn.t117 VSS 0.26133f
C534 vbn.t131 VSS 0.26133f
C535 vbn.t145 VSS 0.26133f
C536 vbn.t159 VSS 0.26133f
C537 vbn.t173 VSS 0.26133f
C538 vbn.t187 VSS 0.26133f
C539 vbn.t201 VSS 0.26133f
C540 vbn.t215 VSS 0.26133f
C541 vbn.t229 VSS 0.22348f
C542 vbn.n14 VSS 0.07979f
C543 vbn.t48 VSS 0.20005f
C544 vbn.t62 VSS 0.26133f
C545 vbn.t76 VSS 0.26133f
C546 vbn.t90 VSS 0.26133f
C547 vbn.t104 VSS 0.26133f
C548 vbn.t118 VSS 0.26133f
C549 vbn.t132 VSS 0.26133f
C550 vbn.t146 VSS 0.26133f
C551 vbn.t160 VSS 0.26133f
C552 vbn.t174 VSS 0.26133f
C553 vbn.t188 VSS 0.26133f
C554 vbn.t202 VSS 0.26133f
C555 vbn.t216 VSS 0.26133f
C556 vbn.t230 VSS 0.22348f
C557 vbn.n15 VSS 0.06522f
C558 vbn.t231 VSS 0.20005f
C559 vbn.t238 VSS 0.26133f
C560 vbn.t245 VSS 0.26133f
C561 vbn.t252 VSS 0.26133f
C562 vbn.t259 VSS 0.26133f
C563 vbn.t266 VSS 0.26133f
C564 vbn.t273 VSS 0.26133f
C565 vbn.t280 VSS 0.26133f
C566 vbn.t287 VSS 0.26133f
C567 vbn.t294 VSS 0.26133f
C568 vbn.t301 VSS 0.26133f
C569 vbn.t308 VSS 0.26133f
C570 vbn.t315 VSS 0.26133f
C571 vbn.t32 VSS 0.22348f
C572 vbn.t33 VSS 0.02523f
C573 vbn.t31 VSS 0.02523f
C574 vbn.n16 VSS 0.05938f
C575 vbn.n17 VSS 0.12844f
C576 vbn.n18 VSS 0.10438f
C577 vbn.t232 VSS 0.20005f
C578 vbn.t239 VSS 0.26133f
C579 vbn.t246 VSS 0.26133f
C580 vbn.t253 VSS 0.26133f
C581 vbn.t260 VSS 0.26133f
C582 vbn.t267 VSS 0.26133f
C583 vbn.t274 VSS 0.26133f
C584 vbn.t281 VSS 0.26133f
C585 vbn.t288 VSS 0.26133f
C586 vbn.t295 VSS 0.26133f
C587 vbn.t302 VSS 0.26133f
C588 vbn.t309 VSS 0.26133f
C589 vbn.t316 VSS 0.26133f
C590 vbn.t30 VSS 0.22348f
C591 vbn.n19 VSS 0.10438f
C592 vbn.t233 VSS 0.20005f
C593 vbn.t240 VSS 0.26133f
C594 vbn.t247 VSS 0.26133f
C595 vbn.t254 VSS 0.26133f
C596 vbn.t261 VSS 0.26133f
C597 vbn.t268 VSS 0.26133f
C598 vbn.t275 VSS 0.26133f
C599 vbn.t282 VSS 0.26133f
C600 vbn.t289 VSS 0.26133f
C601 vbn.t296 VSS 0.26133f
C602 vbn.t303 VSS 0.26133f
C603 vbn.t310 VSS 0.26133f
C604 vbn.t317 VSS 0.26133f
C605 vbn.t28 VSS 0.22348f
C606 vbn.t29 VSS 0.02523f
C607 vbn.t27 VSS 0.02523f
C608 vbn.n20 VSS 0.05938f
C609 vbn.n21 VSS 0.13823f
C610 vbn.n22 VSS 0.10438f
C611 vbn.t234 VSS 0.20005f
C612 vbn.t241 VSS 0.26133f
C613 vbn.t248 VSS 0.26133f
C614 vbn.t255 VSS 0.26133f
C615 vbn.t262 VSS 0.26133f
C616 vbn.t269 VSS 0.26133f
C617 vbn.t276 VSS 0.26133f
C618 vbn.t283 VSS 0.26133f
C619 vbn.t290 VSS 0.26133f
C620 vbn.t297 VSS 0.26133f
C621 vbn.t304 VSS 0.26133f
C622 vbn.t311 VSS 0.26133f
C623 vbn.t318 VSS 0.26133f
C624 vbn.t26 VSS 0.22348f
C625 vbn.n23 VSS 0.10438f
C626 vbn.t235 VSS 0.20005f
C627 vbn.t242 VSS 0.26133f
C628 vbn.t249 VSS 0.26133f
C629 vbn.t256 VSS 0.26133f
C630 vbn.t263 VSS 0.26133f
C631 vbn.t270 VSS 0.26133f
C632 vbn.t277 VSS 0.26133f
C633 vbn.t284 VSS 0.26133f
C634 vbn.t291 VSS 0.26133f
C635 vbn.t298 VSS 0.26133f
C636 vbn.t305 VSS 0.26133f
C637 vbn.t312 VSS 0.26133f
C638 vbn.t319 VSS 0.26133f
C639 vbn.t24 VSS 0.22348f
C640 vbn.t25 VSS 0.02523f
C641 vbn.t23 VSS 0.02523f
C642 vbn.n24 VSS 0.05938f
C643 vbn.n25 VSS 0.13823f
C644 vbn.n26 VSS 0.10438f
C645 vbn.t236 VSS 0.20005f
C646 vbn.t243 VSS 0.26133f
C647 vbn.t250 VSS 0.26133f
C648 vbn.t257 VSS 0.26133f
C649 vbn.t264 VSS 0.26133f
C650 vbn.t271 VSS 0.26133f
C651 vbn.t278 VSS 0.26133f
C652 vbn.t285 VSS 0.26133f
C653 vbn.t292 VSS 0.26133f
C654 vbn.t299 VSS 0.26133f
C655 vbn.t306 VSS 0.26133f
C656 vbn.t313 VSS 0.26133f
C657 vbn.t320 VSS 0.26133f
C658 vbn.t22 VSS 0.22348f
C659 vbn.n27 VSS 0.10371f
C660 vbn.t237 VSS 0.20005f
C661 vbn.t244 VSS 0.26133f
C662 vbn.t251 VSS 0.26133f
C663 vbn.t258 VSS 0.26133f
C664 vbn.t265 VSS 0.26133f
C665 vbn.t272 VSS 0.26133f
C666 vbn.t279 VSS 0.26133f
C667 vbn.t286 VSS 0.26133f
C668 vbn.t293 VSS 0.26133f
C669 vbn.t300 VSS 0.26133f
C670 vbn.t307 VSS 0.26133f
C671 vbn.t314 VSS 0.26133f
C672 vbn.t321 VSS 0.26133f
C673 vbn.t20 VSS 0.22348f
C674 vbn.t21 VSS 0.06963f
C675 vbn.n28 VSS 0.17534f
C676 vbn.n29 VSS 0.06492f
C677 vbn.t322 VSS 0.20005f
C678 vbn.t350 VSS 0.26133f
C679 vbn.t378 VSS 0.26133f
C680 vbn.t406 VSS 0.26133f
C681 vbn.t434 VSS 0.26133f
C682 vbn.t462 VSS 0.26133f
C683 vbn.t490 VSS 0.26133f
C684 vbn.t518 VSS 0.26133f
C685 vbn.t546 VSS 0.26133f
C686 vbn.t574 VSS 0.26133f
C687 vbn.t602 VSS 0.26133f
C688 vbn.t630 VSS 0.26133f
C689 vbn.t658 VSS 0.26133f
C690 vbn.t686 VSS 0.22348f
C691 vbn.n30 VSS 0.05342f
C692 vbn.t323 VSS 0.20005f
C693 vbn.t351 VSS 0.26133f
C694 vbn.t379 VSS 0.26133f
C695 vbn.t407 VSS 0.26133f
C696 vbn.t435 VSS 0.26133f
C697 vbn.t463 VSS 0.26133f
C698 vbn.t491 VSS 0.26133f
C699 vbn.t519 VSS 0.26133f
C700 vbn.t547 VSS 0.26133f
C701 vbn.t575 VSS 0.26133f
C702 vbn.t603 VSS 0.26133f
C703 vbn.t631 VSS 0.26133f
C704 vbn.t659 VSS 0.26133f
C705 vbn.t687 VSS 0.22348f
C706 vbn.n31 VSS 0.05342f
C707 vbn.t324 VSS 0.20005f
C708 vbn.t352 VSS 0.26133f
C709 vbn.t380 VSS 0.26133f
C710 vbn.t408 VSS 0.26133f
C711 vbn.t436 VSS 0.26133f
C712 vbn.t464 VSS 0.26133f
C713 vbn.t492 VSS 0.26133f
C714 vbn.t520 VSS 0.26133f
C715 vbn.t548 VSS 0.26133f
C716 vbn.t576 VSS 0.26133f
C717 vbn.t604 VSS 0.26133f
C718 vbn.t632 VSS 0.26133f
C719 vbn.t660 VSS 0.26133f
C720 vbn.t688 VSS 0.22348f
C721 vbn.n32 VSS 0.05342f
C722 vbn.t325 VSS 0.20005f
C723 vbn.t353 VSS 0.26133f
C724 vbn.t381 VSS 0.26133f
C725 vbn.t409 VSS 0.26133f
C726 vbn.t437 VSS 0.26133f
C727 vbn.t465 VSS 0.26133f
C728 vbn.t493 VSS 0.26133f
C729 vbn.t521 VSS 0.26133f
C730 vbn.t549 VSS 0.26133f
C731 vbn.t577 VSS 0.26133f
C732 vbn.t605 VSS 0.26133f
C733 vbn.t633 VSS 0.26133f
C734 vbn.t661 VSS 0.26133f
C735 vbn.t689 VSS 0.22348f
C736 vbn.n33 VSS 0.05342f
C737 vbn.t326 VSS 0.20005f
C738 vbn.t354 VSS 0.26133f
C739 vbn.t382 VSS 0.26133f
C740 vbn.t410 VSS 0.26133f
C741 vbn.t438 VSS 0.26133f
C742 vbn.t466 VSS 0.26133f
C743 vbn.t494 VSS 0.26133f
C744 vbn.t522 VSS 0.26133f
C745 vbn.t550 VSS 0.26133f
C746 vbn.t578 VSS 0.26133f
C747 vbn.t606 VSS 0.26133f
C748 vbn.t634 VSS 0.26133f
C749 vbn.t662 VSS 0.26133f
C750 vbn.t690 VSS 0.22348f
C751 vbn.n34 VSS 0.05342f
C752 vbn.t327 VSS 0.20005f
C753 vbn.t355 VSS 0.26133f
C754 vbn.t383 VSS 0.26133f
C755 vbn.t411 VSS 0.26133f
C756 vbn.t439 VSS 0.26133f
C757 vbn.t467 VSS 0.26133f
C758 vbn.t495 VSS 0.26133f
C759 vbn.t523 VSS 0.26133f
C760 vbn.t551 VSS 0.26133f
C761 vbn.t579 VSS 0.26133f
C762 vbn.t607 VSS 0.26133f
C763 vbn.t635 VSS 0.26133f
C764 vbn.t663 VSS 0.26133f
C765 vbn.t691 VSS 0.22348f
C766 vbn.n35 VSS 0.05342f
C767 vbn.t328 VSS 0.20005f
C768 vbn.t356 VSS 0.26133f
C769 vbn.t384 VSS 0.26133f
C770 vbn.t412 VSS 0.26133f
C771 vbn.t440 VSS 0.26133f
C772 vbn.t468 VSS 0.26133f
C773 vbn.t496 VSS 0.26133f
C774 vbn.t524 VSS 0.26133f
C775 vbn.t552 VSS 0.26133f
C776 vbn.t580 VSS 0.26133f
C777 vbn.t608 VSS 0.26133f
C778 vbn.t636 VSS 0.26133f
C779 vbn.t664 VSS 0.26133f
C780 vbn.t692 VSS 0.22348f
C781 vbn.n36 VSS 0.05342f
C782 vbn.t329 VSS 0.20005f
C783 vbn.t357 VSS 0.26133f
C784 vbn.t385 VSS 0.26133f
C785 vbn.t413 VSS 0.26133f
C786 vbn.t441 VSS 0.26133f
C787 vbn.t469 VSS 0.26133f
C788 vbn.t497 VSS 0.26133f
C789 vbn.t525 VSS 0.26133f
C790 vbn.t553 VSS 0.26133f
C791 vbn.t581 VSS 0.26133f
C792 vbn.t609 VSS 0.26133f
C793 vbn.t637 VSS 0.26133f
C794 vbn.t665 VSS 0.26133f
C795 vbn.t693 VSS 0.22348f
C796 vbn.n37 VSS 0.05342f
C797 vbn.t330 VSS 0.20005f
C798 vbn.t358 VSS 0.26133f
C799 vbn.t386 VSS 0.26133f
C800 vbn.t414 VSS 0.26133f
C801 vbn.t442 VSS 0.26133f
C802 vbn.t470 VSS 0.26133f
C803 vbn.t498 VSS 0.26133f
C804 vbn.t526 VSS 0.26133f
C805 vbn.t554 VSS 0.26133f
C806 vbn.t582 VSS 0.26133f
C807 vbn.t610 VSS 0.26133f
C808 vbn.t638 VSS 0.26133f
C809 vbn.t666 VSS 0.26133f
C810 vbn.t694 VSS 0.22348f
C811 vbn.n38 VSS 0.05342f
C812 vbn.t331 VSS 0.20005f
C813 vbn.t359 VSS 0.26133f
C814 vbn.t387 VSS 0.26133f
C815 vbn.t415 VSS 0.26133f
C816 vbn.t443 VSS 0.26133f
C817 vbn.t471 VSS 0.26133f
C818 vbn.t499 VSS 0.26133f
C819 vbn.t527 VSS 0.26133f
C820 vbn.t555 VSS 0.26133f
C821 vbn.t583 VSS 0.26133f
C822 vbn.t611 VSS 0.26133f
C823 vbn.t639 VSS 0.26133f
C824 vbn.t667 VSS 0.26133f
C825 vbn.t695 VSS 0.22348f
C826 vbn.n39 VSS 0.05342f
C827 vbn.t332 VSS 0.20005f
C828 vbn.t360 VSS 0.26133f
C829 vbn.t388 VSS 0.26133f
C830 vbn.t416 VSS 0.26133f
C831 vbn.t444 VSS 0.26133f
C832 vbn.t472 VSS 0.26133f
C833 vbn.t500 VSS 0.26133f
C834 vbn.t528 VSS 0.26133f
C835 vbn.t556 VSS 0.26133f
C836 vbn.t584 VSS 0.26133f
C837 vbn.t612 VSS 0.26133f
C838 vbn.t640 VSS 0.26133f
C839 vbn.t668 VSS 0.26133f
C840 vbn.t696 VSS 0.22348f
C841 vbn.n40 VSS 0.05342f
C842 vbn.t333 VSS 0.20005f
C843 vbn.t361 VSS 0.26133f
C844 vbn.t389 VSS 0.26133f
C845 vbn.t417 VSS 0.26133f
C846 vbn.t445 VSS 0.26133f
C847 vbn.t473 VSS 0.26133f
C848 vbn.t501 VSS 0.26133f
C849 vbn.t529 VSS 0.26133f
C850 vbn.t557 VSS 0.26133f
C851 vbn.t585 VSS 0.26133f
C852 vbn.t613 VSS 0.26133f
C853 vbn.t641 VSS 0.26133f
C854 vbn.t669 VSS 0.26133f
C855 vbn.t697 VSS 0.22348f
C856 vbn.n41 VSS 0.05342f
C857 vbn.t334 VSS 0.20005f
C858 vbn.t362 VSS 0.26133f
C859 vbn.t390 VSS 0.26133f
C860 vbn.t418 VSS 0.26133f
C861 vbn.t446 VSS 0.26133f
C862 vbn.t474 VSS 0.26133f
C863 vbn.t502 VSS 0.26133f
C864 vbn.t530 VSS 0.26133f
C865 vbn.t558 VSS 0.26133f
C866 vbn.t586 VSS 0.26133f
C867 vbn.t614 VSS 0.26133f
C868 vbn.t642 VSS 0.26133f
C869 vbn.t670 VSS 0.26133f
C870 vbn.t698 VSS 0.22348f
C871 vbn.n42 VSS 0.05342f
C872 vbn.t335 VSS 0.20005f
C873 vbn.t363 VSS 0.26133f
C874 vbn.t391 VSS 0.26133f
C875 vbn.t419 VSS 0.26133f
C876 vbn.t447 VSS 0.26133f
C877 vbn.t475 VSS 0.26133f
C878 vbn.t503 VSS 0.26133f
C879 vbn.t531 VSS 0.26133f
C880 vbn.t559 VSS 0.26133f
C881 vbn.t587 VSS 0.26133f
C882 vbn.t615 VSS 0.26133f
C883 vbn.t643 VSS 0.26133f
C884 vbn.t671 VSS 0.26133f
C885 vbn.t699 VSS 0.22348f
C886 vbn.n43 VSS 0.05342f
C887 vbn.t336 VSS 0.20005f
C888 vbn.t364 VSS 0.26133f
C889 vbn.t392 VSS 0.26133f
C890 vbn.t420 VSS 0.26133f
C891 vbn.t448 VSS 0.26133f
C892 vbn.t476 VSS 0.26133f
C893 vbn.t504 VSS 0.26133f
C894 vbn.t532 VSS 0.26133f
C895 vbn.t560 VSS 0.26133f
C896 vbn.t588 VSS 0.26133f
C897 vbn.t616 VSS 0.26133f
C898 vbn.t644 VSS 0.26133f
C899 vbn.t672 VSS 0.26133f
C900 vbn.t700 VSS 0.22348f
C901 vbn.n44 VSS 0.05342f
C902 vbn.t337 VSS 0.20005f
C903 vbn.t365 VSS 0.26133f
C904 vbn.t393 VSS 0.26133f
C905 vbn.t421 VSS 0.26133f
C906 vbn.t449 VSS 0.26133f
C907 vbn.t477 VSS 0.26133f
C908 vbn.t505 VSS 0.26133f
C909 vbn.t533 VSS 0.26133f
C910 vbn.t561 VSS 0.26133f
C911 vbn.t589 VSS 0.26133f
C912 vbn.t617 VSS 0.26133f
C913 vbn.t645 VSS 0.26133f
C914 vbn.t673 VSS 0.26133f
C915 vbn.t701 VSS 0.22348f
C916 vbn.n45 VSS 0.05342f
C917 vbn.t338 VSS 0.20005f
C918 vbn.t366 VSS 0.26133f
C919 vbn.t394 VSS 0.26133f
C920 vbn.t422 VSS 0.26133f
C921 vbn.t450 VSS 0.26133f
C922 vbn.t478 VSS 0.26133f
C923 vbn.t506 VSS 0.26133f
C924 vbn.t534 VSS 0.26133f
C925 vbn.t562 VSS 0.26133f
C926 vbn.t590 VSS 0.26133f
C927 vbn.t618 VSS 0.26133f
C928 vbn.t646 VSS 0.26133f
C929 vbn.t674 VSS 0.26133f
C930 vbn.t702 VSS 0.22348f
C931 vbn.n46 VSS 0.05342f
C932 vbn.t339 VSS 0.20005f
C933 vbn.t367 VSS 0.26133f
C934 vbn.t395 VSS 0.26133f
C935 vbn.t423 VSS 0.26133f
C936 vbn.t451 VSS 0.26133f
C937 vbn.t479 VSS 0.26133f
C938 vbn.t507 VSS 0.26133f
C939 vbn.t535 VSS 0.26133f
C940 vbn.t563 VSS 0.26133f
C941 vbn.t591 VSS 0.26133f
C942 vbn.t619 VSS 0.26133f
C943 vbn.t647 VSS 0.26133f
C944 vbn.t675 VSS 0.26133f
C945 vbn.t703 VSS 0.22348f
C946 vbn.n47 VSS 0.05342f
C947 vbn.t340 VSS 0.20005f
C948 vbn.t368 VSS 0.26133f
C949 vbn.t396 VSS 0.26133f
C950 vbn.t424 VSS 0.26133f
C951 vbn.t452 VSS 0.26133f
C952 vbn.t480 VSS 0.26133f
C953 vbn.t508 VSS 0.26133f
C954 vbn.t536 VSS 0.26133f
C955 vbn.t564 VSS 0.26133f
C956 vbn.t592 VSS 0.26133f
C957 vbn.t620 VSS 0.26133f
C958 vbn.t648 VSS 0.26133f
C959 vbn.t676 VSS 0.26133f
C960 vbn.t704 VSS 0.22348f
C961 vbn.n48 VSS 0.05342f
C962 vbn.t341 VSS 0.20005f
C963 vbn.t369 VSS 0.26133f
C964 vbn.t397 VSS 0.26133f
C965 vbn.t425 VSS 0.26133f
C966 vbn.t453 VSS 0.26133f
C967 vbn.t481 VSS 0.26133f
C968 vbn.t509 VSS 0.26133f
C969 vbn.t537 VSS 0.26133f
C970 vbn.t565 VSS 0.26133f
C971 vbn.t593 VSS 0.26133f
C972 vbn.t621 VSS 0.26133f
C973 vbn.t649 VSS 0.26133f
C974 vbn.t677 VSS 0.26133f
C975 vbn.t705 VSS 0.22348f
C976 vbn.n49 VSS 0.05342f
C977 vbn.t342 VSS 0.20005f
C978 vbn.t370 VSS 0.26133f
C979 vbn.t398 VSS 0.26133f
C980 vbn.t426 VSS 0.26133f
C981 vbn.t454 VSS 0.26133f
C982 vbn.t482 VSS 0.26133f
C983 vbn.t510 VSS 0.26133f
C984 vbn.t538 VSS 0.26133f
C985 vbn.t566 VSS 0.26133f
C986 vbn.t594 VSS 0.26133f
C987 vbn.t622 VSS 0.26133f
C988 vbn.t650 VSS 0.26133f
C989 vbn.t678 VSS 0.26133f
C990 vbn.t706 VSS 0.22348f
C991 vbn.n50 VSS 0.05342f
C992 vbn.t343 VSS 0.20005f
C993 vbn.t371 VSS 0.26133f
C994 vbn.t399 VSS 0.26133f
C995 vbn.t427 VSS 0.26133f
C996 vbn.t455 VSS 0.26133f
C997 vbn.t483 VSS 0.26133f
C998 vbn.t511 VSS 0.26133f
C999 vbn.t539 VSS 0.26133f
C1000 vbn.t567 VSS 0.26133f
C1001 vbn.t595 VSS 0.26133f
C1002 vbn.t623 VSS 0.26133f
C1003 vbn.t651 VSS 0.26133f
C1004 vbn.t679 VSS 0.26133f
C1005 vbn.t707 VSS 0.22348f
C1006 vbn.n51 VSS 0.05342f
C1007 vbn.t344 VSS 0.20005f
C1008 vbn.t372 VSS 0.26133f
C1009 vbn.t400 VSS 0.26133f
C1010 vbn.t428 VSS 0.26133f
C1011 vbn.t456 VSS 0.26133f
C1012 vbn.t484 VSS 0.26133f
C1013 vbn.t512 VSS 0.26133f
C1014 vbn.t540 VSS 0.26133f
C1015 vbn.t568 VSS 0.26133f
C1016 vbn.t596 VSS 0.26133f
C1017 vbn.t624 VSS 0.26133f
C1018 vbn.t652 VSS 0.26133f
C1019 vbn.t680 VSS 0.26133f
C1020 vbn.t708 VSS 0.22348f
C1021 vbn.n52 VSS 0.05342f
C1022 vbn.t345 VSS 0.20005f
C1023 vbn.t373 VSS 0.26133f
C1024 vbn.t401 VSS 0.26133f
C1025 vbn.t429 VSS 0.26133f
C1026 vbn.t457 VSS 0.26133f
C1027 vbn.t485 VSS 0.26133f
C1028 vbn.t513 VSS 0.26133f
C1029 vbn.t541 VSS 0.26133f
C1030 vbn.t569 VSS 0.26133f
C1031 vbn.t597 VSS 0.26133f
C1032 vbn.t625 VSS 0.26133f
C1033 vbn.t653 VSS 0.26133f
C1034 vbn.t681 VSS 0.26133f
C1035 vbn.t709 VSS 0.22348f
C1036 vbn.n53 VSS 0.05342f
C1037 vbn.t346 VSS 0.20005f
C1038 vbn.t374 VSS 0.26133f
C1039 vbn.t402 VSS 0.26133f
C1040 vbn.t430 VSS 0.26133f
C1041 vbn.t458 VSS 0.26133f
C1042 vbn.t486 VSS 0.26133f
C1043 vbn.t514 VSS 0.26133f
C1044 vbn.t542 VSS 0.26133f
C1045 vbn.t570 VSS 0.26133f
C1046 vbn.t598 VSS 0.26133f
C1047 vbn.t626 VSS 0.26133f
C1048 vbn.t654 VSS 0.26133f
C1049 vbn.t682 VSS 0.26133f
C1050 vbn.t710 VSS 0.22348f
C1051 vbn.n54 VSS 0.05342f
C1052 vbn.t347 VSS 0.20005f
C1053 vbn.t375 VSS 0.26133f
C1054 vbn.t403 VSS 0.26133f
C1055 vbn.t431 VSS 0.26133f
C1056 vbn.t459 VSS 0.26133f
C1057 vbn.t487 VSS 0.26133f
C1058 vbn.t515 VSS 0.26133f
C1059 vbn.t543 VSS 0.26133f
C1060 vbn.t571 VSS 0.26133f
C1061 vbn.t599 VSS 0.26133f
C1062 vbn.t627 VSS 0.26133f
C1063 vbn.t655 VSS 0.26133f
C1064 vbn.t683 VSS 0.26133f
C1065 vbn.t711 VSS 0.22348f
C1066 vbn.n55 VSS 0.05342f
C1067 vbn.t348 VSS 0.20005f
C1068 vbn.t376 VSS 0.26133f
C1069 vbn.t404 VSS 0.26133f
C1070 vbn.t432 VSS 0.26133f
C1071 vbn.t460 VSS 0.26133f
C1072 vbn.t488 VSS 0.26133f
C1073 vbn.t516 VSS 0.26133f
C1074 vbn.t544 VSS 0.26133f
C1075 vbn.t572 VSS 0.26133f
C1076 vbn.t600 VSS 0.26133f
C1077 vbn.t628 VSS 0.26133f
C1078 vbn.t656 VSS 0.26133f
C1079 vbn.t684 VSS 0.26133f
C1080 vbn.t712 VSS 0.22348f
C1081 vbn.n56 VSS 0.07979f
C1082 vbn.t349 VSS 0.20005f
C1083 vbn.t377 VSS 0.26133f
C1084 vbn.t405 VSS 0.26133f
C1085 vbn.t433 VSS 0.26133f
C1086 vbn.t461 VSS 0.26133f
C1087 vbn.t489 VSS 0.26133f
C1088 vbn.t517 VSS 0.26133f
C1089 vbn.t545 VSS 0.26133f
C1090 vbn.t573 VSS 0.26133f
C1091 vbn.t601 VSS 0.26133f
C1092 vbn.t629 VSS 0.26133f
C1093 vbn.t657 VSS 0.26133f
C1094 vbn.t685 VSS 0.26133f
C1095 vbn.t713 VSS 0.22348f
C1096 vbn.n57 VSS 0.06522f
C1097 vbn.t714 VSS 0.20005f
C1098 vbn.t721 VSS 0.26133f
C1099 vbn.t728 VSS 0.26133f
C1100 vbn.t735 VSS 0.26133f
C1101 vbn.t742 VSS 0.26133f
C1102 vbn.t749 VSS 0.26133f
C1103 vbn.t756 VSS 0.26133f
C1104 vbn.t763 VSS 0.26133f
C1105 vbn.t770 VSS 0.26133f
C1106 vbn.t777 VSS 0.26133f
C1107 vbn.t784 VSS 0.26133f
C1108 vbn.t791 VSS 0.26133f
C1109 vbn.t798 VSS 0.26133f
C1110 vbn.t18 VSS 0.22348f
C1111 vbn.t19 VSS 0.02523f
C1112 vbn.t17 VSS 0.02523f
C1113 vbn.n58 VSS 0.05938f
C1114 vbn.n59 VSS 0.12844f
C1115 vbn.n60 VSS 0.10438f
C1116 vbn.t715 VSS 0.20005f
C1117 vbn.t722 VSS 0.26133f
C1118 vbn.t729 VSS 0.26133f
C1119 vbn.t736 VSS 0.26133f
C1120 vbn.t743 VSS 0.26133f
C1121 vbn.t750 VSS 0.26133f
C1122 vbn.t757 VSS 0.26133f
C1123 vbn.t764 VSS 0.26133f
C1124 vbn.t771 VSS 0.26133f
C1125 vbn.t778 VSS 0.26133f
C1126 vbn.t785 VSS 0.26133f
C1127 vbn.t792 VSS 0.26133f
C1128 vbn.t799 VSS 0.26133f
C1129 vbn.t16 VSS 0.22348f
C1130 vbn.n61 VSS 0.10438f
C1131 vbn.t716 VSS 0.20005f
C1132 vbn.t723 VSS 0.26133f
C1133 vbn.t730 VSS 0.26133f
C1134 vbn.t737 VSS 0.26133f
C1135 vbn.t744 VSS 0.26133f
C1136 vbn.t751 VSS 0.26133f
C1137 vbn.t758 VSS 0.26133f
C1138 vbn.t765 VSS 0.26133f
C1139 vbn.t772 VSS 0.26133f
C1140 vbn.t779 VSS 0.26133f
C1141 vbn.t786 VSS 0.26133f
C1142 vbn.t793 VSS 0.26133f
C1143 vbn.t800 VSS 0.26133f
C1144 vbn.t14 VSS 0.22348f
C1145 vbn.t15 VSS 0.02523f
C1146 vbn.t13 VSS 0.02523f
C1147 vbn.n62 VSS 0.05938f
C1148 vbn.n63 VSS 0.13823f
C1149 vbn.n64 VSS 0.10438f
C1150 vbn.t717 VSS 0.20005f
C1151 vbn.t724 VSS 0.26133f
C1152 vbn.t731 VSS 0.26133f
C1153 vbn.t738 VSS 0.26133f
C1154 vbn.t745 VSS 0.26133f
C1155 vbn.t752 VSS 0.26133f
C1156 vbn.t759 VSS 0.26133f
C1157 vbn.t766 VSS 0.26133f
C1158 vbn.t773 VSS 0.26133f
C1159 vbn.t780 VSS 0.26133f
C1160 vbn.t787 VSS 0.26133f
C1161 vbn.t794 VSS 0.26133f
C1162 vbn.t801 VSS 0.26133f
C1163 vbn.t12 VSS 0.22348f
C1164 vbn.n65 VSS 0.10438f
C1165 vbn.t718 VSS 0.20005f
C1166 vbn.t725 VSS 0.26133f
C1167 vbn.t732 VSS 0.26133f
C1168 vbn.t739 VSS 0.26133f
C1169 vbn.t746 VSS 0.26133f
C1170 vbn.t753 VSS 0.26133f
C1171 vbn.t760 VSS 0.26133f
C1172 vbn.t767 VSS 0.26133f
C1173 vbn.t774 VSS 0.26133f
C1174 vbn.t781 VSS 0.26133f
C1175 vbn.t788 VSS 0.26133f
C1176 vbn.t795 VSS 0.26133f
C1177 vbn.t802 VSS 0.26133f
C1178 vbn.t10 VSS 0.22348f
C1179 vbn.t11 VSS 0.02523f
C1180 vbn.t9 VSS 0.02523f
C1181 vbn.n66 VSS 0.05938f
C1182 vbn.n67 VSS 0.13823f
C1183 vbn.n68 VSS 0.10438f
C1184 vbn.t719 VSS 0.20005f
C1185 vbn.t726 VSS 0.26133f
C1186 vbn.t733 VSS 0.26133f
C1187 vbn.t740 VSS 0.26133f
C1188 vbn.t747 VSS 0.26133f
C1189 vbn.t754 VSS 0.26133f
C1190 vbn.t761 VSS 0.26133f
C1191 vbn.t768 VSS 0.26133f
C1192 vbn.t775 VSS 0.26133f
C1193 vbn.t782 VSS 0.26133f
C1194 vbn.t789 VSS 0.26133f
C1195 vbn.t796 VSS 0.26133f
C1196 vbn.t803 VSS 0.26133f
C1197 vbn.t8 VSS 0.22348f
C1198 vbn.n69 VSS 0.10371f
C1199 vbn.t720 VSS 0.20005f
C1200 vbn.t727 VSS 0.26133f
C1201 vbn.t734 VSS 0.26133f
C1202 vbn.t741 VSS 0.26133f
C1203 vbn.t748 VSS 0.26133f
C1204 vbn.t755 VSS 0.26133f
C1205 vbn.t762 VSS 0.26133f
C1206 vbn.t769 VSS 0.26133f
C1207 vbn.t776 VSS 0.26133f
C1208 vbn.t783 VSS 0.26133f
C1209 vbn.t790 VSS 0.26133f
C1210 vbn.t797 VSS 0.26133f
C1211 vbn.t804 VSS 0.26133f
C1212 vbn.t6 VSS 0.22348f
C1213 vbn.t7 VSS 0.06963f
C1214 vbn.n70 VSS 0.17534f
C1215 vbn.n71 VSS 0.06492f
C1216 vbn.t805 VSS 0.20005f
C1217 vbn.t819 VSS 0.26133f
C1218 vbn.t833 VSS 0.26133f
C1219 vbn.t847 VSS 0.26133f
C1220 vbn.t861 VSS 0.26133f
C1221 vbn.t875 VSS 0.26133f
C1222 vbn.t889 VSS 0.26133f
C1223 vbn.t903 VSS 0.26133f
C1224 vbn.t917 VSS 0.26133f
C1225 vbn.t931 VSS 0.26133f
C1226 vbn.t945 VSS 0.26133f
C1227 vbn.t959 VSS 0.26133f
C1228 vbn.t973 VSS 0.26133f
C1229 vbn.t987 VSS 0.22348f
C1230 vbn.n72 VSS 0.05342f
C1231 vbn.t806 VSS 0.20005f
C1232 vbn.t820 VSS 0.26133f
C1233 vbn.t834 VSS 0.26133f
C1234 vbn.t848 VSS 0.26133f
C1235 vbn.t862 VSS 0.26133f
C1236 vbn.t876 VSS 0.26133f
C1237 vbn.t890 VSS 0.26133f
C1238 vbn.t904 VSS 0.26133f
C1239 vbn.t918 VSS 0.26133f
C1240 vbn.t932 VSS 0.26133f
C1241 vbn.t946 VSS 0.26133f
C1242 vbn.t960 VSS 0.26133f
C1243 vbn.t974 VSS 0.26133f
C1244 vbn.t988 VSS 0.22348f
C1245 vbn.n73 VSS 0.05342f
C1246 vbn.t807 VSS 0.20005f
C1247 vbn.t821 VSS 0.26133f
C1248 vbn.t835 VSS 0.26133f
C1249 vbn.t849 VSS 0.26133f
C1250 vbn.t863 VSS 0.26133f
C1251 vbn.t877 VSS 0.26133f
C1252 vbn.t891 VSS 0.26133f
C1253 vbn.t905 VSS 0.26133f
C1254 vbn.t919 VSS 0.26133f
C1255 vbn.t933 VSS 0.26133f
C1256 vbn.t947 VSS 0.26133f
C1257 vbn.t961 VSS 0.26133f
C1258 vbn.t975 VSS 0.26133f
C1259 vbn.t989 VSS 0.22348f
C1260 vbn.n74 VSS 0.05342f
C1261 vbn.t808 VSS 0.20005f
C1262 vbn.t822 VSS 0.26133f
C1263 vbn.t836 VSS 0.26133f
C1264 vbn.t850 VSS 0.26133f
C1265 vbn.t864 VSS 0.26133f
C1266 vbn.t878 VSS 0.26133f
C1267 vbn.t892 VSS 0.26133f
C1268 vbn.t906 VSS 0.26133f
C1269 vbn.t920 VSS 0.26133f
C1270 vbn.t934 VSS 0.26133f
C1271 vbn.t948 VSS 0.26133f
C1272 vbn.t962 VSS 0.26133f
C1273 vbn.t976 VSS 0.26133f
C1274 vbn.t990 VSS 0.22348f
C1275 vbn.n75 VSS 0.04075f
C1276 vbn.t809 VSS 0.20005f
C1277 vbn.t823 VSS 0.26133f
C1278 vbn.t837 VSS 0.26133f
C1279 vbn.t851 VSS 0.26133f
C1280 vbn.t865 VSS 0.26133f
C1281 vbn.t879 VSS 0.26133f
C1282 vbn.t893 VSS 0.26133f
C1283 vbn.t907 VSS 0.26133f
C1284 vbn.t921 VSS 0.26133f
C1285 vbn.t935 VSS 0.26133f
C1286 vbn.t949 VSS 0.26133f
C1287 vbn.t963 VSS 0.26133f
C1288 vbn.t977 VSS 0.26133f
C1289 vbn.t991 VSS 0.22348f
C1290 vbn.t2 VSS 0.17662f
C1291 vbn.t3 VSS 0.17662f
C1292 vbn.n76 VSS 0.8422f
C1293 vbn.n77 VSS 0.09848f
C1294 vbn.n78 VSS 0.03938f
C1295 vbn.t810 VSS 0.20005f
C1296 vbn.t824 VSS 0.26133f
C1297 vbn.t838 VSS 0.26133f
C1298 vbn.t852 VSS 0.26133f
C1299 vbn.t866 VSS 0.26133f
C1300 vbn.t880 VSS 0.26133f
C1301 vbn.t894 VSS 0.26133f
C1302 vbn.t908 VSS 0.26133f
C1303 vbn.t922 VSS 0.26133f
C1304 vbn.t936 VSS 0.26133f
C1305 vbn.t950 VSS 0.26133f
C1306 vbn.t964 VSS 0.26133f
C1307 vbn.t978 VSS 0.26133f
C1308 vbn.t992 VSS 0.22348f
C1309 vbn.n79 VSS 0.05342f
C1310 vbn.t811 VSS 0.20005f
C1311 vbn.t825 VSS 0.26133f
C1312 vbn.t839 VSS 0.26133f
C1313 vbn.t853 VSS 0.26133f
C1314 vbn.t867 VSS 0.26133f
C1315 vbn.t881 VSS 0.26133f
C1316 vbn.t895 VSS 0.26133f
C1317 vbn.t909 VSS 0.26133f
C1318 vbn.t923 VSS 0.26133f
C1319 vbn.t937 VSS 0.26133f
C1320 vbn.t951 VSS 0.26133f
C1321 vbn.t965 VSS 0.26133f
C1322 vbn.t979 VSS 0.26133f
C1323 vbn.t993 VSS 0.22348f
C1324 vbn.n80 VSS 0.05342f
C1325 vbn.t812 VSS 0.20005f
C1326 vbn.t826 VSS 0.26133f
C1327 vbn.t840 VSS 0.26133f
C1328 vbn.t854 VSS 0.26133f
C1329 vbn.t868 VSS 0.26133f
C1330 vbn.t882 VSS 0.26133f
C1331 vbn.t896 VSS 0.26133f
C1332 vbn.t910 VSS 0.26133f
C1333 vbn.t924 VSS 0.26133f
C1334 vbn.t938 VSS 0.26133f
C1335 vbn.t952 VSS 0.26133f
C1336 vbn.t966 VSS 0.26133f
C1337 vbn.t980 VSS 0.26133f
C1338 vbn.t994 VSS 0.22348f
C1339 vbn.n81 VSS 0.05342f
C1340 vbn.t813 VSS 0.20005f
C1341 vbn.t827 VSS 0.26133f
C1342 vbn.t841 VSS 0.26133f
C1343 vbn.t855 VSS 0.26133f
C1344 vbn.t869 VSS 0.26133f
C1345 vbn.t883 VSS 0.26133f
C1346 vbn.t897 VSS 0.26133f
C1347 vbn.t911 VSS 0.26133f
C1348 vbn.t925 VSS 0.26133f
C1349 vbn.t939 VSS 0.26133f
C1350 vbn.t953 VSS 0.26133f
C1351 vbn.t967 VSS 0.26133f
C1352 vbn.t981 VSS 0.26133f
C1353 vbn.t995 VSS 0.22348f
C1354 vbn.n82 VSS 0.05342f
C1355 vbn.t814 VSS 0.20005f
C1356 vbn.t828 VSS 0.26133f
C1357 vbn.t842 VSS 0.26133f
C1358 vbn.t856 VSS 0.26133f
C1359 vbn.t870 VSS 0.26133f
C1360 vbn.t884 VSS 0.26133f
C1361 vbn.t898 VSS 0.26133f
C1362 vbn.t912 VSS 0.26133f
C1363 vbn.t926 VSS 0.26133f
C1364 vbn.t940 VSS 0.26133f
C1365 vbn.t954 VSS 0.26133f
C1366 vbn.t968 VSS 0.26133f
C1367 vbn.t982 VSS 0.26133f
C1368 vbn.t996 VSS 0.22348f
C1369 vbn.n83 VSS 0.05342f
C1370 vbn.t815 VSS 0.20005f
C1371 vbn.t829 VSS 0.26133f
C1372 vbn.t843 VSS 0.26133f
C1373 vbn.t857 VSS 0.26133f
C1374 vbn.t871 VSS 0.26133f
C1375 vbn.t885 VSS 0.26133f
C1376 vbn.t899 VSS 0.26133f
C1377 vbn.t913 VSS 0.26133f
C1378 vbn.t927 VSS 0.26133f
C1379 vbn.t941 VSS 0.26133f
C1380 vbn.t955 VSS 0.26133f
C1381 vbn.t969 VSS 0.26133f
C1382 vbn.t983 VSS 0.26133f
C1383 vbn.t997 VSS 0.22348f
C1384 vbn.n84 VSS 0.05342f
C1385 vbn.t816 VSS 0.20005f
C1386 vbn.t830 VSS 0.26133f
C1387 vbn.t844 VSS 0.26133f
C1388 vbn.t858 VSS 0.26133f
C1389 vbn.t872 VSS 0.26133f
C1390 vbn.t886 VSS 0.26133f
C1391 vbn.t900 VSS 0.26133f
C1392 vbn.t914 VSS 0.26133f
C1393 vbn.t928 VSS 0.26133f
C1394 vbn.t942 VSS 0.26133f
C1395 vbn.t956 VSS 0.26133f
C1396 vbn.t970 VSS 0.26133f
C1397 vbn.t984 VSS 0.26133f
C1398 vbn.t998 VSS 0.22348f
C1399 vbn.n85 VSS 0.0655f
C1400 vbn.t817 VSS 0.20005f
C1401 vbn.t831 VSS 0.26133f
C1402 vbn.t845 VSS 0.26133f
C1403 vbn.t859 VSS 0.26133f
C1404 vbn.t873 VSS 0.26133f
C1405 vbn.t887 VSS 0.26133f
C1406 vbn.t901 VSS 0.26133f
C1407 vbn.t915 VSS 0.26133f
C1408 vbn.t929 VSS 0.26133f
C1409 vbn.t943 VSS 0.26133f
C1410 vbn.t957 VSS 0.26133f
C1411 vbn.t971 VSS 0.26133f
C1412 vbn.t985 VSS 0.26133f
C1413 vbn.t999 VSS 0.22348f
C1414 vbn.t5 VSS 0.3136f
C1415 vbn.n86 VSS 2.74828f
C1416 vbn.t818 VSS 0.20005f
C1417 vbn.t832 VSS 0.26133f
C1418 vbn.t846 VSS 0.26133f
C1419 vbn.t860 VSS 0.26133f
C1420 vbn.t874 VSS 0.26133f
C1421 vbn.t888 VSS 0.26133f
C1422 vbn.t902 VSS 0.26133f
C1423 vbn.t916 VSS 0.26133f
C1424 vbn.t930 VSS 0.26133f
C1425 vbn.t944 VSS 0.26133f
C1426 vbn.t958 VSS 0.26133f
C1427 vbn.t972 VSS 0.26133f
C1428 vbn.t986 VSS 0.26133f
C1429 vbn.t1000 VSS 0.22348f
C1430 vbn.n87 VSS 1.68747f
C1431 vbn.n88 VSS 0.12816f
C1432 vbn.n89 VSS 0.12816f
C1433 vbn.n90 VSS 0.12816f
C1434 vbn.n91 VSS 0.12816f
C1435 vbn.n92 VSS 0.12816f
C1436 vbn.n93 VSS 0.12816f
C1437 vbn.n94 VSS 0.12816f
C1438 vbn.n95 VSS 0.12816f
C1439 vbn.n96 VSS 0.12816f
C1440 vbn.n97 VSS 0.12816f
C1441 vbn.n98 VSS 0.12816f
C1442 vbn.n99 VSS 0.12816f
C1443 vbn.n100 VSS 0.15383f
C1444 vbn.n101 VSS 0.15383f
C1445 vbn.n102 VSS 0.12816f
C1446 vbn.n103 VSS 0.12816f
C1447 vbn.n104 VSS 0.12816f
C1448 vbn.n105 VSS 0.12816f
C1449 vbn.n106 VSS 0.12816f
C1450 vbn.n107 VSS 0.15383f
C1451 vbn.n108 VSS 0.15383f
C1452 vbn.n109 VSS 0.12816f
C1453 vbn.n110 VSS 0.12816f
C1454 vbn.n111 VSS 0.12816f
C1455 vbn.n112 VSS 0.12816f
C1456 vbn.n113 VSS 0.12816f
C1457 vbn.n114 VSS 0.12816f
C1458 vbn.n115 VSS 0.12816f
C1459 vbn.n116 VSS 0.12816f
C1460 vbn.n117 VSS 0.12816f
C1461 vbn.n118 VSS 0.12816f
C1462 vbn.n119 VSS 0.12816f
C1463 vbn.n120 VSS 0.12816f
C1464 vbn.n121 VSS 0.12816f
C1465 vbn.n122 VSS 0.12816f
C1466 vbn.n123 VSS 0.12816f
C1467 vbn.n124 VSS 0.12816f
C1468 vbn.n125 VSS 0.12816f
C1469 vbn.n126 VSS 0.12816f
C1470 vbn.n127 VSS 0.12816f
C1471 vbn.n128 VSS 0.12816f
C1472 vbn.n129 VSS 0.12816f
C1473 vbn.n130 VSS 0.12816f
C1474 vbn.n131 VSS 0.12816f
C1475 vbn.n132 VSS 0.12816f
C1476 vbn.n133 VSS 0.12816f
C1477 vbn.n134 VSS 0.12816f
C1478 vbn.n135 VSS 0.15383f
C1479 vbn.n136 VSS 0.15383f
C1480 vbn.n137 VSS 0.12816f
C1481 vbn.n138 VSS 0.12816f
C1482 vbn.n139 VSS 0.12816f
C1483 vbn.n140 VSS 0.12816f
C1484 vbn.n141 VSS 0.12816f
C1485 vbn.n142 VSS 0.15383f
C1486 vbn.n143 VSS 0.15383f
C1487 vbn.n144 VSS 0.12816f
C1488 vbn.n145 VSS 0.12816f
C1489 vbn.n146 VSS 0.12816f
C1490 vbn.n147 VSS 0.12816f
C1491 vbn.n148 VSS 0.12816f
C1492 vbn.n149 VSS 0.12816f
C1493 vbn.n150 VSS 0.12816f
C1494 vbn.n151 VSS 0.12816f
C1495 vbn.n152 VSS 0.12816f
C1496 vbn.n153 VSS 0.12816f
C1497 vbn.n154 VSS 0.12816f
C1498 vbn.n155 VSS 0.12816f
C1499 vbn.n156 VSS 1.68747f
C1500 vbn.n157 VSS 1.6835f
C1501 vbn.n158 VSS 0.74023f
C1502 vbn.t34 VSS 0.04565f
C1503 vbn.n159 VSS 0.16998f
C1504 vbnf.t1 VSS 0.2353f
C1505 vbnf.t2 VSS 0.23188f
C1506 vbnf.n0 VSS 0.13136f
C1507 vbnf.t3 VSS 0.23188f
C1508 vbnf.n1 VSS 0.06735f
C1509 vbnf.t4 VSS 0.23188f
C1510 vbnf.n2 VSS 0.06735f
C1511 vbnf.t5 VSS 0.23188f
C1512 vbnf.n3 VSS 0.06735f
C1513 vbnf.t6 VSS 0.23188f
C1514 vbnf.n4 VSS 0.06735f
C1515 vbnf.t7 VSS 0.23188f
C1516 vbnf.n5 VSS 0.06735f
C1517 vbnf.t8 VSS 0.23188f
C1518 vbnf.n6 VSS 0.06735f
C1519 vbnf.t9 VSS 0.23188f
C1520 vbnf.n7 VSS 0.06735f
C1521 vbnf.t10 VSS 0.23188f
C1522 vbnf.n8 VSS 0.06529f
C1523 vbnf.t0 VSS 0
C1524 vbnf.n9 VSS 0.00316f
.ends
