* ring_core: magic R+C extraction of layout/ring_core.gds (layout/gen/pex.sh)
* extracted 2026-11-08T11:35:15+01:00 with magic 8.3.642, mode lvs, from ring_core_v3.gds
.subckt ring_core VDD VSS vbn vctrl bit0 bit1 bit2 bit3 bit4 bitb0 bitb1 bitb2 bitb3 bitb4 vg a0 a1 a2 a3 a4
X0 vbn bitb0 a_6156_6633# VDD pfet_03v3 ad=2.25p pd=10.9u as=2.25p ps=10.9u w=5u l=0.28u
X1 VSS vg VSS VSS nfet_03v3 ad=13.8195p pd=62.32u as=0.1289n ps=0.52988m w=30.71u l=4u
X2 VSS vbn vg VSS nfet_03v3 ad=0.28p pd=1.56u as=0.28p ps=1.56u w=1u l=5.335u
X3 a_6006_4464# bitb2 VSS VSS nfet_03v3 ad=0.45p pd=2.9u as=0.45p ps=2.9u w=1u l=0.28u
X4 vg a_6006_14# VSS VSS nfet_03v3 ad=0.28p pd=1.56u as=0.28p ps=1.56u w=1u l=5.335u
X5 VSS a_6006_14# vg VSS nfet_03v3 ad=0.45p pd=2.9u as=0.28p ps=1.56u w=1u l=5.335u
X6 vg a_6006_14# VSS VSS nfet_03v3 ad=0.28p pd=1.56u as=0.28p ps=1.56u w=1u l=5.335u
X7 vg a_6156_6633# VSS VSS nfet_03v3 ad=0.28p pd=1.56u as=0.45p ps=2.9u w=1u l=5.335u
X8 a3 a2 VDD VDD pfet_03v3 ad=2.25p pd=10.9u as=2.25p ps=10.9u w=5u l=0.28u
X9 VSS a_6006_14# vg VSS nfet_03v3 ad=0.28p pd=1.56u as=0.28p ps=1.56u w=1u l=5.335u
X10 vg a_6006_14# VSS VSS nfet_03v3 ad=0.28p pd=1.56u as=0.28p ps=1.56u w=1u l=5.335u
X11 a4 a3 VDD VDD pfet_03v3 ad=2.25p pd=10.9u as=2.25p ps=10.9u w=5u l=0.28u
X12 vbn bit1 a_6896_6633# VSS nfet_03v3 ad=0.9p pd=4.9u as=0.9p ps=4.9u w=2u l=0.28u
X13 vg a_6006_4464# VSS VSS nfet_03v3 ad=0.28p pd=1.56u as=0.45p ps=2.9u w=1u l=5.335u
X14 vbn bitb4 a_6006_14# VDD pfet_03v3 ad=2.25p pd=10.9u as=2.25p ps=10.9u w=5u l=0.28u
X15 VSS vg VSS VSS nfet_03v3 ad=8.5988p pd=31.27u as=0 ps=0 w=30.71u l=4u
X16 vg a4 a0 VSS nfet_03v3 ad=0.9p pd=4.9u as=0.9p ps=4.9u w=2u l=0.28u
X17 a_6006_856# bitb3 VSS VSS nfet_03v3 ad=0.45p pd=2.9u as=0.45p ps=2.9u w=1u l=0.28u
X18 vbn bit2 a_6006_4464# VSS nfet_03v3 ad=0.9p pd=4.9u as=0.9p ps=4.9u w=2u l=0.28u
X19 VSS vg VSS VSS nfet_03v3 ad=8.5988p pd=31.27u as=0 ps=0 w=30.71u l=4u
X20 VSS a_6006_14# vg VSS nfet_03v3 ad=0.28p pd=1.56u as=0.28p ps=1.56u w=1u l=5.335u
X21 vg a_6006_856# VSS VSS nfet_03v3 ad=0.28p pd=1.56u as=0.45p ps=2.9u w=1u l=5.335u
X22 VSS a_6006_856# vg VSS nfet_03v3 ad=0.45p pd=2.9u as=0.28p ps=1.56u w=1u l=5.335u
X23 VSS a_6006_856# vg VSS nfet_03v3 ad=0.28p pd=1.56u as=0.28p ps=1.56u w=1u l=5.335u
X24 VSS vg VSS VSS nfet_03v3 ad=8.5988p pd=31.27u as=0 ps=0 w=30.71u l=4u
X25 VSS a_6006_856# vg VSS nfet_03v3 ad=0.45p pd=2.9u as=0.28p ps=1.56u w=1u l=5.335u
X26 a2 a1 vg VSS nfet_03v3 ad=0.9p pd=4.9u as=0.9p ps=4.9u w=2u l=0.28u
X27 vg a_6006_856# VSS VSS nfet_03v3 ad=0.28p pd=1.56u as=0.28p ps=1.56u w=1u l=5.335u
X28 VSS vctrl vg VSS nfet_03v3 ad=0.45p pd=2.9u as=0.28p ps=1.56u w=1u l=21.335u
X29 VSS vg VSS VSS nfet_03v3 ad=8.5988p pd=31.27u as=0 ps=0 w=30.71u l=4u
X30 vg a_6006_856# VSS VSS nfet_03v3 ad=0.28p pd=1.56u as=0.28p ps=1.56u w=1u l=5.335u
X31 VSS vbn vg VSS nfet_03v3 ad=0.28p pd=1.56u as=0.28p ps=1.56u w=1u l=5.335u
X32 vg a_6006_14# VSS VSS nfet_03v3 ad=0.28p pd=1.56u as=0.45p ps=2.9u w=1u l=5.335u
X33 VSS vbn vg VSS nfet_03v3 ad=0.28p pd=1.56u as=0.28p ps=1.56u w=1u l=5.335u
X34 vbn bitb1 a_6896_6633# VDD pfet_03v3 ad=2.25p pd=10.9u as=2.25p ps=10.9u w=5u l=0.28u
X35 vbn bit3 a_6006_856# VSS nfet_03v3 ad=0.9p pd=4.9u as=0.9p ps=4.9u w=2u l=0.28u
X36 VSS a_6006_14# vg VSS nfet_03v3 ad=0.45p pd=2.9u as=0.28p ps=1.56u w=1u l=5.335u
X37 VSS a_6006_14# vg VSS nfet_03v3 ad=0.28p pd=1.56u as=0.28p ps=1.56u w=1u l=5.335u
X38 VDD a4 a0 VDD pfet_03v3 ad=2.25p pd=10.9u as=2.25p ps=10.9u w=5u l=0.28u
X39 a_6156_6633# bitb0 VSS VSS nfet_03v3 ad=0.45p pd=2.9u as=0.45p ps=2.9u w=1u l=0.28u
X40 VSS a_6006_14# vg VSS nfet_03v3 ad=0.28p pd=1.56u as=0.28p ps=1.56u w=1u l=5.335u
X41 vbn bitb2 a_6006_4464# VDD pfet_03v3 ad=2.25p pd=10.9u as=2.25p ps=10.9u w=5u l=0.28u
X42 a_6896_6633# bitb1 VSS VSS nfet_03v3 ad=0.45p pd=2.9u as=0.45p ps=2.9u w=1u l=0.28u
X43 vg a_6006_856# VSS VSS nfet_03v3 ad=0.28p pd=1.56u as=0.45p ps=2.9u w=1u l=5.335u
X44 a2 a1 VDD VDD pfet_03v3 ad=2.25p pd=10.9u as=2.25p ps=10.9u w=5u l=0.28u
X45 VSS a_6006_14# vg VSS nfet_03v3 ad=0.45p pd=2.9u as=0.28p ps=1.56u w=1u l=5.335u
X46 a_6006_14# bitb4 VSS VSS nfet_03v3 ad=0.45p pd=2.9u as=0.45p ps=2.9u w=1u l=0.28u
X47 VSS a_6006_4464# vg VSS nfet_03v3 ad=0.28p pd=1.56u as=0.28p ps=1.56u w=1u l=5.335u
X48 vg a_6006_4464# VSS VSS nfet_03v3 ad=0.28p pd=1.56u as=0.28p ps=1.56u w=1u l=5.335u
X49 a1 a0 vg VSS nfet_03v3 ad=0.9p pd=4.9u as=0.9p ps=4.9u w=2u l=0.28u
X50 VSS a_6006_14# vg VSS nfet_03v3 ad=0.28p pd=1.56u as=0.28p ps=1.56u w=1u l=5.335u
X51 vg a_6006_14# VSS VSS nfet_03v3 ad=0.28p pd=1.56u as=0.28p ps=1.56u w=1u l=5.335u
X52 vbn bitb3 a_6006_856# VDD pfet_03v3 ad=2.25p pd=10.9u as=2.25p ps=10.9u w=5u l=0.28u
X53 vbn bit0 a_6156_6633# VSS nfet_03v3 ad=0.9p pd=4.9u as=0.9p ps=4.9u w=2u l=0.28u
X54 vg vbn VSS VSS nfet_03v3 ad=0.28p pd=1.56u as=0.28p ps=1.56u w=1u l=5.335u
X55 a3 a2 vg VSS nfet_03v3 ad=0.9p pd=4.9u as=0.9p ps=4.9u w=2u l=0.28u
X56 VSS a_6006_4464# vg VSS nfet_03v3 ad=0.45p pd=2.9u as=0.28p ps=1.56u w=1u l=5.335u
X57 vg a_6006_14# VSS VSS nfet_03v3 ad=0.28p pd=1.56u as=0.45p ps=2.9u w=1u l=5.335u
X58 a4 a3 vg VSS nfet_03v3 ad=0.9p pd=4.9u as=0.9p ps=4.9u w=2u l=0.28u
X59 vbn bit4 a_6006_14# VSS nfet_03v3 ad=0.9p pd=4.9u as=0.9p ps=4.9u w=2u l=0.28u
X60 vg a_6006_14# VSS VSS nfet_03v3 ad=0.28p pd=1.56u as=0.45p ps=2.9u w=1u l=5.335u
X61 VSS vg VSS VSS nfet_03v3 ad=8.5988p pd=31.27u as=0 ps=0 w=30.71u l=4u
X62 VSS a_6006_856# vg VSS nfet_03v3 ad=0.28p pd=1.56u as=0.28p ps=1.56u w=1u l=5.335u
X63 vg vbn VSS VSS nfet_03v3 ad=0.28p pd=1.56u as=0.28p ps=1.56u w=1u l=5.335u
X64 a1 a0 VDD VDD pfet_03v3 ad=2.25p pd=10.9u as=2.25p ps=10.9u w=5u l=0.28u
X65 vg vbn VSS VSS nfet_03v3 ad=0.28p pd=1.56u as=0.28p ps=1.56u w=1u l=5.335u
X66 VSS a_6896_6633# vg VSS nfet_03v3 ad=0.28p pd=1.56u as=0.28p ps=1.56u w=1u l=5.335u
X67 vg a_6896_6633# VSS VSS nfet_03v3 ad=0.28p pd=1.56u as=0.28p ps=1.56u w=1u l=5.335u
X68 vg a_6006_14# VSS VSS nfet_03v3 ad=0.28p pd=1.56u as=0.28p ps=1.56u w=1u l=5.335u
.ends
