* tx_drv: magic R+C extraction of layout/tx_drv.gds (layout/gen/pex.sh)
* extracted 2026-11-09T21:25:48+01:00 with magic 8.3.642, mode c, from tx_drv.gds
.subckt tx_drv VDD VSS ls en_p en_n out_p out_n
X0 out_p py4 VSS VSS nfet_03v3 ad=4.8p pd=9.2u as=9.6p ps=18.4u w=8u l=0.28u
X1 out_p py4 VDD VDD pfet_03v3 ad=12p pd=21.2u as=12p ps=21.2u w=20u l=0.28u
X2 VSS VDD VSS VSS nfet_03v3 ad=12p pd=22.4u as=0.42061n ps=0.8429m w=10u l=10u
X3 VSS VDD VSS VSS nfet_03v3 ad=6p pd=11.2u as=0 ps=0 w=10u l=10u
X4 b a VDD VDD pfet_03v3 ad=1.05p pd=4.1u as=0.4725p ps=3u w=1.05u l=0.28u
X5 py0 a VDD VDD pfet_03v3 ad=0.625p pd=2.25u as=0.5625p ps=3.4u w=1.25u l=0.28u
X6 out_p py4 VSS VSS nfet_03v3 ad=9.6p pd=18.4u as=4.8p ps=9.2u w=8u l=0.28u
X7 out_n ny4 VSS VSS nfet_03v3 ad=4.8p pd=9.2u as=4.8p ps=9.2u w=8u l=0.28u
X8 b a VSS VSS nfet_03v3 ad=0.42p pd=2.84u as=0.189p ps=1.74u w=0.42u l=0.28u
X9 VSS VDD VSS VSS nfet_03v3 ad=6p pd=11.2u as=0 ps=0 w=10u l=10u
X10 VDD ny4 out_n VDD pfet_03v3 ad=12p pd=21.2u as=12p ps=21.2u w=20u l=0.28u
X11 ta t VDD VDD pfet_03v3 ad=1.25p pd=4.5u as=0.5625p ps=3.4u w=1.25u l=0.28u
X12 VSS VDD VSS VSS nfet_03v3 ad=6p pd=11.2u as=0 ps=0 w=10u l=10u
X13 out_n ny4 VDD VDD pfet_03v3 ad=12p pd=21.2u as=12p ps=21.2u w=20u l=0.28u
X14 tb t VSS VSS nfet_03v3 ad=1.5p pd=5u as=0.675p ps=3.9u w=1.5u l=0.28u
X15 VSS en_p a_9448_1520# VSS nfet_03v3 ad=0.45p pd=2.9u as=0.28p ps=1.56u w=1u l=0.28u
X16 VSS VDD VSS VSS nfet_03v3 ad=6p pd=11.2u as=0 ps=0 w=10u l=10u
X17 b VSS tb VDD pfet_03v3 ad=2.5p pd=7u as=2.5p ps=7u w=2.5u l=0.28u
X18 VSS py3 py4 VSS nfet_03v3 ad=2.25p pd=10.9u as=2.5p ps=6u w=5u l=0.28u
X19 tb t VDD VDD pfet_03v3 ad=3.75p pd=9.5u as=1.6875p ps=8.4u w=3.75u l=0.28u
X20 a_9448_1520# a py0 VSS nfet_03v3 ad=0.28p pd=1.56u as=1p ps=4u w=1u l=0.28u
X21 VDD ny2 ny3 VDD pfet_03v3 ad=2.8125p pd=13.4u as=6.25p ps=14.5u w=6.25u l=0.28u
X22 py2 py1 VDD VDD pfet_03v3 ad=1.56p pd=5.12u as=0.702p ps=4.02u w=1.56u l=0.28u
X23 VDD py4 out_p VDD pfet_03v3 ad=12p pd=21.2u as=12p ps=21.2u w=20u l=0.28u
X24 a b VDD VDD pfet_03v3 ad=1.05p pd=4.1u as=0.4725p ps=3u w=1.05u l=0.28u
X25 out_p py4 VDD VDD pfet_03v3 ad=12p pd=21.2u as=24p ps=42.4u w=20u l=0.28u
X26 out_n ny4 VSS VSS nfet_03v3 ad=4.8p pd=9.2u as=4.8p ps=9.2u w=8u l=0.28u
X27 a ta VSS VSS nfet_03v3 ad=1p pd=4u as=0.45p ps=2.9u w=1u l=0.28u
X28 VSS VDD VSS VSS nfet_03v3 ad=6p pd=11.2u as=0 ps=0 w=10u l=10u
X29 VSS py4 out_p VSS nfet_03v3 ad=4.8p pd=9.2u as=4.8p ps=9.2u w=8u l=0.28u
X30 VDD ny0 ny1 VDD pfet_03v3 ad=0.4725p pd=3u as=1.05p ps=4.1u w=1.05u l=0.28u
X31 py4 py3 VDD VDD pfet_03v3 ad=6.25p pd=13.5u as=5.625p ps=25.9u w=12.5u l=0.28u
X32 a b VSS VSS nfet_03v3 ad=0.42p pd=2.84u as=0.189p ps=1.74u w=0.42u l=0.28u
X33 VSS VDD VSS VSS nfet_03v3 ad=6p pd=11.2u as=0 ps=0 w=10u l=10u
X34 VSS VDD VSS VSS nfet_03v3 ad=6p pd=11.2u as=0 ps=0 w=10u l=10u
X35 VSS VDD VSS VSS nfet_03v3 ad=6p pd=11.2u as=0 ps=0 w=10u l=10u
X36 VDD ny3 ny4 VDD pfet_03v3 ad=5.625p pd=25.9u as=6.25p ps=13.5u w=12.5u l=0.28u
X37 VSS ny0 ny1 VSS nfet_03v3 ad=0.189p pd=1.74u as=0.42p ps=2.84u w=0.42u l=0.28u
X38 py3 py2 VSS VSS nfet_03v3 ad=2.5p pd=7u as=1.125p ps=5.9u w=2.5u l=0.28u
X39 VSS VDD VSS VSS nfet_03v3 ad=12p pd=22.4u as=0 ps=0 w=10u l=10u
X40 py2 py1 VSS VSS nfet_03v3 ad=0.625p pd=3.25u as=0.28125p ps=2.15u w=0.625u l=0.28u
X41 VDD ny4 out_n VDD pfet_03v3 ad=24p pd=42.4u as=12p ps=21.2u w=20u l=0.28u
X42 VSS ny4 out_n VSS nfet_03v3 ad=9.6p pd=18.4u as=4.8p ps=9.2u w=8u l=0.28u
X43 ta t VSS VSS nfet_03v3 ad=0.5p pd=3u as=0.225p ps=1.9u w=0.5u l=0.28u
X44 VSS VDD VSS VSS nfet_03v3 ad=6p pd=11.2u as=0 ps=0 w=10u l=10u
X45 VDD ny1 ny2 VDD pfet_03v3 ad=0.702p pd=4.02u as=1.56p ps=5.12u w=1.56u l=0.28u
X46 VDD b ny0 VDD pfet_03v3 ad=0.5625p pd=3.4u as=0.625p ps=2.25u w=1.25u l=0.28u
X47 ny4 ny3 VSS VSS nfet_03v3 ad=2.5p pd=6u as=2.25p ps=10.9u w=5u l=0.28u
X48 out_p py4 VSS VSS nfet_03v3 ad=4.8p pd=9.2u as=4.8p ps=9.2u w=8u l=0.28u
X49 t ls VDD VDD pfet_03v3 ad=1.05p pd=4.1u as=0.4725p ps=3u w=1.05u l=0.28u
X50 VDD en_p py0 VDD pfet_03v3 ad=0.5625p pd=3.4u as=0.625p ps=2.25u w=1.25u l=0.28u
X51 out_p py4 VDD VDD pfet_03v3 ad=24p pd=42.4u as=12p ps=21.2u w=20u l=0.28u
X52 VSS VDD VSS VSS nfet_03v3 ad=6p pd=11.2u as=0 ps=0 w=10u l=10u
X53 VSS VDD VSS VSS nfet_03v3 ad=6p pd=11.2u as=0 ps=0 w=10u l=10u
X54 VSS VDD VSS VSS nfet_03v3 ad=6p pd=11.2u as=0 ps=0 w=10u l=10u
X55 VDD py3 py4 VDD pfet_03v3 ad=5.625p pd=25.9u as=6.25p ps=13.5u w=12.5u l=0.28u
X56 VDD py4 out_p VDD pfet_03v3 ad=12p pd=21.2u as=12p ps=21.2u w=20u l=0.28u
X57 t ls VSS VSS nfet_03v3 ad=0.42p pd=2.84u as=0.189p ps=1.74u w=0.42u l=0.28u
X58 VSS VDD VSS VSS nfet_03v3 ad=12p pd=22.4u as=0 ps=0 w=10u l=10u
X59 VSS VDD VSS VSS nfet_03v3 ad=12p pd=22.4u as=0 ps=0 w=10u l=10u
X60 ny4 ny3 VDD VDD pfet_03v3 ad=6.25p pd=13.5u as=5.625p ps=25.9u w=12.5u l=0.28u
X61 ny0 en_n VDD VDD pfet_03v3 ad=0.625p pd=2.25u as=0.5625p ps=3.4u w=1.25u l=0.28u
X62 a ta VDD VDD pfet_03v3 ad=2.5p pd=7u as=1.125p ps=5.9u w=2.5u l=0.28u
X63 VSS ny4 out_n VSS nfet_03v3 ad=4.8p pd=9.2u as=4.8p ps=9.2u w=8u l=0.28u
X64 VSS ny3 ny4 VSS nfet_03v3 ad=2.25p pd=10.9u as=2.5p ps=6u w=5u l=0.28u
X65 VSS VDD VSS VSS nfet_03v3 ad=6p pd=11.2u as=0 ps=0 w=10u l=10u
X66 VSS ny1 ny2 VSS nfet_03v3 ad=0.28125p pd=2.15u as=0.625p ps=3.25u w=0.625u l=0.28u
X67 ny0 b a_4834_1520# VSS nfet_03v3 ad=1p pd=4u as=0.28p ps=1.56u w=1u l=0.28u
X68 py4 py3 VSS VSS nfet_03v3 ad=2.5p pd=6u as=2.25p ps=10.9u w=5u l=0.28u
X69 VSS VDD VSS VSS nfet_03v3 ad=6p pd=11.2u as=0 ps=0 w=10u l=10u
X70 VSS VDD VSS VSS nfet_03v3 ad=6p pd=11.2u as=0 ps=0 w=10u l=10u
X71 VSS VDD VSS VSS nfet_03v3 ad=6p pd=11.2u as=0 ps=0 w=10u l=10u
X72 VSS VDD VSS VSS nfet_03v3 ad=6p pd=11.2u as=0 ps=0 w=10u l=10u
X73 py1 py0 VDD VDD pfet_03v3 ad=1.05p pd=4.1u as=0.4725p ps=3u w=1.05u l=0.28u
X74 VSS ny4 out_n VSS nfet_03v3 ad=4.8p pd=9.2u as=9.6p ps=18.4u w=8u l=0.28u
X75 VSS VDD VSS VSS nfet_03v3 ad=6p pd=11.2u as=0 ps=0 w=10u l=10u
X76 a_4834_1520# en_n VSS VSS nfet_03v3 ad=0.28p pd=1.56u as=0.45p ps=2.9u w=1u l=0.28u
X77 py1 py0 VSS VSS nfet_03v3 ad=0.42p pd=2.84u as=0.189p ps=1.74u w=0.42u l=0.28u
X78 VSS VDD VSS VSS nfet_03v3 ad=12p pd=22.4u as=0 ps=0 w=10u l=10u
X79 VDD ny4 out_n VDD pfet_03v3 ad=12p pd=21.2u as=24p ps=42.4u w=20u l=0.28u
X80 VSS ny2 ny3 VSS nfet_03v3 ad=1.125p pd=5.9u as=2.5p ps=7u w=2.5u l=0.28u
X81 out_n ny4 VDD VDD pfet_03v3 ad=12p pd=21.2u as=12p ps=21.2u w=20u l=0.28u
X82 py3 py2 VDD VDD pfet_03v3 ad=6.25p pd=14.5u as=2.8125p ps=13.4u w=6.25u l=0.28u
X83 b VDD tb VSS nfet_03v3 ad=1p pd=4u as=1p ps=4u w=1u l=0.28u
X84 VSS py4 out_p VSS nfet_03v3 ad=4.8p pd=9.2u as=4.8p ps=9.2u w=8u l=0.28u
X85 VSS VDD VSS VSS nfet_03v3 ad=6p pd=11.2u as=0 ps=0 w=10u l=10u
C0 VDD py3 1.39912f
C1 tb ls 0
C2 ny4 ny3 3.10104f
C3 b t 0.73571f
C4 py1 py3 0.00603f
C5 ny0 ta 0
C6 en_p py3 0
C7 VDD ny3 1.42428f
C8 out_n ny3 0.08017f
C9 ny4 VDD 3.59332f
C10 out_n ny4 2.14292f
C11 t ls 1.38335f
C12 out_n VDD 10.8632f
C13 py0 py3 0
C14 a VDD 1.1105f
C15 VDD py1 0.31684f
C16 ny0 b 1.52226f
C17 VDD en_p 1.91288f
C18 a py1 0
C19 en_n t 0.00471f
C20 a en_p 0.33381f
C21 ny0 ls 0.06938f
C22 en_p py1 0.01669f
C23 VDD py0 0.36165f
C24 t a_4834_1520# 0
C25 a py0 1.51239f
C26 py1 py0 1.35393f
C27 b ta 0.24752f
C28 en_p py0 1.61625f
C29 a_9448_1520# VDD 0
C30 ny0 ny2 0.00602f
C31 py2 out_p 0
C32 ny0 en_n 1.26391f
C33 a_9448_1520# a 0.00915f
C34 tb VDD 0.93681f
C35 a_9448_1520# py1 0
C36 ls ta 0.01915f
C37 py2 py3 1.41154f
C38 a_9448_1520# en_p 0.01543f
C39 tb a 0.11219f
C40 ny0 a_4834_1520# 0.07771f
C41 VDD t 0.49796f
C42 ny0 ny1 1.35334f
C43 tb en_p 0.00253f
C44 a_9448_1520# py0 0.07497f
C45 a t 0.45329f
C46 b ls 0.40078f
C47 VDD py2 0.42847f
C48 ny0 ny3 0
C49 py4 out_p 2.14458f
C50 ny0 ny4 0
C51 a py2 0
C52 py2 py1 1.36352f
C53 ny0 VDD 0.35637f
C54 py4 py3 3.10345f
C55 py2 en_p 0.00231f
C56 ny0 a 0
C57 b en_n 0.29504f
C58 py2 py0 0.00602f
C59 ny2 ls 0
C60 en_n ls 0.43122f
C61 tb t 1.36996f
C62 b a_4834_1520# 0.00888f
C63 VDD py4 3.58597f
C64 b ny1 0.00551f
C65 VDD ta 0.34196f
C66 ls a_4834_1520# 0
C67 py1 py4 0
C68 ls ny1 0.00148f
C69 a ta 1.36616f
C70 ny2 en_n 0.01564f
C71 py4 py0 0
C72 b VDD 1.37403f
C73 ny2 ny1 1.3635f
C74 en_n a_4834_1520# 0.00926f
C75 b a 3.32307f
C76 en_n ny1 0.03101f
C77 ny0 t 0.00734f
C78 VDD ls 1.57899f
C79 b en_p 0.03836f
C80 a ls 0.00617f
C81 ny2 ny3 1.41161f
C82 ny2 ny4 0.00678f
C83 a_4834_1520# ny1 0
C84 out_p py3 0.06951f
C85 b py0 0.00943f
C86 tb ta 0.00604f
C87 en_n ny3 0.0111f
C88 ny2 VDD 0.42942f
C89 out_n ny2 0
C90 VDD en_n 1.55241f
C91 t ta 1.44336f
C92 a_9448_1520# b 0
C93 ny3 ny1 0.00603f
C94 ny4 ny1 0
C95 VDD out_p 10.8686f
C96 VDD a_4834_1520# 0.00141f
C97 tb b 0.52528f
C98 py2 py4 0.00668f
C99 VDD ny1 0.32058f
C100 out_p VSS 7.5575f
C101 en_p VSS 1.04423f
C102 ls VSS 0.94304f
C103 en_n VSS 0.96906f
C104 out_n VSS 7.54955f
C105 VDD VSS 0.29472p
C106 a_9448_1520# VSS 0.13457f
C107 a_4834_1520# VSS 0.13527f
C108 py0 VSS 0.80282f
C109 py1 VSS 0.84746f
C110 tb VSS 1.43825f
C111 a VSS 2.02855f
C112 b VSS 2.81249f
C113 ny0 VSS 0.83789f
C114 ny1 VSS 0.84097f
C115 ta VSS 0.81172f
C116 t VSS 1.29448f
C117 py2 VSS 0.87503f
C118 ny2 VSS 0.88123f
C119 py3 VSS 1.65748f
C120 ny3 VSS 1.64243f
C121 py4 VSS 6.4852f
C122 ny4 VSS 6.46089f
.ends
