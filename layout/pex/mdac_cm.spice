* mdac: magic R+C extraction of layout/mdac.gds (layout/gen/pex.sh)
* 1390 devices merged into 158 instances (layout/gen/pexmerge.py, from mdac_c.spice)
* extracted 2026-11-11T14:15:24+01:00 with magic 8.3.642, mode c, from mdac.gds
.subckt mdac VDD VSS vg vbnf ns30 ns28 ns26 ns24 ns22 ns20 ns18 ns16 ns14 ns12 ns10 ns8 ns6 ns4 ns2 nb4 nb2 nb0 nsd nb1 nb3 ns1 ns3 ns5 ns7 ns9 ns11 ns13 ns15 ns17 ns19 ns21 ns23 ns25 ns27 ns29 ns31
XM0 VDD a_1344_2092# a_546_17710# VDD pfet_03v3 w=1u l=4u m=16 ad=2.90625e-13 as=2.8e-13 pd=1.64375e-06 ps=1.56e-06
XM1 VDD a_1344_2092# VDD VDD pfet_03v3 w=1u l=4u m=160 ad=2.8e-13 as=2.60288e-12 pd=1.56e-06 ps=1.46932e-05
XM2 VDD a_1344_2092# a_1344_2092# VDD pfet_03v3 w=1u l=4u m=32 ad=2.90625e-13 as=2.8e-13 pd=1.64375e-06 ps=1.56e-06
XM3 a_546_17710# a_1344_2092# VDD VDD pfet_03v3 w=1u l=4u m=16 ad=2.8e-13 as=2.90625e-13 pd=1.56e-06 ps=1.64375e-06
XM4 VDD a_1344_2092# a_546_18626# VDD pfet_03v3 w=1u l=4u m=16 ad=2.90625e-13 as=2.8e-13 pd=1.64375e-06 ps=1.56e-06
XM5 VDD a_1344_2092# a_546_14962# VDD pfet_03v3 w=1u l=4u m=16 ad=2.90625e-13 as=2.8e-13 pd=1.64375e-06 ps=1.56e-06
XM6 a_546_18626# a_1344_2092# VDD VDD pfet_03v3 w=1u l=4u m=16 ad=2.8e-13 as=2.90625e-13 pd=1.56e-06 ps=1.64375e-06
XM7 VDD a_1344_2092# a_546_15878# VDD pfet_03v3 w=1u l=4u m=16 ad=2.90625e-13 as=2.8e-13 pd=1.64375e-06 ps=1.56e-06
XM8 a_546_12214# nb3 a_400_3054# VDD pfet_03v3 w=1u l=0.28u m=1 ad=2.8e-13 as=4.5e-13 pd=1.56e-06 ps=2.9e-06
XM9 VDD a_1344_2092# a_546_3454# VDD pfet_03v3 w=1u l=4u m=16 ad=2.90625e-13 as=2.8e-13 pd=1.64375e-06 ps=1.56e-06
XM10 a_1344_2092# a_1344_2092# VDD VDD pfet_03v3 w=1u l=4u m=32 ad=2.8e-13 as=2.90625e-13 pd=1.56e-06 ps=1.64375e-06
XM11 a_546_3454# a_1344_2092# VDD VDD pfet_03v3 w=1u l=4u m=16 ad=2.8e-13 as=2.90625e-13 pd=1.56e-06 ps=1.64375e-06
XM12 a_546_19542# a_1344_2092# VDD VDD pfet_03v3 w=1u l=4u m=16 ad=2.8e-13 as=2.90625e-13 pd=1.56e-06 ps=1.64375e-06
XM13 VDD a_1344_2092# a_546_12614# VDD pfet_03v3 w=1u l=4u m=16 ad=2.90625e-13 as=2.8e-13 pd=1.64375e-06 ps=1.56e-06
XM14 a_546_7634# a_1344_2092# VDD VDD pfet_03v3 w=1u l=4u m=16 ad=2.8e-13 as=2.90625e-13 pd=1.56e-06 ps=1.64375e-06
XM15 a_546_15362# a_1344_2092# VDD VDD pfet_03v3 w=1u l=4u m=16 ad=2.8e-13 as=2.90625e-13 pd=1.56e-06 ps=1.64375e-06
XM16 VDD a_1344_2092# a_546_7634# VDD pfet_03v3 w=1u l=4u m=16 ad=2.90625e-13 as=2.8e-13 pd=1.64375e-06 ps=1.56e-06
XM17 a_546_12214# a_1344_2092# VDD VDD pfet_03v3 w=1u l=4u m=4 ad=2.8e-13 as=3.225e-13 pd=1.56e-06 ps=1.895e-06
XM18 VDD a_1344_2092# a_546_3054# VDD pfet_03v3 w=1u l=4u m=16 ad=2.90625e-13 as=2.8e-13 pd=1.64375e-06 ps=1.56e-06
XM19 a_546_5802# ns18 a_400_3054# VDD pfet_03v3 w=1u l=0.28u m=1 ad=2.8e-13 as=4.5e-13 pd=1.56e-06 ps=2.9e-06
XM20 a_546_16278# a_1344_2092# VDD VDD pfet_03v3 w=1u l=4u m=16 ad=2.8e-13 as=2.90625e-13 pd=1.56e-06 ps=1.64375e-06
XM21 a_546_6718# ns14 a_400_3054# VDD pfet_03v3 w=1u l=0.28u m=1 ad=2.8e-13 as=4.5e-13 pd=1.56e-06 ps=2.9e-06
XM22 VDD a_1344_2092# a_546_3970# VDD pfet_03v3 w=1u l=4u m=16 ad=2.90625e-13 as=2.8e-13 pd=1.64375e-06 ps=1.56e-06
XM23 a_546_3970# a_1344_2092# VDD VDD pfet_03v3 w=1u l=4u m=16 ad=2.8e-13 as=2.90625e-13 pd=1.56e-06 ps=1.64375e-06
XM24 VDD a_1344_2092# a_546_8950# VDD pfet_03v3 w=1u l=4u m=16 ad=2.90625e-13 as=2.8e-13 pd=1.64375e-06 ps=1.56e-06
XM25 VDD a_1344_2092# a_546_4886# VDD pfet_03v3 w=1u l=4u m=16 ad=2.90625e-13 as=2.8e-13 pd=1.64375e-06 ps=1.56e-06
XM26 a_546_4886# a_1344_2092# VDD VDD pfet_03v3 w=1u l=4u m=16 ad=2.8e-13 as=2.90625e-13 pd=1.56e-06 ps=1.64375e-06
XM27 VDD a_1344_2092# a_546_9866# VDD pfet_03v3 w=1u l=4u m=8 ad=2.8e-13 as=2.8e-13 pd=1.56e-06 ps=1.56e-06
XM28 VDD a_1344_2092# a_546_4370# VDD pfet_03v3 w=1u l=4u m=16 ad=2.90625e-13 as=2.8e-13 pd=1.64375e-06 ps=1.56e-06
XM29 a_546_5802# a_1344_2092# VDD VDD pfet_03v3 w=1u l=4u m=16 ad=2.8e-13 as=2.90625e-13 pd=1.56e-06 ps=1.64375e-06
XM30 a_546_14962# a_1344_2092# VDD VDD pfet_03v3 w=1u l=4u m=16 ad=2.8e-13 as=2.90625e-13 pd=1.56e-06 ps=1.64375e-06
XM31 a_546_4370# a_1344_2092# VDD VDD pfet_03v3 w=1u l=4u m=16 ad=2.8e-13 as=2.90625e-13 pd=1.56e-06 ps=1.64375e-06
XM32 VDD a_1344_2092# a_546_5286# VDD pfet_03v3 w=1u l=4u m=16 ad=2.90625e-13 as=2.8e-13 pd=1.64375e-06 ps=1.56e-06
XM33 a_546_5286# a_1344_2092# VDD VDD pfet_03v3 w=1u l=4u m=16 ad=2.8e-13 as=2.90625e-13 pd=1.56e-06 ps=1.64375e-06
XM34 a_546_6718# a_1344_2092# VDD VDD pfet_03v3 w=1u l=4u m=16 ad=2.8e-13 as=2.90625e-13 pd=1.56e-06 ps=1.64375e-06
XM35 VDD a_1344_2092# a_546_17194# VDD pfet_03v3 w=1u l=4u m=16 ad=2.90625e-13 as=2.8e-13 pd=1.64375e-06 ps=1.56e-06
XM36 a_546_15878# a_1344_2092# VDD VDD pfet_03v3 w=1u l=4u m=16 ad=2.8e-13 as=2.90625e-13 pd=1.56e-06 ps=1.64375e-06
XM37 VDD a_1344_2092# a_546_15362# VDD pfet_03v3 w=1u l=4u m=16 ad=2.90625e-13 as=2.8e-13 pd=1.64375e-06 ps=1.56e-06
XM38 a_546_8550# a_1344_2092# VDD VDD pfet_03v3 w=1u l=4u m=16 ad=2.8e-13 as=2.90625e-13 pd=1.56e-06 ps=1.64375e-06
XM39 VDD a_1344_2092# a_546_8550# VDD pfet_03v3 w=1u l=4u m=16 ad=2.90625e-13 as=2.8e-13 pd=1.64375e-06 ps=1.56e-06
XM40 VDD a_1344_2092# a_546_16278# VDD pfet_03v3 w=1u l=4u m=16 ad=2.90625e-13 as=2.8e-13 pd=1.64375e-06 ps=1.56e-06
XM41 VDD a_1344_2092# a_546_9466# VDD pfet_03v3 w=1u l=4u m=16 ad=2.90625e-13 as=2.8e-13 pd=1.64375e-06 ps=1.56e-06
XM42 VDD a_1344_2092# a_546_19542# VDD pfet_03v3 w=1u l=4u m=16 ad=2.90625e-13 as=2.8e-13 pd=1.64375e-06 ps=1.56e-06
XM43 a_546_9466# a_1344_2092# VDD VDD pfet_03v3 w=1u l=4u m=16 ad=2.8e-13 as=2.90625e-13 pd=1.56e-06 ps=1.64375e-06
XM44 VDD a_1344_2092# a_546_18110# VDD pfet_03v3 w=1u l=4u m=16 ad=2.90625e-13 as=2.8e-13 pd=1.64375e-06 ps=1.56e-06
XM45 VDD a_1344_2092# a_546_19026# VDD pfet_03v3 w=1u l=4u m=16 ad=2.90625e-13 as=2.8e-13 pd=1.64375e-06 ps=1.56e-06
XM46 a_210_350# a_400_3054# a_546_8950# VDD pfet_03v3 w=1u l=0.28u m=1 ad=1.2e-12 as=2.8e-13 pd=4.4e-06 ps=1.56e-06
XM47 a_546_8034# a_1344_2092# VDD VDD pfet_03v3 w=1u l=4u m=16 ad=2.8e-13 as=2.90625e-13 pd=1.56e-06 ps=1.64375e-06
XM48 a_210_350# a_400_3054# a_546_9866# VDD pfet_03v3 w=1u l=0.28u m=1 ad=1.2e-12 as=2.8e-13 pd=4.4e-06 ps=1.56e-06
XM49 a_546_16794# a_1344_2092# VDD VDD pfet_03v3 w=1u l=4u m=16 ad=2.8e-13 as=2.90625e-13 pd=1.56e-06 ps=1.64375e-06
XM50 VDD a_1344_2092# a_546_16794# VDD pfet_03v3 w=1u l=4u m=16 ad=2.90625e-13 as=2.8e-13 pd=1.64375e-06 ps=1.56e-06
XM51 a_546_13530# a_1344_2092# VDD VDD pfet_03v3 w=1u l=4u m=16 ad=2.8e-13 as=2.90625e-13 pd=1.56e-06 ps=1.64375e-06
XM52 a_546_14446# a_1344_2092# VDD VDD pfet_03v3 w=1u l=4u m=16 ad=2.8e-13 as=2.90625e-13 pd=1.56e-06 ps=1.64375e-06
XM53 a_546_13530# ns5 a_400_3054# VDD pfet_03v3 w=1u l=0.28u m=1 ad=2.8e-13 as=4.5e-13 pd=1.56e-06 ps=2.9e-06
XM54 a_546_14446# ns9 a_400_3054# VDD pfet_03v3 w=1u l=0.28u m=1 ad=2.8e-13 as=4.5e-13 pd=1.56e-06 ps=2.9e-06
XM55 VSS a_400_3054# a_400_3054# VSS nfet_03v3 w=1.2u l=5.335u m=15 ad=3.496e-13 as=3.36e-13 pd=1.86267e-06 ps=1.76e-06
XM56 a_210_350# a_400_3054# a_546_17194# VDD pfet_03v3 w=1u l=0.28u m=1 ad=1.2e-12 as=2.8e-13 pd=4.4e-06 ps=1.56e-06
XM57 VDD a_1344_2092# a_546_13530# VDD pfet_03v3 w=1u l=4u m=16 ad=2.90625e-13 as=2.8e-13 pd=1.64375e-06 ps=1.56e-06
XM58 a_546_8950# a_1344_2092# VDD VDD pfet_03v3 w=1u l=4u m=16 ad=2.8e-13 as=2.90625e-13 pd=1.56e-06 ps=1.64375e-06
XM59 VDD a_1344_2092# a_546_14446# VDD pfet_03v3 w=1u l=4u m=16 ad=2.90625e-13 as=2.8e-13 pd=1.64375e-06 ps=1.56e-06
XM60 a_400_3054# a_1344_2092# VDD VDD pfet_03v3 w=1u l=4u m=16 ad=2.8e-13 as=2.90625e-13 pd=1.56e-06 ps=1.64375e-06
XM61 VDD a_1344_2092# a_546_5802# VDD pfet_03v3 w=1u l=4u m=16 ad=2.90625e-13 as=2.8e-13 pd=1.64375e-06 ps=1.56e-06
XM62 a_546_13130# a_1344_2092# VDD VDD pfet_03v3 w=1u l=4u m=16 ad=2.8e-13 as=2.90625e-13 pd=1.56e-06 ps=1.64375e-06
XM63 VDD a_1344_2092# a_546_6718# VDD pfet_03v3 w=1u l=4u m=16 ad=2.90625e-13 as=2.8e-13 pd=1.64375e-06 ps=1.56e-06
XM64 a_546_14046# a_1344_2092# VDD VDD pfet_03v3 w=1u l=4u m=16 ad=2.8e-13 as=2.90625e-13 pd=1.56e-06 ps=1.64375e-06
XM65 VDD a_1344_2092# a_546_6202# VDD pfet_03v3 w=1u l=4u m=16 ad=2.90625e-13 as=2.8e-13 pd=1.64375e-06 ps=1.56e-06
XM66 a_546_6202# a_1344_2092# VDD VDD pfet_03v3 w=1u l=4u m=16 ad=2.8e-13 as=2.90625e-13 pd=1.56e-06 ps=1.64375e-06
XM67 a_546_7118# a_1344_2092# VDD VDD pfet_03v3 w=1u l=4u m=16 ad=2.8e-13 as=2.90625e-13 pd=1.56e-06 ps=1.64375e-06
XM68 VDD a_1344_2092# a_546_7118# VDD pfet_03v3 w=1u l=4u m=16 ad=2.90625e-13 as=2.8e-13 pd=1.64375e-06 ps=1.56e-06
XM69 a_210_350# a_400_3054# a_546_10782# VDD pfet_03v3 w=1u l=0.28u m=1 ad=1.2e-12 as=2.8e-13 pd=4.4e-06 ps=1.56e-06
XM70 a_546_17194# a_1344_2092# VDD VDD pfet_03v3 w=1u l=4u m=16 ad=2.8e-13 as=2.90625e-13 pd=1.56e-06 ps=1.64375e-06
XM71 VDD a_1344_2092# a_546_13130# VDD pfet_03v3 w=1u l=4u m=16 ad=2.90625e-13 as=2.8e-13 pd=1.64375e-06 ps=1.56e-06
XM72 a_210_350# a_400_3054# a_546_11698# VDD pfet_03v3 w=1u l=0.28u m=1 ad=1.2e-12 as=2.8e-13 pd=4.4e-06 ps=1.56e-06
XM73 a_400_3054# a_400_3054# VSS VSS nfet_03v3 w=1.2u l=5.335u m=15 ad=3.36e-13 as=3.632e-13 pd=1.76e-06 ps=1.96533e-06
XM74 a_546_3054# a_1344_2092# VDD VDD pfet_03v3 w=1u l=4u m=16 ad=2.8e-13 as=2.90625e-13 pd=1.56e-06 ps=1.64375e-06
XM75 VDD a_1344_2092# a_546_14046# VDD pfet_03v3 w=1u l=4u m=16 ad=2.90625e-13 as=2.8e-13 pd=1.64375e-06 ps=1.56e-06
XM76 VDD a_1344_2092# a_546_8034# VDD pfet_03v3 w=1u l=4u m=16 ad=2.90625e-13 as=2.8e-13 pd=1.64375e-06 ps=1.56e-06
XM77 a_210_350# a_400_3054# a_546_3454# VDD pfet_03v3 w=1u l=0.28u m=1 ad=1.2e-12 as=2.8e-13 pd=4.4e-06 ps=1.56e-06
XM78 a_546_8034# ns8 a_400_3054# VDD pfet_03v3 w=1u l=0.28u m=1 ad=2.8e-13 as=4.5e-13 pd=1.56e-06 ps=2.9e-06
XM79 a_210_350# a_400_3054# a_546_18110# VDD pfet_03v3 w=1u l=0.28u m=1 ad=1.2e-12 as=2.8e-13 pd=4.4e-06 ps=1.56e-06
XM80 a_210_350# a_400_3054# a_546_19026# VDD pfet_03v3 w=1u l=0.28u m=1 ad=1.2e-12 as=2.8e-13 pd=4.4e-06 ps=1.56e-06
XM81 VDD a_1344_2092# a_400_3054# VDD pfet_03v3 w=1u l=4u m=16 ad=2.90625e-13 as=2.8e-13 pd=1.64375e-06 ps=1.56e-06
XM82 a_546_18110# a_1344_2092# VDD VDD pfet_03v3 w=1u l=4u m=16 ad=2.8e-13 as=2.90625e-13 pd=1.56e-06 ps=1.64375e-06
XM83 a_210_350# a_400_3054# a_546_12614# VDD pfet_03v3 w=1u l=0.28u m=1 ad=1.2e-12 as=2.8e-13 pd=4.4e-06 ps=1.56e-06
XM84 a_546_19026# a_1344_2092# VDD VDD pfet_03v3 w=1u l=4u m=16 ad=2.8e-13 as=2.90625e-13 pd=1.56e-06 ps=1.64375e-06
XM85 a_546_9866# a_1344_2092# VDD VDD pfet_03v3 w=1u l=4u m=8 ad=2.8e-13 as=3.0125e-13 pd=1.56e-06 ps=1.7275e-06
XM86 VDD a_1344_2092# a_546_10382# VDD pfet_03v3 w=1u l=4u m=2 ad=2.8e-13 as=2.8e-13 pd=1.56e-06 ps=1.56e-06
XM87 a_546_12614# a_1344_2092# VDD VDD pfet_03v3 w=1u l=4u m=16 ad=2.8e-13 as=2.90625e-13 pd=1.56e-06 ps=1.64375e-06
XM88 a_546_19542# ns31 a_400_3054# VDD pfet_03v3 w=1u l=0.28u m=1 ad=2.8e-13 as=4.5e-13 pd=1.56e-06 ps=2.9e-06
XM89 VDD a_1344_2092# a_546_12214# VDD pfet_03v3 w=1u l=4u m=4 ad=2.8e-13 as=2.8e-13 pd=1.56e-06 ps=1.56e-06
XM90 a_210_350# a_400_3054# a_546_16794# VDD pfet_03v3 w=1u l=0.28u m=1 ad=1.2e-12 as=2.8e-13 pd=4.4e-06 ps=1.56e-06
XM91 a_210_350# a_400_3054# a_546_8550# VDD pfet_03v3 w=1u l=0.28u m=1 ad=1.2e-12 as=2.8e-13 pd=4.4e-06 ps=1.56e-06
XM92 a_210_350# a_400_3054# a_546_9466# VDD pfet_03v3 w=1u l=0.28u m=1 ad=1.2e-12 as=2.8e-13 pd=4.4e-06 ps=1.56e-06
XM93 a_546_13130# ns3 a_400_3054# VDD pfet_03v3 w=1u l=0.28u m=1 ad=2.8e-13 as=4.5e-13 pd=1.56e-06 ps=2.9e-06
XM94 a_546_14046# ns7 a_400_3054# VDD pfet_03v3 w=1u l=0.28u m=1 ad=2.8e-13 as=4.5e-13 pd=1.56e-06 ps=2.9e-06
XM95 a_546_7634# ns10 a_400_3054# VDD pfet_03v3 w=1u l=0.28u m=1 ad=2.8e-13 as=4.5e-13 pd=1.56e-06 ps=2.9e-06
XM96 a_210_350# a_400_3054# a_546_17710# VDD pfet_03v3 w=1u l=0.28u m=1 ad=1.2e-12 as=2.8e-13 pd=4.4e-06 ps=1.56e-06
XM97 a_210_350# a_400_3054# a_546_18626# VDD pfet_03v3 w=1u l=0.28u m=1 ad=1.2e-12 as=2.8e-13 pd=4.4e-06 ps=1.56e-06
XM98 a_210_350# a_400_3054# a_546_10382# VDD pfet_03v3 w=1u l=0.28u m=1 ad=1.2e-12 as=2.8e-13 pd=4.4e-06 ps=1.56e-06
XM99 a_210_350# a_400_3054# a_546_11298# VDD pfet_03v3 w=1u l=0.28u m=1 ad=1.2e-12 as=2.8e-13 pd=4.4e-06 ps=1.56e-06
XM100 a_210_350# a_400_3054# a_546_3054# VDD pfet_03v3 w=1u l=0.28u m=1 ad=1.2e-12 as=2.8e-13 pd=4.4e-06 ps=1.56e-06
XM101 a_210_350# a_210_350# VSS VSS nfet_03v3 w=3.4u l=1u m=1 ad=9.52e-13 as=1.53e-12 pd=3.96e-06 ps=7.7e-06
XM102 a_546_15362# ns13 a_400_3054# VDD pfet_03v3 w=1u l=0.28u m=1 ad=2.8e-13 as=4.5e-13 pd=1.56e-06 ps=2.9e-06
XM103 a_546_16278# ns17 a_400_3054# VDD pfet_03v3 w=1u l=0.28u m=1 ad=2.8e-13 as=4.5e-13 pd=1.56e-06 ps=2.9e-06
XM104 a_546_8950# ns4 a_400_3054# VDD pfet_03v3 w=1u l=0.28u m=1 ad=2.8e-13 as=4.5e-13 pd=1.56e-06 ps=2.9e-06
XM105 a_546_9866# nb4 a_400_3054# VDD pfet_03v3 w=1u l=0.28u m=1 ad=2.8e-13 as=4.5e-13 pd=1.56e-06 ps=2.9e-06
XM106 a_210_350# a_400_3054# a_546_12214# VDD pfet_03v3 w=1u l=0.28u m=1 ad=1.2e-12 as=2.8e-13 pd=4.4e-06 ps=1.56e-06
XM107 a_546_10382# a_1344_2092# VDD VDD pfet_03v3 w=1u l=4u m=2 ad=2.8e-13 as=3.65e-13 pd=1.56e-06 ps=2.23e-06
XM108 a_210_350# a_400_3054# a_546_4370# VDD pfet_03v3 w=1u l=0.28u m=1 ad=1.2e-12 as=2.8e-13 pd=4.4e-06 ps=1.56e-06
XM109 a_210_350# a_400_3054# a_546_5286# VDD pfet_03v3 w=1u l=0.28u m=1 ad=1.2e-12 as=2.8e-13 pd=4.4e-06 ps=1.56e-06
XM110 a_546_3454# ns28 a_400_3054# VDD pfet_03v3 w=1u l=0.28u m=1 ad=2.8e-13 as=4.5e-13 pd=1.56e-06 ps=2.9e-06
XM111 a_210_350# a_400_3054# a_546_13530# VDD pfet_03v3 w=1u l=0.28u m=1 ad=1.2e-12 as=2.8e-13 pd=4.4e-06 ps=1.56e-06
XM112 a_210_350# a_400_3054# a_546_14446# VDD pfet_03v3 w=1u l=0.28u m=1 ad=1.2e-12 as=2.8e-13 pd=4.4e-06 ps=1.56e-06
XM113 a_210_350# a_400_3054# a_546_6202# VDD pfet_03v3 w=1u l=0.28u m=1 ad=1.2e-12 as=2.8e-13 pd=4.4e-06 ps=1.56e-06
XM114 a_210_350# a_400_3054# a_546_7118# VDD pfet_03v3 w=1u l=0.28u m=1 ad=1.2e-12 as=2.8e-13 pd=4.4e-06 ps=1.56e-06
XM115 a_546_14962# ns11 a_400_3054# VDD pfet_03v3 w=1u l=0.28u m=1 ad=2.8e-13 as=4.5e-13 pd=1.56e-06 ps=2.9e-06
XM116 a_546_15878# ns15 a_400_3054# VDD pfet_03v3 w=1u l=0.28u m=1 ad=2.8e-13 as=4.5e-13 pd=1.56e-06 ps=2.9e-06
XM117 vg a_400_3054# VSS VSS nfet_03v3 w=1.2u l=5.335u m=2 ad=4.38e-13 as=3.36e-13 pd=2.53e-06 ps=1.76e-06
XM118 VSS a_210_350# a_210_350# VSS nfet_03v3 w=3.4u l=1u m=1 ad=1.53e-12 as=9.52e-13 pd=7.7e-06 ps=3.96e-06
XM119 a_210_350# a_400_3054# a_546_3970# VDD pfet_03v3 w=1u l=0.28u m=1 ad=1.2e-12 as=2.8e-13 pd=4.4e-06 ps=1.56e-06
XM120 a_210_350# a_400_3054# a_546_4886# VDD pfet_03v3 w=1u l=0.28u m=1 ad=1.2e-12 as=2.8e-13 pd=4.4e-06 ps=1.56e-06
XM121 a_546_8550# ns6 a_400_3054# VDD pfet_03v3 w=1u l=0.28u m=1 ad=2.8e-13 as=4.5e-13 pd=1.56e-06 ps=2.9e-06
XM122 a_546_9466# ns2 a_400_3054# VDD pfet_03v3 w=1u l=0.28u m=1 ad=2.8e-13 as=4.5e-13 pd=1.56e-06 ps=2.9e-06
XM123 a_210_350# a_400_3054# a_546_19542# VDD pfet_03v3 w=1u l=0.28u m=1 ad=1.2e-12 as=2.8e-13 pd=4.4e-06 ps=1.56e-06
XM124 a_1344_2092# vbnf VSS VSS nfet_03v3 w=1.2u l=5.335u m=1 ad=5.4e-13 as=5.4e-13 pd=3.3e-06 ps=3.3e-06
XM125 a_210_350# a_400_3054# a_546_5802# VDD pfet_03v3 w=1u l=0.28u m=1 ad=1.2e-12 as=2.8e-13 pd=4.4e-06 ps=1.56e-06
XM126 a_546_17194# ns21 a_400_3054# VDD pfet_03v3 w=1u l=0.28u m=1 ad=2.8e-13 as=4.5e-13 pd=1.56e-06 ps=2.9e-06
XM127 a_210_350# a_400_3054# a_546_6718# VDD pfet_03v3 w=1u l=0.28u m=1 ad=1.2e-12 as=2.8e-13 pd=4.4e-06 ps=1.56e-06
XM128 a_546_3054# ns30 a_400_3054# VDD pfet_03v3 w=1u l=0.28u m=1 ad=2.8e-13 as=4.5e-13 pd=1.56e-06 ps=2.9e-06
XM129 a_210_350# a_400_3054# a_546_13130# VDD pfet_03v3 w=1u l=0.28u m=1 ad=1.2e-12 as=2.8e-13 pd=4.4e-06 ps=1.56e-06
XM130 a_210_350# a_400_3054# a_546_14046# VDD pfet_03v3 w=1u l=0.28u m=1 ad=1.2e-12 as=2.8e-13 pd=4.4e-06 ps=1.56e-06
XM131 a_546_10782# nb0 a_400_3054# VDD pfet_03v3 w=1u l=0.28u m=1 ad=2.8e-13 as=4.5e-13 pd=1.56e-06 ps=2.9e-06
XM132 a_546_11698# nb1 a_400_3054# VDD pfet_03v3 w=1u l=0.28u m=1 ad=2.8e-13 as=4.5e-13 pd=1.56e-06 ps=2.9e-06
XM133 VDD a_1344_2092# a_546_10782# VDD pfet_03v3 w=1u l=4u m=1 ad=2.8e-13 as=4.5e-13 pd=1.56e-06 ps=2.9e-06
XM134 a_546_11698# a_1344_2092# VDD VDD pfet_03v3 w=1u l=4u m=1 ad=2.8e-13 as=4.5e-13 pd=1.56e-06 ps=2.9e-06
XM135 a_546_18110# ns25 a_400_3054# VDD pfet_03v3 w=1u l=0.28u m=1 ad=2.8e-13 as=4.5e-13 pd=1.56e-06 ps=2.9e-06
XM136 a_546_19026# ns29 a_400_3054# VDD pfet_03v3 w=1u l=0.28u m=1 ad=2.8e-13 as=4.5e-13 pd=1.56e-06 ps=2.9e-06
XM137 a_546_4370# ns24 a_400_3054# VDD pfet_03v3 w=1u l=0.28u m=1 ad=2.8e-13 as=4.5e-13 pd=1.56e-06 ps=2.9e-06
XM138 a_546_5286# ns20 a_400_3054# VDD pfet_03v3 w=1u l=0.28u m=1 ad=2.8e-13 as=4.5e-13 pd=1.56e-06 ps=2.9e-06
XM139 a_546_12614# ns1 a_400_3054# VDD pfet_03v3 w=1u l=0.28u m=1 ad=2.8e-13 as=4.5e-13 pd=1.56e-06 ps=2.9e-06
XM140 a_210_350# a_400_3054# a_546_15362# VDD pfet_03v3 w=1u l=0.28u m=1 ad=1.2e-12 as=2.8e-13 pd=4.4e-06 ps=1.56e-06
XM141 a_210_350# a_400_3054# a_546_16278# VDD pfet_03v3 w=1u l=0.28u m=1 ad=1.2e-12 as=2.8e-13 pd=4.4e-06 ps=1.56e-06
XM142 a_210_350# a_400_3054# a_546_8034# VDD pfet_03v3 w=1u l=0.28u m=1 ad=1.2e-12 as=2.8e-13 pd=4.4e-06 ps=1.56e-06
XM143 a_546_6202# ns16 a_400_3054# VDD pfet_03v3 w=1u l=0.28u m=1 ad=2.8e-13 as=4.5e-13 pd=1.56e-06 ps=2.9e-06
XM144 a_546_7118# ns12 a_400_3054# VDD pfet_03v3 w=1u l=0.28u m=1 ad=2.8e-13 as=4.5e-13 pd=1.56e-06 ps=2.9e-06
XM145 VSS a_400_3054# vg VSS nfet_03v3 w=1.2u l=5.335u m=1 ad=3.36e-13 as=3.36e-13 pd=1.76e-06 ps=1.76e-06
XM146 a_546_16794# ns19 a_400_3054# VDD pfet_03v3 w=1u l=0.28u m=1 ad=2.8e-13 as=4.5e-13 pd=1.56e-06 ps=2.9e-06
XM147 a_546_17710# ns23 a_400_3054# VDD pfet_03v3 w=1u l=0.28u m=1 ad=2.8e-13 as=4.5e-13 pd=1.56e-06 ps=2.9e-06
XM148 a_546_18626# ns27 a_400_3054# VDD pfet_03v3 w=1u l=0.28u m=1 ad=2.8e-13 as=4.5e-13 pd=1.56e-06 ps=2.9e-06
XM149 a_546_10382# nb2 a_400_3054# VDD pfet_03v3 w=1u l=0.28u m=1 ad=2.8e-13 as=4.5e-13 pd=1.56e-06 ps=2.9e-06
XM150 a_546_11298# nsd a_400_3054# VDD pfet_03v3 w=1u l=0.28u m=1 ad=2.8e-13 as=4.5e-13 pd=1.56e-06 ps=2.9e-06
XM151 VDD a_1344_2092# a_546_11698# VDD pfet_03v3 w=1u l=4u m=1 ad=2.8e-13 as=2.8e-13 pd=1.56e-06 ps=1.56e-06
XM152 a_546_3970# ns26 a_400_3054# VDD pfet_03v3 w=1u l=0.28u m=1 ad=2.8e-13 as=4.5e-13 pd=1.56e-06 ps=2.9e-06
XM153 a_546_4886# ns22 a_400_3054# VDD pfet_03v3 w=1u l=0.28u m=1 ad=2.8e-13 as=4.5e-13 pd=1.56e-06 ps=2.9e-06
XM154 VDD a_1344_2092# a_546_11298# VDD pfet_03v3 w=1u l=4u m=1 ad=2.8e-13 as=4.5e-13 pd=1.56e-06 ps=2.9e-06
XM155 a_210_350# a_400_3054# a_546_14962# VDD pfet_03v3 w=1u l=0.28u m=1 ad=1.2e-12 as=2.8e-13 pd=4.4e-06 ps=1.56e-06
XM156 a_210_350# a_400_3054# a_546_15878# VDD pfet_03v3 w=1u l=0.28u m=1 ad=1.2e-12 as=2.8e-13 pd=4.4e-06 ps=1.56e-06
XM157 a_210_350# a_400_3054# a_546_7634# VDD pfet_03v3 w=1u l=0.28u m=1 ad=1.2e-12 as=2.8e-13 pd=4.4e-06 ps=1.56e-06
C0 a_546_12214# a_1344_2092# 1.40353f
C1 ns15 a_210_350# 0.0057f
C2 ns7 ns5 0.31364f
C3 a_546_8550# a_1344_2092# 4.84882f
C4 a_546_6202# a_546_6718# 2.81004f
C5 a_546_4370# ns26 0
C6 ns16 ns18 0.03875f
C7 a_400_3054# a_546_16794# 0.20887f
C8 ns11 a_210_350# 0.0057f
C9 a_546_16278# ns17 0.01017f
C10 a_400_3054# nsd 0.10249f
C11 a_1344_2092# a_210_350# 0.85523f
C12 a_546_13530# ns3 0
C13 ns30 ns28 0.03875f
C14 a_400_3054# ns30 0.13243f
C15 a_546_15878# VDD 3.7311f
C16 ns23 a_400_3054# 0.10249f
C17 a_1344_2092# a_546_3454# 4.84893f
C18 a_546_14446# a_546_14046# 3.92235f
C19 a_546_7118# a_1344_2092# 4.84882f
C20 a_546_6718# VDD 3.7311f
C21 a_1344_2092# a_546_19542# 8.60519f
C22 a_546_9866# a_400_3054# 0.20887f
C23 ns2 a_210_350# 0.0057f
C24 nb0 nb2 0.03875f
C25 ns1 a_400_3054# 0.10249f
C26 a_546_6202# VDD 3.7311f
C27 a_546_13130# a_210_350# 0.18749f
C28 a_546_9466# a_546_8950# 2.81004f
C29 ns21 VDD 0.17433f
C30 a_546_12614# VDD 4.51189f
C31 a_546_10782# a_546_11698# 0
C32 a_546_17710# a_546_18110# 3.92235f
C33 a_546_10782# nb2 0
C34 a_546_14046# a_210_350# 0.18749f
C35 ns2 ns4 0.31364f
C36 ns27 a_210_350# 0.0057f
C37 a_546_9866# nb4 0.01017f
C38 a_546_10382# a_546_9866# 0.34912f
C39 a_1344_2092# vg 1.03458f
C40 a_400_3054# ns19 0.10249f
C41 a_546_17194# a_1344_2092# 4.84882f
C42 ns13 a_546_15362# 0.01017f
C43 ns29 VDD 0.17527f
C44 a_546_11698# a_1344_2092# 0.24594f
C45 a_400_3054# nb3 0.10249f
C46 a_546_18626# a_546_18110# 2.81004f
C47 a_546_3970# VDD 3.7311f
C48 a_546_11298# VDD 0.16947f
C49 a_546_4370# a_1344_2092# 4.84882f
C50 ns5 a_546_13130# 0
C51 ns25 VDD 0.17433f
C52 ns15 ns17 0.03875f
C53 ns9 ns7 0.03875f
C54 a_546_18626# a_546_19026# 3.92235f
C55 ns13 a_546_14962# 0
C56 a_546_15878# a_210_350# 0.18749f
C57 VDD ns6 0.17433f
C58 a_400_3054# ns24 0.10249f
C59 a_546_6718# a_210_350# 0.18749f
C60 VDD ns10 0.17433f
C61 ns11 a_546_15362# 0
C62 a_1344_2092# a_546_4886# 4.84882f
C63 a_1344_2092# a_546_15362# 4.84882f
C64 a_546_12214# a_546_12614# 0.95694f
C65 a_400_3054# ns12 0.10249f
C66 nb1 a_546_11298# 0
C67 nb1 VDD 0.17433f
C68 a_546_16794# ns19 0.01017f
C69 a_1344_2092# a_546_8034# 4.84882f
C70 ns9 ns11 0.31364f
C71 a_546_14446# VDD 3.7311f
C72 a_546_9466# a_400_3054# 0.20887f
C73 a_546_6202# a_210_350# 0.18749f
C74 a_546_7118# a_546_6718# 3.92235f
C75 a_546_16278# a_400_3054# 0.20887f
C76 a_546_13130# ns3 0.01017f
C77 ns11 a_546_14962# 0.01017f
C78 a_546_17710# a_400_3054# 0.20887f
C79 ns21 a_210_350# 0.0057f
C80 a_546_12614# a_210_350# 0.18749f
C81 a_546_6718# ns14 0.01017f
C82 a_1344_2092# a_546_14962# 4.84882f
C83 ns26 ns28 0.31364f
C84 a_400_3054# ns26 0.10249f
C85 a_400_3054# a_546_13530# 0.20887f
C86 a_1344_2092# a_546_18110# 4.84882f
C87 VDD ns20 0.17433f
C88 a_546_8950# a_1344_2092# 4.84882f
C89 a_546_12214# VDD 1.01612f
C90 a_546_8550# VDD 3.7311f
C91 a_546_9466# nb4 0
C92 a_400_3054# a_546_18626# 0.20887f
C93 a_1344_2092# a_546_19026# 4.84903f
C94 ns29 a_210_350# 0.0057f
C95 a_1344_2092# vbnf 0.76826f
C96 a_546_11298# a_210_350# 0.21108f
C97 a_546_3970# a_210_350# 0.18749f
C98 VDD a_210_350# 4.14621f
C99 ns25 a_210_350# 0.0057f
C100 a_546_6202# ns16 0.01017f
C101 ns1 nb3 0.03875f
C102 a_546_8550# ns6 0.01017f
C103 a_546_3970# a_546_3454# 2.81004f
C104 a_400_3054# ns13 0.10249f
C105 a_546_3454# VDD 3.7311f
C106 a_546_3054# ns28 0
C107 a_400_3054# ns18 0.10249f
C108 a_400_3054# ns7 0.10249f
C109 VDD ns4 0.17433f
C110 a_546_7118# VDD 3.7311f
C111 ns9 a_546_14046# 0
C112 a_546_16278# a_546_16794# 2.81004f
C113 a_210_350# ns6 0.0057f
C114 a_546_3054# a_400_3054# 3.0073f
C115 a_400_3054# nb0 0.10249f
C116 VDD ns14 0.17433f
C117 a_546_15878# ns17 0
C118 a_546_19542# VDD 3.88941f
C119 ns5 VDD 0.17433f
C120 a_210_350# ns10 0.0057f
C121 a_546_5802# ns18 0.01017f
C122 a_546_17194# ns21 0.01017f
C123 ns4 ns6 0.03875f
C124 VDD ns16 0.17433f
C125 a_546_10782# a_400_3054# 0.20887f
C126 ns23 a_546_17710# 0.01017f
C127 nb1 a_210_350# 0.0057f
C128 ns15 a_400_3054# 0.10249f
C129 a_546_14446# a_210_350# 0.18749f
C130 ns27 a_546_19026# 0
C131 a_546_15878# a_546_15362# 2.81004f
C132 a_546_10382# nb0 0
C133 a_546_9466# a_546_9866# 1.94557f
C134 a_400_3054# ns11 0.10249f
C135 a_400_3054# a_1344_2092# 9.85091f
C136 VDD vg 0.02223f
C137 a_546_12214# a_210_350# 0.18749f
C138 a_210_350# ns20 0.0057f
C139 a_546_17194# VDD 3.7311f
C140 a_546_10782# a_546_10382# 0.08398f
C141 a_546_11698# a_546_11298# 0.08398f
C142 a_546_11698# VDD 0.28639f
C143 a_1344_2092# a_546_5286# 4.84882f
C144 a_546_8550# a_210_350# 0.18749f
C145 VDD nb2 0.17433f
C146 a_546_4370# a_546_3970# 3.92235f
C147 a_546_4370# VDD 3.7311f
C148 nsd nb0 0.31364f
C149 a_1344_2092# a_546_5802# 4.84882f
C150 a_546_7634# a_1344_2092# 4.84882f
C151 VDD ns3 0.17433f
C152 a_546_3054# ns30 0.01017f
C153 VDD ns22 0.17433f
C154 a_546_10382# a_1344_2092# 0.64528f
C155 a_546_8550# ns4 0
C156 VDD ns17 0.17433f
C157 ns29 ns31 0.31364f
C158 ns2 a_400_3054# 0.10249f
C159 a_546_3454# a_210_350# 0.18749f
C160 a_210_350# ns4 0.0057f
C161 a_546_7118# a_210_350# 0.18749f
C162 VDD ns31 0.18804f
C163 a_400_3054# a_546_13130# 0.20887f
C164 a_210_350# ns14 0.0057f
C165 a_546_19542# a_210_350# 0.18602f
C166 nb1 a_546_11698# 0.01017f
C167 VDD a_546_4886# 3.7311f
C168 a_1344_2092# a_546_16794# 4.84882f
C169 VDD a_546_15362# 3.7311f
C170 ns5 a_210_350# 0.0057f
C171 a_400_3054# a_546_14046# 0.20887f
C172 a_400_3054# ns27 0.10249f
C173 VDD a_546_8034# 3.7311f
C174 ns2 nb4 0.03875f
C175 a_210_350# ns16 0.0057f
C176 ns9 VDD 0.17433f
C177 a_546_7118# ns14 0
C178 VDD a_546_14962# 3.7311f
C179 a_546_12214# a_546_11698# 0.17331f
C180 ns26 ns24 0.03875f
C181 VDD a_546_18110# 3.7311f
C182 a_546_8950# VDD 3.7311f
C183 ns25 a_546_18110# 0.01017f
C184 ns29 a_546_19026# 0.01017f
C185 ns8 VDD 0.17433f
C186 ns16 ns14 0.31364f
C187 a_546_9866# a_1344_2092# 2.91115f
C188 a_546_17194# a_210_350# 0.18749f
C189 VDD a_546_19026# 3.77138f
C190 a_546_11698# a_210_350# 0.18733f
C191 ns22 ns20 0.03875f
C192 a_546_8034# ns10 0
C193 a_400_3054# a_546_15878# 0.20887f
C194 vbnf VDD 0.22379f
C195 a_210_350# nb2 0.0057f
C196 a_546_4370# a_210_350# 0.18749f
C197 a_546_8950# ns6 0
C198 a_210_350# ns3 0.0057f
C199 ns8 ns6 0.31364f
C200 a_400_3054# a_546_6718# 0.20887f
C201 a_210_350# ns22 0.0057f
C202 ns9 a_546_14446# 0.01017f
C203 a_210_350# ns17 0.0057f
C204 a_546_4886# ns20 0
C205 ns8 ns10 0.03875f
C206 a_546_14446# a_546_14962# 2.81004f
C207 a_546_9866# ns2 0
C208 a_210_350# ns31 0.0057f
C209 a_546_6202# a_400_3054# 0.20887f
C210 a_400_3054# ns21 0.10249f
C211 a_546_12614# a_400_3054# 0.20887f
C212 a_546_8550# a_546_8034# 2.81004f
C213 a_210_350# a_546_4886# 0.18749f
C214 a_546_15362# a_210_350# 0.18749f
C215 ns5 ns3 0.03875f
C216 a_210_350# a_546_8034# 0.18749f
C217 a_546_6202# a_546_5802# 3.92235f
C218 ns9 a_210_350# 0.0057f
C219 ns29 a_400_3054# 0.10249f
C220 a_546_19542# ns31 0.01017f
C221 a_210_350# a_546_14962# 0.18749f
C222 VDD ns28 0.17433f
C223 a_546_8950# a_546_8550# 3.92235f
C224 a_400_3054# a_546_3970# 0.20887f
C225 a_400_3054# a_546_11298# 0.20887f
C226 a_400_3054# VDD 10.0095f
C227 a_400_3054# ns25 0.10249f
C228 a_210_350# a_546_18110# 0.18749f
C229 a_546_8950# a_210_350# 0.18749f
C230 VDD a_546_5286# 3.7311f
C231 ns8 a_210_350# 0.0057f
C232 a_546_16278# ns15 0
C233 a_210_350# a_546_19026# 0.18749f
C234 a_546_5802# VDD 3.7311f
C235 a_400_3054# ns6 0.10249f
C236 a_546_7634# VDD 3.7311f
C237 a_546_9466# a_1344_2092# 5.56786f
C238 a_546_16278# a_1344_2092# 4.84882f
C239 a_546_8950# ns4 0.01017f
C240 a_546_16794# ns21 0
C241 nb4 VDD 0.17433f
C242 a_546_10382# a_546_11298# 0
C243 a_546_10382# VDD 0.58335f
C244 a_546_17710# a_1344_2092# 4.84882f
C245 a_400_3054# ns10 0.10249f
C246 a_1344_2092# a_546_13530# 4.84882f
C247 ns23 ns21 0.31364f
C248 nb1 a_400_3054# 0.10249f
C249 a_546_19542# a_546_19026# 2.81004f
C250 a_1344_2092# a_546_18626# 4.84893f
C251 a_400_3054# a_546_14446# 0.20887f
C252 a_546_4370# a_546_4886# 2.81004f
C253 a_546_16794# VDD 3.7311f
C254 a_546_7634# ns10 0.01017f
C255 a_546_11298# nsd 0.01017f
C256 ns15 ns13 0.31364f
C257 a_546_9466# ns2 0.01017f
C258 nsd VDD 0.17232f
C259 a_546_10782# nb0 0.01017f
C260 a_546_4886# ns22 0.01017f
C261 ns30 VDD 0.21376f
C262 a_400_3054# ns20 0.10249f
C263 a_546_12214# a_400_3054# 0.20887f
C264 ns13 ns11 0.03875f
C265 a_546_12614# ns1 0.01017f
C266 ns23 VDD 0.17433f
C267 ns23 ns25 0.03875f
C268 a_400_3054# a_546_8550# 0.20887f
C269 a_546_5286# ns20 0.01017f
C270 a_210_350# ns28 0.0057f
C271 a_546_3054# a_1344_2092# 4.84903f
C272 a_546_13530# a_546_13130# 3.92235f
C273 a_400_3054# a_210_350# 5.88849f
C274 vbnf vg 0.11299f
C275 a_546_9866# VDD 2.01413f
C276 a_546_14046# a_546_13530# 2.81004f
C277 a_546_5286# a_210_350# 0.18749f
C278 a_546_3454# ns28 0.01017f
C279 ns21 ns19 0.03875f
C280 ns1 VDD 0.17433f
C281 a_546_10782# a_1344_2092# 0.04811f
C282 a_400_3054# a_546_3454# 0.20887f
C283 nb1 nsd 0.03875f
C284 a_400_3054# ns4 0.10249f
C285 a_546_12614# nb3 0
C286 a_400_3054# a_546_7118# 0.20887f
C287 a_546_5802# a_210_350# 0.18749f
C288 ns27 a_546_18626# 0.01017f
C289 a_546_7634# a_210_350# 0.18749f
C290 a_400_3054# ns14 0.10249f
C291 nb4 a_210_350# 0.0057f
C292 a_546_15362# a_546_14962# 3.92235f
C293 a_546_10382# a_210_350# 0.18749f
C294 a_400_3054# a_546_19542# 0.20887f
C295 a_400_3054# ns5 0.10249f
C296 a_546_16278# a_546_15878# 3.92235f
C297 a_546_6718# ns12 0
C298 a_546_7634# a_546_7118# 2.81004f
C299 a_400_3054# ns16 0.10249f
C300 ns19 VDD 0.17433f
C301 a_546_14046# ns7 0.01017f
C302 nb3 VDD 0.17433f
C303 ns8 a_546_8034# 0.01017f
C304 a_546_16794# a_210_350# 0.18749f
C305 nsd a_210_350# 0.0057f
C306 a_546_5802# ns16 0
C307 a_400_3054# vg 0.47931f
C308 ns30 a_210_350# 0.0057f
C309 a_400_3054# a_546_17194# 0.20887f
C310 a_400_3054# a_546_11698# 0.20887f
C311 ns23 a_210_350# 0.0057f
C312 a_400_3054# nb2 0.10249f
C313 a_546_4370# a_400_3054# 0.20887f
C314 a_546_3970# ns24 0
C315 VDD ns24 0.17433f
C316 a_1344_2092# a_546_13130# 4.84882f
C317 a_546_3454# ns30 0
C318 a_546_12214# ns1 0
C319 a_400_3054# ns3 0.10249f
C320 nb1 nb3 0.31364f
C321 a_546_9866# a_210_350# 0.18749f
C322 a_400_3054# ns22 0.10249f
C323 a_546_14046# a_1344_2092# 4.84882f
C324 VDD ns12 0.17433f
C325 a_400_3054# ns17 0.10249f
C326 a_546_5286# ns22 0
C327 ns1 a_210_350# 0.0057f
C328 a_546_10382# a_546_11698# 0.0333f
C329 a_546_9466# VDD 4.25146f
C330 a_546_16278# VDD 3.7311f
C331 nb4 nb2 0.31364f
C332 a_546_10382# nb2 0.01017f
C333 a_400_3054# ns31 0.10226f
C334 a_546_17710# VDD 3.7311f
C335 a_546_17710# ns25 0
C336 a_546_3970# ns26 0.01017f
C337 ns26 VDD 0.17433f
C338 a_546_12214# nb3 0.01017f
C339 a_400_3054# a_546_4886# 0.20887f
C340 a_546_13530# VDD 3.7311f
C341 a_400_3054# a_546_15362# 0.20887f
C342 ns15 a_546_15878# 0.01017f
C343 a_546_6202# ns18 0
C344 ns29 a_546_18626# 0
C345 a_546_17194# a_546_16794# 3.92235f
C346 a_546_5286# a_546_4886# 3.92235f
C347 ns12 ns10 0.31364f
C348 a_400_3054# a_546_8034# 0.20887f
C349 VDD a_546_18626# 3.7311f
C350 ns19 a_210_350# 0.0057f
C351 ns9 a_400_3054# 0.10249f
C352 a_546_11698# nsd 0
C353 nb3 a_210_350# 0.0057f
C354 a_1344_2092# a_546_15878# 4.84882f
C355 a_400_3054# a_546_14962# 0.20887f
C356 a_546_6718# a_1344_2092# 4.84882f
C357 a_400_3054# a_546_18110# 0.20887f
C358 a_400_3054# a_546_8950# 0.20887f
C359 a_546_7634# a_546_8034# 3.92235f
C360 a_400_3054# ns8 0.10249f
C361 ns13 VDD 0.17433f
C362 VDD ns18 0.17433f
C363 ns7 VDD 0.17433f
C364 a_400_3054# a_546_19026# 0.20887f
C365 a_546_3054# VDD 3.73935f
C366 nb0 VDD 0.17232f
C367 a_400_3054# vbnf 0.0113f
C368 a_210_350# ns24 0.0057f
C369 a_546_6202# a_1344_2092# 4.84882f
C370 a_546_12614# a_1344_2092# 5.92738f
C371 a_546_7634# ns8 0
C372 a_546_10782# a_546_11298# 0.0859f
C373 a_210_350# ns12 0.0057f
C374 a_546_10782# VDD 0.16947f
C375 ns15 VDD 0.17433f
C376 ns1 ns3 0.31364f
C377 a_546_9466# a_210_350# 0.18749f
C378 a_546_16278# a_210_350# 0.18749f
C379 a_546_17710# a_210_350# 0.18749f
C380 a_546_17194# ns19 0
C381 ns11 VDD 0.17433f
C382 a_546_7118# ns12 0.01017f
C383 a_546_3970# a_1344_2092# 4.84882f
C384 a_546_11298# a_1344_2092# 0.04811f
C385 a_1344_2092# VDD 0.95895p
C386 ns26 a_210_350# 0.0057f
C387 a_546_13530# a_210_350# 0.18749f
C388 a_546_14446# ns7 0
C389 ns12 ns14 0.03875f
C390 a_546_18626# a_210_350# 0.18749f
C391 a_546_12614# a_546_13130# 2.81004f
C392 ns23 a_546_18110# 0
C393 ns20 ns18 0.31364f
C394 a_400_3054# ns28 0.10249f
C395 ns19 ns17 0.31364f
C396 a_546_13530# ns5 0.01017f
C397 ns2 VDD 0.17433f
C398 a_400_3054# a_546_5286# 0.20887f
C399 ns13 a_210_350# 0.0057f
C400 a_210_350# ns18 0.0057f
C401 ns7 a_210_350# 0.0057f
C402 a_546_4370# ns24 0.01017f
C403 a_546_3054# a_210_350# 0.18555f
C404 VDD a_546_13130# 3.7311f
C405 nb0 a_210_350# 0.0057f
C406 a_400_3054# a_546_5802# 0.20887f
C407 a_546_7634# a_400_3054# 0.20887f
C408 a_546_14446# a_1344_2092# 4.84882f
C409 ns29 ns27 0.03875f
C410 a_400_3054# nb4 0.10249f
C411 ns24 ns22 0.31364f
C412 a_546_14046# VDD 3.7311f
C413 a_546_10382# a_400_3054# 0.20887f
C414 a_546_5802# a_546_5286# 2.81004f
C415 ns27 VDD 0.17436f
C416 a_546_3054# a_546_3454# 3.92235f
C417 ns27 ns25 0.31364f
C418 a_546_17710# a_546_17194# 2.81004f
C419 a_546_10782# a_210_350# 0.21108f
C420 vg VSS 4.32658f
C421 vbnf VSS 4.0635f
C422 ns30 VSS 0.11974f
C423 ns28 VSS 0.06717f
C424 ns26 VSS 0.06717f
C425 ns24 VSS 0.06717f
C426 ns22 VSS 0.06717f
C427 ns20 VSS 0.06717f
C428 ns18 VSS 0.06717f
C429 ns16 VSS 0.06717f
C430 ns14 VSS 0.06717f
C431 ns12 VSS 0.06717f
C432 ns10 VSS 0.06717f
C433 ns8 VSS 0.06717f
C434 ns6 VSS 0.06717f
C435 ns4 VSS 0.06717f
C436 ns2 VSS 0.06717f
C437 nb4 VSS 0.06717f
C438 nb2 VSS 0.06717f
C439 nb0 VSS 0.06893f
C440 nsd VSS 0.06893f
C441 nb1 VSS 0.06717f
C442 nb3 VSS 0.06717f
C443 ns1 VSS 0.06717f
C444 ns3 VSS 0.06717f
C445 ns5 VSS 0.06717f
C446 ns7 VSS 0.06717f
C447 ns9 VSS 0.06717f
C448 ns11 VSS 0.06717f
C449 ns13 VSS 0.06717f
C450 ns15 VSS 0.06717f
C451 ns17 VSS 0.06717f
C452 ns19 VSS 0.06717f
C453 ns21 VSS 0.06717f
C454 ns23 VSS 0.06717f
C455 ns25 VSS 0.06717f
C456 ns27 VSS 0.06717f
C457 ns29 VSS 0.06717f
C458 ns31 VSS 0.10187f
C459 VDD VSS 1.56788p
C460 a_546_9466# VSS 0.58464f
C461 a_546_9866# VSS 0.44726f
C462 a_546_10382# VSS 0.07495f
C463 a_546_10782# VSS 0
C464 a_546_11298# VSS 0
C465 a_546_11698# VSS 0
C466 a_546_12214# VSS 0.22447f
C467 a_546_12614# VSS 0.88967f
C468 a_210_350# VSS 2.77519f
C469 a_546_19542# VSS 0.084f
C470 a_400_3054# VSS 44.2409f
C471 a_1344_2092# VSS 13.2175f
.ends
