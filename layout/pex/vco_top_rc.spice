* vco_top: magic R+C extraction of layout/vco_top.gds (layout/gen/pex.sh)
* extracted 2026-11-12T17:49:19+01:00 with magic 8.3.642, mode rc, from vco_top.gds
.subckt vco_top VDD VDD_LS VSS vctrl bit0 bit1 bit2 bit3 bit4 bitb0 bitb1 bitb2 bitb3 bitb4 ck a0 vbn vg ls vbnf
X0 a_36888_1807# vbn.t833 a_37178_2387# VSS.t93 nfet_03v3 ad=0.9p pd=4.9u as=0.56p ps=2.56u w=2u l=1u
X1 a_37178_4707# vbn.t515 a_36888_4127# VSS.t89 nfet_03v3 ad=0.56p pd=2.56u as=0.56p ps=2.56u w=2u l=1u
X2 a_36888_7607# vbn.t207 a_37178_8187# VSS.t83 nfet_03v3 ad=0.56p pd=2.56u as=0.56p ps=2.56u w=2u l=1u
X3 vg.t34 a_6206_14# VSS.t117 VSS.t11 nfet_03v3 ad=0.336p pd=1.76u as=0.336p ps=1.76u w=1.2u l=5.335u
X4 a_37178_3547# vbn.t872 a_36888_2967# VSS.t80 nfet_03v3 ad=0.56p pd=2.56u as=0.56p ps=2.56u w=2u l=1u
X5 a_37178_8187# vbn.t663 a_36888_7607# VSS.t83 nfet_03v3 ad=0.56p pd=2.56u as=0.56p ps=2.56u w=2u l=1u
X6 a_36888_7607# vbn.t654 a_37178_7027# VSS.t84 nfet_03v3 ad=0.56p pd=2.56u as=0.56p ps=2.56u w=2u l=1u
X7 a_41564_2967# vbn.t260 a_41854_3547# VSS.t91 nfet_03v3 ad=0.56p pd=2.56u as=0.56p ps=2.56u w=2u l=1u
X8 a_41854_5867# vbn.t294 a_41564_6447# VSS.t86 nfet_03v3 ad=0.9p pd=4.9u as=0.56p ps=2.56u w=2u l=1u
X9 a_36866_9481# vbn.t706 a_37178_8187# VSS.t82 nfet_03v3 ad=0.56p pd=2.56u as=0.56p ps=2.56u w=2u l=1u
X10 a_37178_3547# vbn.t112 a_36888_4127# VSS.t90 nfet_03v3 ad=0.56p pd=2.56u as=0.56p ps=2.56u w=2u l=1u
X11 a_37178_2387# vbn.t389 a_36888_1807# VSS.t93 nfet_03v3 ad=0.56p pd=2.56u as=0.56p ps=2.56u w=2u l=1u
X12 a_37178_4707# vbn.t136 a_36888_5287# VSS.t88 nfet_03v3 ad=0.56p pd=2.56u as=0.56p ps=2.56u w=2u l=1u
X13 a_36888_1807# vbn.t354 a_37178_1227# VSS.t94 nfet_03v3 ad=0.56p pd=2.56u as=0.56p ps=2.56u w=2u l=1u
X14 a_36888_7607# vbn.t205 a_37178_8187# VSS.t83 nfet_03v3 ad=0.56p pd=2.56u as=0.56p ps=2.56u w=2u l=1u
X15 a_6356_6633# bitb0.t0 VSS.t132 VSS.t131 nfet_03v3 ad=0.45p pd=2.9u as=0.45p ps=2.9u w=1u l=0.28u
X16 a_41564_2967# vbn.t255 a_41854_2387# VSS.t92 nfet_03v3 ad=0.56p pd=2.56u as=0.56p ps=2.56u w=2u l=1u
X17 a_37178_1227# vbn.t50 a_36888_1807# VSS.t94 nfet_03v3 ad=0.56p pd=2.56u as=0.56p ps=2.56u w=2u l=1u
X18 a_37178_4707# vbn.t896 a_36888_4127# VSS.t89 nfet_03v3 ad=0.56p pd=2.56u as=0.56p ps=2.56u w=2u l=1u
X19 a_36888_7607# vbn.t965 a_37178_7027# VSS.t84 nfet_03v3 ad=0.56p pd=2.56u as=0.56p ps=2.56u w=2u l=1u
X20 a_37178_7027# vbn.t956 a_36888_6447# VSS.t80 nfet_03v3 ad=0.56p pd=2.56u as=0.56p ps=2.56u w=2u l=1u
X21 a_41564_6447# vbn.t302 a_41854_7027# VSS.t85 nfet_03v3 ad=0.56p pd=2.56u as=0.56p ps=2.56u w=2u l=1u
X22 a_37178_8187# vbn.t711 a_36866_9481# VSS.t82 nfet_03v3 ad=0.56p pd=2.56u as=0.56p ps=2.56u w=2u l=1u
X23 a_36888_4127# vbn.t117 a_37178_3547# VSS.t90 nfet_03v3 ad=0.56p pd=2.56u as=0.56p ps=2.56u w=2u l=1u
X24 a_36888_1807# vbn.t394 a_37178_2387# VSS.t93 nfet_03v3 ad=0.56p pd=2.56u as=0.56p ps=2.56u w=2u l=1u
X25 vg.t5 a_6206_896# VSS.t12 VSS.t11 nfet_03v3 ad=0.336p pd=1.76u as=0.336p ps=1.76u w=1.2u l=5.335u
X26 VDD.t9 a_36866_9481# a_36866_9481# VDD.t8 pfet_03v3 ad=3.92p pd=14.56u as=3.92p ps=14.56u w=14u l=14u
X27 a_36888_4127# vbn.t498 a_37178_4707# VSS.t89 nfet_03v3 ad=0.56p pd=2.56u as=0.56p ps=2.56u w=2u l=1u
X28 a_37178_8187# vbn.t210 a_36888_7607# VSS.t83 nfet_03v3 ad=0.56p pd=2.56u as=0.56p ps=2.56u w=2u l=1u
X29 a_36888_5287# vbn.t550 a_37178_5867# VSS.t87 nfet_03v3 ad=0.56p pd=2.56u as=0.56p ps=2.56u w=2u l=1u
X30 a_37178_7027# vbn.t657 a_36888_7607# VSS.t84 nfet_03v3 ad=0.56p pd=2.56u as=0.9p ps=4.9u w=2u l=1u
X31 a_41854_3547# vbn.t263 a_41564_2967# VSS.t91 nfet_03v3 ad=0.56p pd=2.56u as=0.56p ps=2.56u w=2u l=1u
X32 a_41564_6447# vbn.t297 a_41854_5867# VSS.t86 nfet_03v3 ad=0.56p pd=2.56u as=0.56p ps=2.56u w=2u l=1u
X33 w_36826_300# vbn.t342 a_37178_1227# VSS.t95 nfet_03v3 ad=0.56p pd=2.56u as=0.56p ps=2.56u w=2u l=1u
X34 a_37178_4707# vbn.t124 a_36888_4127# VSS.t89 nfet_03v3 ad=0.56p pd=2.56u as=0.56p ps=2.56u w=2u l=1u
X35 a_36888_4127# vbn.t115 a_37178_3547# VSS.t90 nfet_03v3 ad=0.56p pd=2.56u as=0.56p ps=2.56u w=2u l=1u
X36 a_36888_1807# vbn.t55 a_37178_1227# VSS.t94 nfet_03v3 ad=0.56p pd=2.56u as=0.56p ps=2.56u w=2u l=1u
X37 a_37178_5867# vbn.t148 a_36888_5287# VSS.t87 nfet_03v3 ad=0.56p pd=2.56u as=0.56p ps=2.56u w=2u l=1u
X38 a_37178_8187# vbn.t994 a_36866_9481# VSS.t82 nfet_03v3 ad=0.56p pd=2.56u as=0.56p ps=2.56u w=2u l=1u
X39 a_37178_2387# vbn.t850 a_36888_2967# VSS.t92 nfet_03v3 ad=0.56p pd=2.56u as=0.56p ps=2.56u w=2u l=1u
X40 a_36888_7607# vbn.t215 a_37178_8187# VSS.t83 nfet_03v3 ad=0.56p pd=2.56u as=0.56p ps=2.56u w=2u l=1u
X41 VSS.t6 a_n5549_6703# q1 VSS.t5 nfet_03v3 ad=0.27p pd=2.1u as=0.6p ps=3.2u w=0.6u l=0.28u
X42 a_36888_4127# vbn.t899 a_37178_4707# VSS.t81 nfet_03v3 ad=0.56p pd=2.56u as=0.56p ps=2.56u w=2u l=1u
X43 a_36866_9481# vbn.t694 a_37178_8187# VSS.t82 nfet_03v3 ad=0.56p pd=2.56u as=0.56p ps=2.56u w=2u l=1u
X44 a_37178_7027# vbn.t968 a_36888_7607# VSS.t84 nfet_03v3 ad=0.56p pd=2.56u as=0.56p ps=2.56u w=2u l=1u
X45 a_36888_4127# vbn.t486 a_37178_3547# VSS.t90 nfet_03v3 ad=0.56p pd=2.56u as=0.56p ps=2.56u w=2u l=1u
X46 a_41854_7027# vbn.t305 a_41564_6447# VSS.t85 nfet_03v3 ad=0.56p pd=2.56u as=0.56p ps=2.56u w=2u l=1u
X47 a_37178_1227# vbn.t347 w_36826_300# VSS.t95 nfet_03v3 ad=0.56p pd=2.56u as=0.56p ps=2.56u w=2u l=1u
X48 a_36888_5287# vbn.t538 a_37178_4707# VSS.t88 nfet_03v3 ad=0.56p pd=2.56u as=0.56p ps=2.56u w=2u l=1u
X49 a_36888_5287# vbn.t153 a_37178_5867# VSS.t87 nfet_03v3 ad=0.56p pd=2.56u as=0.56p ps=2.56u w=2u l=1u
X50 a_36888_7607# vbn.t213 a_37178_8187# VSS.t83 nfet_03v3 ad=0.56p pd=2.56u as=0.56p ps=2.56u w=2u l=1u
X51 a_37178_8187# vbn.t222 a_36866_9481# VSS.t82 nfet_03v3 ad=0.56p pd=2.56u as=0.56p ps=2.56u w=2u l=1u
X52 VDD.t35 vg.t45 VDD.t35 VDD.t34 pfet_03v3 ad=8.3496p pd=30.38u as=0 ps=0 w=29.82u l=4.12u
X53 a_37178_5867# vbn.t934 a_36888_6447# VSS.t86 nfet_03v3 ad=0.56p pd=2.56u as=0.56p ps=2.56u w=2u l=1u
X54 a_36888_2967# vbn.t420 a_37178_2387# VSS.t92 nfet_03v3 ad=0.56p pd=2.56u as=0.56p ps=2.56u w=2u l=1u
X55 a_36888_4127# vbn.t881 a_37178_3547# VSS.t90 nfet_03v3 ad=0.56p pd=2.56u as=0.56p ps=2.56u w=2u l=1u
X56 a_37178_1227# vbn.t812 w_36826_300# VSS.t95 nfet_03v3 ad=0.56p pd=2.56u as=0.56p ps=2.56u w=2u l=1u
X57 a_36866_9481# vbn.t997 a_37178_8187# VSS.t81 nfet_03v3 ad=0.56p pd=2.56u as=0.56p ps=2.56u w=2u l=1u
X58 a_37178_4707# vbn.t543 a_36888_5287# VSS.t88 nfet_03v3 ad=0.56p pd=2.56u as=0.56p ps=2.56u w=2u l=1u
X59 a_36888_7607# vbn.t682 a_37178_8187# VSS.t83 nfet_03v3 ad=0.56p pd=2.56u as=0.56p ps=2.56u w=2u l=1u
X60 w_36826_300# vbn.t330 a_37178_1227# VSS.t95 nfet_03v3 ad=0.56p pd=2.56u as=0.56p ps=2.56u w=2u l=1u
X61 a_37178_3547# vbn.t489 a_36888_4127# VSS.t90 nfet_03v3 ad=0.56p pd=2.56u as=0.9p ps=4.9u w=2u l=1u
X62 a_41854_7027# vbn.t310 a_41564_7607# VSS.t84 nfet_03v3 ad=0.56p pd=2.56u as=0.56p ps=2.56u w=2u l=1u
X63 a_37178_1227# vbn.t373 a_36888_1807# VSS.t94 nfet_03v3 ad=0.56p pd=2.56u as=0.56p ps=2.56u w=2u l=1u
X64 a_36888_1807# vbn.t382 a_37178_2387# VSS.t93 nfet_03v3 ad=0.56p pd=2.56u as=0.56p ps=2.56u w=2u l=1u
X65 a_36888_6447# vbn.t588 a_37178_5867# VSS.t86 nfet_03v3 ad=0.56p pd=2.56u as=0.56p ps=2.56u w=2u l=1u
X66 a_37178_2387# vbn.t425 a_36888_2967# VSS.t92 nfet_03v3 ad=0.56p pd=2.56u as=0.56p ps=2.56u w=2u l=1u
X67 a_37178_1227# vbn.t40 w_36826_300# VSS.t95 nfet_03v3 ad=0.56p pd=2.56u as=0.56p ps=2.56u w=2u l=1u
X68 a_n4384_6451# a_n4642_7514# a_n5234_7514# VSS.t74 nfet_03v3 ad=0.28p pd=1.56u as=1p ps=4u w=1u l=0.28u
X69 a_37178_2387# vbn.t64 a_36888_1807# VSS.t93 nfet_03v3 ad=0.56p pd=2.56u as=0.56p ps=2.56u w=2u l=1u
X70 a_37178_4707# vbn.t910 a_36888_5287# VSS.t88 nfet_03v3 ad=0.56p pd=2.56u as=0.56p ps=2.56u w=2u l=1u
X71 a_37178_1227# vbn.t371 a_36888_1807# VSS.t94 nfet_03v3 ad=0.56p pd=2.56u as=0.56p ps=2.56u w=2u l=1u
X72 a_36888_7607# vbn.t979 a_37178_8187# VSS.t83 nfet_03v3 ad=0.56p pd=2.56u as=0.56p ps=2.56u w=2u l=1u
X73 a_41564_4127# vbn.t759 a_41854_4707# VSS.t89 nfet_03v3 ad=0.56p pd=2.56u as=0.56p ps=2.56u w=2u l=1u
X74 a_37178_3547# vbn.t884 a_36888_4127# VSS.t90 nfet_03v3 ad=0.56p pd=2.56u as=0.56p ps=2.56u w=2u l=1u
X75 a_37178_1227# vbn.t824 a_36888_1807# VSS.t94 nfet_03v3 ad=0.56p pd=2.56u as=0.56p ps=2.56u w=2u l=1u
X76 w_36826_300# vbn.t815 a_37178_1227# VSS.t81 nfet_03v3 ad=0.56p pd=2.56u as=0.56p ps=2.56u w=2u l=1u
X77 a_36888_5287# vbn.t526 a_37178_4707# VSS.t88 nfet_03v3 ad=0.56p pd=2.56u as=0.56p ps=2.56u w=2u l=1u
X78 a_36888_2967# vbn.t434 a_37178_3547# VSS.t91 nfet_03v3 ad=0.9p pd=4.9u as=0.56p ps=2.56u w=2u l=1u
X79 a_36888_7607# vbn.t640 a_37178_7027# VSS.t84 nfet_03v3 ad=0.56p pd=2.56u as=0.56p ps=2.56u w=2u l=1u
X80 a_37178_5867# vbn.t593 a_36888_6447# VSS.t86 nfet_03v3 ad=0.56p pd=2.56u as=0.56p ps=2.56u w=2u l=1u
X81 a_37178_5867# vbn.t569 a_36888_5287# VSS.t87 nfet_03v3 ad=0.56p pd=2.56u as=0.56p ps=2.56u w=2u l=1u
X82 a_37178_8187# vbn.t685 a_36888_7607# VSS.t83 nfet_03v3 ad=0.56p pd=2.56u as=0.9p ps=4.9u w=2u l=1u
X83 a_36888_1807# vbn.t69 a_37178_2387# VSS.t93 nfet_03v3 ad=0.56p pd=2.56u as=0.56p ps=2.56u w=2u l=1u
X84 a_41564_4127# vbn.t757 a_41854_4707# VSS.t89 nfet_03v3 ad=0.56p pd=2.56u as=0.56p ps=2.56u w=2u l=1u
X85 a_41854_1227# vbn.t723 a_41564_1807# VSS.t94 nfet_03v3 ad=0.56p pd=2.56u as=0.56p ps=2.56u w=2u l=1u
X86 a_37178_4707# vbn.t138 a_36888_5287# VSS.t88 nfet_03v3 ad=0.56p pd=2.56u as=0.56p ps=2.56u w=2u l=1u
X87 a_36888_1807# vbn.t376 a_37178_1227# VSS.t94 nfet_03v3 ad=0.56p pd=2.56u as=0.56p ps=2.56u w=2u l=1u
X88 a_37178_5867# vbn.t567 a_36888_5287# VSS.t87 nfet_03v3 ad=0.56p pd=2.56u as=0.56p ps=2.56u w=2u l=1u
X89 a_36888_2967# vbn.t428 a_37178_2387# VSS.t92 nfet_03v3 ad=0.56p pd=2.56u as=0.56p ps=2.56u w=2u l=1u
X90 vbn.t12 vbn.t11 a_41854_8187# VSS.t82 nfet_03v3 ad=0.56p pd=2.56u as=0.56p ps=2.56u w=2u l=1u
X91 a_36888_6447# vbn.t602 a_37178_7027# VSS.t85 nfet_03v3 ad=0.9p pd=4.9u as=0.56p ps=2.56u w=2u l=1u
X92 a_37178_5867# vbn.t922 a_36888_5287# VSS.t87 nfet_03v3 ad=0.56p pd=2.56u as=0.56p ps=2.56u w=2u l=1u
X93 a_36888_5287# vbn.t913 a_37178_4707# VSS.t81 nfet_03v3 ad=0.56p pd=2.56u as=0.56p ps=2.56u w=2u l=1u
X94 a_37178_7027# vbn.t645 a_36888_7607# VSS.t84 nfet_03v3 ad=0.56p pd=2.56u as=0.56p ps=2.56u w=2u l=1u
X95 a_37178_8187# vbn.t982 a_36888_7607# VSS.t83 nfet_03v3 ad=0.56p pd=2.56u as=0.56p ps=2.56u w=2u l=1u
X96 a_36888_7607# vbn.t961 a_37178_7027# VSS.t84 nfet_03v3 ad=0.56p pd=2.56u as=0.56p ps=2.56u w=2u l=1u
X97 a_41854_4707# vbn.t762 a_41564_4127# VSS.t89 nfet_03v3 ad=0.56p pd=2.56u as=0.9p ps=4.9u w=2u l=1u
X98 a_37178_3547# vbn.t437 a_36888_2967# VSS.t91 nfet_03v3 ad=0.56p pd=2.56u as=0.56p ps=2.56u w=2u l=1u
X99 a_37178_2387# vbn.t413 a_36888_2967# VSS.t92 nfet_03v3 ad=0.56p pd=2.56u as=0.56p ps=2.56u w=2u l=1u
X100 a_36888_1807# vbn.t827 a_37178_1227# VSS.t94 nfet_03v3 ad=0.56p pd=2.56u as=0.56p ps=2.56u w=2u l=1u
X101 a_41854_5867# vbn.t772 a_41564_5287# VSS.t87 nfet_03v3 ad=0.56p pd=2.56u as=0.56p ps=2.56u w=2u l=1u
X102 vbn.t16 vbn.t15 a_41854_8187# VSS.t82 nfet_03v3 ad=0.56p pd=2.56u as=0.56p ps=2.56u w=2u l=1u
X103 a_37178_7027# vbn.t643 a_36888_7607# VSS.t84 nfet_03v3 ad=0.56p pd=2.56u as=0.56p ps=2.56u w=2u l=1u
X104 a_36888_6447# vbn.t596 a_37178_5867# VSS.t86 nfet_03v3 ad=0.56p pd=2.56u as=0.56p ps=2.56u w=2u l=1u
X105 a_36888_5287# vbn.t572 a_37178_5867# VSS.t87 nfet_03v3 ad=0.56p pd=2.56u as=0.56p ps=2.56u w=2u l=1u
X106 a_41854_3547# vbn.t268 a_41564_4127# VSS.t90 nfet_03v3 ad=0.56p pd=2.56u as=0.56p ps=2.56u w=2u l=1u
X107 a_1867_7085# a_1632_6633# VDD.t21 VDD.t20 pfet_03v3 ad=2.25p pd=10.9u as=2.25p ps=10.9u w=5u l=0.28u
X108 a_36888_2967# vbn.t91 a_37178_3547# VSS.t91 nfet_03v3 ad=0.9p pd=4.9u as=0.56p ps=2.56u w=2u l=1u
X109 VSS.t139 a_n7601_6703# a_n8217_6703# VSS.t138 nfet_03v3 ad=0.27p pd=2.1u as=0.6p ps=3.2u w=0.6u l=0.28u
X110 a_36888_1807# vbn.t57 a_37178_1227# VSS.t94 nfet_03v3 ad=0.56p pd=2.56u as=0.56p ps=2.56u w=2u l=1u
X111 VSS.t99 vbn.t717 a_41854_1227# VSS.t95 nfet_03v3 ad=0.56p pd=2.56u as=0.56p ps=2.56u w=2u l=1u
X112 VDD_LS.t5 a_n5549_6703# q1 VDD_LS.t4 pfet_03v3 ad=0.675p pd=3.9u as=1.5p ps=5u w=1.5u l=0.28u
X113 a_37178_1227# vbn.t832 a_36888_1807# VSS.t78 nfet_03v3 ad=0.56p pd=2.56u as=0.9p ps=4.9u w=2u l=1u
X114 a_41854_8187# vbn.t5 vbn.t6 VSS.t82 nfet_03v3 ad=0.56p pd=2.56u as=0.9p ps=4.9u w=2u l=1u
X115 a_37178_7027# vbn.t605 a_36888_6447# VSS.t85 nfet_03v3 ad=0.56p pd=2.56u as=0.56p ps=2.56u w=2u l=1u
X116 a_37178_5867# vbn.t581 a_36888_6447# VSS.t86 nfet_03v3 ad=0.56p pd=2.56u as=0.56p ps=2.56u w=2u l=1u
X117 a_36888_5287# vbn.t925 a_37178_5867# VSS.t87 nfet_03v3 ad=0.56p pd=2.56u as=0.56p ps=2.56u w=2u l=1u
X118 a_36888_7607# vbn.t648 a_37178_7027# VSS.t84 nfet_03v3 ad=0.56p pd=2.56u as=0.56p ps=2.56u w=2u l=1u
X119 a_36866_9481# a_36866_9481# VDD.t7 VDD.t6 pfet_03v3 ad=3.92p pd=14.56u as=3.92p ps=14.56u w=14u l=14u
X120 a_36888_4127# vbn.t472 a_37178_3547# VSS.t90 nfet_03v3 ad=0.56p pd=2.56u as=0.56p ps=2.56u w=2u l=1u
X121 a_41854_8187# vbn.t317 a_41564_7607# VSS.t83 nfet_03v3 ad=0.56p pd=2.56u as=0.56p ps=2.56u w=2u l=1u
X122 a_37178_2387# vbn.t401 a_36888_1807# VSS.t93 nfet_03v3 ad=0.56p pd=2.56u as=0.56p ps=2.56u w=2u l=1u
X123 VSS.t101 vbn.t715 a_41854_1227# VSS.t95 nfet_03v3 ad=0.56p pd=2.56u as=0.56p ps=2.56u w=2u l=1u
X124 a_36888_6447# vbn.t175 a_37178_7027# VSS.t85 nfet_03v3 ad=0.9p pd=4.9u as=0.56p ps=2.56u w=2u l=1u
X125 vbnf.t7 bit2.t0 a_6206_4704# VSS.t150 nfet_03v3 ad=0.9p pd=4.9u as=0.9p ps=4.9u w=2u l=0.28u
X126 a_37178_1227# vbn.t62 a_36888_1807# VSS.t94 nfet_03v3 ad=0.56p pd=2.56u as=0.9p ps=4.9u w=2u l=1u
X127 VDD.t31 vg.t47 VDD.t31 VDD.t30 pfet_03v3 ad=8.3496p pd=30.38u as=0 ps=0 w=29.82u l=4.12u
X128 a_37178_2387# vbn.t86 a_36888_2967# VSS.t92 nfet_03v3 ad=0.56p pd=2.56u as=0.56p ps=2.56u w=2u l=1u
X129 a_37178_2387# vbn.t399 a_36888_1807# VSS.t93 nfet_03v3 ad=0.56p pd=2.56u as=0.56p ps=2.56u w=2u l=1u
X130 a_36888_5287# vbn.t155 a_37178_5867# VSS.t87 nfet_03v3 ad=0.56p pd=2.56u as=0.56p ps=2.56u w=2u l=1u
X131 a_37178_5867# vbn.t930 a_36888_5287# VSS.t78 nfet_03v3 ad=0.56p pd=2.56u as=0.9p ps=4.9u w=2u l=1u
X132 a_41564_5287# vbn.t766 a_41854_4707# VSS.t88 nfet_03v3 ad=0.56p pd=2.56u as=0.56p ps=2.56u w=2u l=1u
X133 a_37178_3547# vbn.t477 a_36888_4127# VSS.t90 nfet_03v3 ad=0.56p pd=2.56u as=0.56p ps=2.56u w=2u l=1u
X134 VSS.t111 vbn.t34 a_60550_8387# VSS.t110 nfet_03v3 ad=0.9p pd=4.9u as=2.36p ps=6.36u w=2u l=0.28u
X135 a_37178_2387# vbn.t838 a_36888_1807# VSS.t93 nfet_03v3 ad=0.56p pd=2.56u as=0.56p ps=2.56u w=2u l=1u
X136 a_37178_1227# vbn.t60 a_36888_1807# VSS.t94 nfet_03v3 ad=0.56p pd=2.56u as=0.56p ps=2.56u w=2u l=1u
X137 a_36888_4127# vbn.t877 a_37178_3547# VSS.t90 nfet_03v3 ad=0.56p pd=2.56u as=0.56p ps=2.56u w=2u l=1u
X138 a_41854_1227# vbn.t720 VSS.t96 VSS.t95 nfet_03v3 ad=0.56p pd=2.56u as=0.9p ps=4.9u w=2u l=1u
X139 a_36888_7607# vbn.t668 a_37178_8187# VSS.t83 nfet_03v3 ad=0.56p pd=2.56u as=0.56p ps=2.56u w=2u l=1u
X140 a_36888_4127# vbn.t492 a_37178_4707# VSS.t89 nfet_03v3 ad=0.56p pd=2.56u as=0.56p ps=2.56u w=2u l=1u
X141 a_37178_7027# vbn.t631 a_36888_7607# VSS.t84 nfet_03v3 ad=0.56p pd=2.56u as=0.56p ps=2.56u w=2u l=1u
X142 a_41564_5287# vbn.t764 a_41854_4707# VSS.t88 nfet_03v3 ad=0.56p pd=2.56u as=0.56p ps=2.56u w=2u l=1u
X143 a_41854_2387# vbn.t730 a_41564_1807# VSS.t93 nfet_03v3 ad=0.56p pd=2.56u as=0.56p ps=2.56u w=2u l=1u
X144 a_41854_7027# vbn.t314 a_41564_7607# VSS.t84 nfet_03v3 ad=0.56p pd=2.56u as=0.9p ps=4.9u w=2u l=1u
X145 a_37178_1227# vbn.t359 a_36888_1807# VSS.t94 nfet_03v3 ad=0.56p pd=2.56u as=0.56p ps=2.56u w=2u l=1u
X146 a_37178_3547# vbn.t475 a_36888_4127# VSS.t90 nfet_03v3 ad=0.56p pd=2.56u as=0.56p ps=2.56u w=2u l=1u
X147 a_37178_3547# vbn.t451 a_36888_2967# VSS.t91 nfet_03v3 ad=0.56p pd=2.56u as=0.56p ps=2.56u w=2u l=1u
X148 a_36888_1807# vbn.t404 a_37178_2387# VSS.t93 nfet_03v3 ad=0.56p pd=2.56u as=0.56p ps=2.56u w=2u l=1u
X149 a_37178_5867# vbn.t160 a_36888_5287# VSS.t87 nfet_03v3 ad=0.56p pd=2.56u as=0.9p ps=4.9u w=2u l=1u
X150 a_37178_5867# vbn.t170 a_36888_6447# VSS.t86 nfet_03v3 ad=0.56p pd=2.56u as=0.56p ps=2.56u w=2u l=1u
X151 a_41564_4127# vbn.t278 a_41854_4707# VSS.t89 nfet_03v3 ad=0.56p pd=2.56u as=0.56p ps=2.56u w=2u l=1u
X152 a_37178_8187# vbn.t673 a_36888_7607# VSS.t83 nfet_03v3 ad=0.56p pd=2.56u as=0.56p ps=2.56u w=2u l=1u
X153 a_36888_7607# vbn.t636 a_37178_7027# VSS.t84 nfet_03v3 ad=0.56p pd=2.56u as=0.56p ps=2.56u w=2u l=1u
X154 a_36888_7607# vbn.t975 a_37178_8187# VSS.t83 nfet_03v3 ad=0.56p pd=2.56u as=0.56p ps=2.56u w=2u l=1u
X155 a_37178_5867# vbn.t158 a_36888_5287# VSS.t87 nfet_03v3 ad=0.56p pd=2.56u as=0.56p ps=2.56u w=2u l=1u
X156 a_41854_4707# vbn.t769 a_41564_5287# VSS.t88 nfet_03v3 ad=0.56p pd=2.56u as=0.9p ps=4.9u w=2u l=1u
X157 a_36866_9481# vbn.t688 a_37178_8187# VSS.t82 nfet_03v3 ad=0.56p pd=2.56u as=0.56p ps=2.56u w=2u l=1u
X158 a_36888_4127# vbn.t480 a_37178_3547# VSS.t90 nfet_03v3 ad=0.56p pd=2.56u as=0.56p ps=2.56u w=2u l=1u
X159 a_n4810_7514# a_n5549_6703# VDD_LS.t7 VDD_LS.t6 pfet_03v3 ad=0.56p pd=2.56u as=0.56p ps=2.56u w=2u l=0.28u
X160 a_36888_1807# vbn.t841 a_37178_2387# VSS.t93 nfet_03v3 ad=0.56p pd=2.56u as=0.56p ps=2.56u w=2u l=1u
X161 a_37178_1227# vbn.t820 a_36888_1807# VSS.t94 nfet_03v3 ad=0.56p pd=2.56u as=0.56p ps=2.56u w=2u l=1u
X162 a_37178_7027# vbn.t619 a_36888_6447# VSS.t85 nfet_03v3 ad=0.56p pd=2.56u as=0.56p ps=2.56u w=2u l=1u
X163 a_36888_4127# vbn.t889 a_37178_4707# VSS.t89 nfet_03v3 ad=0.9p pd=4.9u as=0.56p ps=2.56u w=2u l=1u
X164 a_41854_1227# vbn.t725 a_41564_1807# VSS.t94 nfet_03v3 ad=0.56p pd=2.56u as=0.56p ps=2.56u w=2u l=1u
X165 a_37178_8187# vbn.t671 a_36888_7607# VSS.t83 nfet_03v3 ad=0.56p pd=2.56u as=0.56p ps=2.56u w=2u l=1u
X166 a_37178_5867# vbn.t555 a_36888_5287# VSS.t87 nfet_03v3 ad=0.56p pd=2.56u as=0.56p ps=2.56u w=2u l=1u
X167 a_41854_2387# vbn.t735 a_41564_2967# VSS.t92 nfet_03v3 ad=0.9p pd=4.9u as=0.56p ps=2.56u w=2u l=1u
X168 a_36888_1807# vbn.t362 a_37178_1227# VSS.t94 nfet_03v3 ad=0.56p pd=2.56u as=0.56p ps=2.56u w=2u l=1u
X169 a_37178_4707# vbn.t501 a_36888_4127# VSS.t89 nfet_03v3 ad=0.56p pd=2.56u as=0.56p ps=2.56u w=2u l=1u
X170 vbn.t22 vbn.t21 a_41854_8187# VSS.t82 nfet_03v3 ad=0.56p pd=2.56u as=0.56p ps=2.56u w=2u l=1u
X171 a_36888_1807# vbn.t71 a_37178_2387# VSS.t93 nfet_03v3 ad=0.56p pd=2.56u as=0.56p ps=2.56u w=2u l=1u
X172 a_37178_7027# vbn.t192 a_36888_7607# VSS.t84 nfet_03v3 ad=0.56p pd=2.56u as=0.56p ps=2.56u w=2u l=1u
X173 a_37178_2387# vbn.t846 a_36888_1807# VSS.t78 nfet_03v3 ad=0.56p pd=2.56u as=0.9p ps=4.9u w=2u l=1u
X174 a_36888_2967# vbn.t865 a_37178_3547# VSS.t91 nfet_03v3 ad=0.56p pd=2.56u as=0.56p ps=2.56u w=2u l=1u
X175 a_996_6587# a_1867_7085# VDD.t41 VDD.t40 pfet_03v3 ad=2.25p pd=10.9u as=2.25p ps=10.9u w=5u l=0.28u
X176 a_36888_7607# vbn.t676 a_37178_8187# VSS.t83 nfet_03v3 ad=0.56p pd=2.56u as=0.56p ps=2.56u w=2u l=1u
X177 a_36866_9481# vbn.t987 a_37178_8187# VSS.t82 nfet_03v3 ad=0.9p pd=4.9u as=0.56p ps=2.56u w=2u l=1u
X178 a_37178_5867# vbn.t918 a_36888_5287# VSS.t87 nfet_03v3 ad=0.56p pd=2.56u as=0.56p ps=2.56u w=2u l=1u
X179 a_36888_1807# vbn.t831 a_37178_1227# VSS.t79 nfet_03v3 ad=0.56p pd=2.56u as=0.56p ps=2.56u w=2u l=1u
X180 a_41564_2967# vbn.t740 a_41854_2387# VSS.t92 nfet_03v3 ad=0.56p pd=2.56u as=0.56p ps=2.56u w=2u l=1u
X181 a_37178_3547# vbn.t463 a_36888_4127# VSS.t90 nfet_03v3 ad=0.56p pd=2.56u as=0.56p ps=2.56u w=2u l=1u
X182 w_36826_300# vbn.t324 a_37178_1227# VSS.t95 nfet_03v3 ad=0.56p pd=2.56u as=0.56p ps=2.56u w=2u l=1u
X183 a_41854_5867# vbn.t777 a_41564_6447# VSS.t86 nfet_03v3 ad=0.9p pd=4.9u as=0.56p ps=2.56u w=2u l=1u
X184 a_41854_5867# vbn.t774 a_41564_5287# VSS.t87 nfet_03v3 ad=0.56p pd=2.56u as=0.56p ps=2.56u w=2u l=1u
X185 a_36888_4127# vbn.t506 a_37178_4707# VSS.t89 nfet_03v3 ad=0.56p pd=2.56u as=0.56p ps=2.56u w=2u l=1u
X186 a_41854_3547# vbn.t272 a_41564_4127# VSS.t90 nfet_03v3 ad=0.56p pd=2.56u as=0.9p ps=4.9u w=2u l=1u
X187 a_37178_8187# vbn.t697 a_36866_9481# VSS.t82 nfet_03v3 ad=0.56p pd=2.56u as=0.56p ps=2.56u w=2u l=1u
X188 a_36888_5287# vbn.t558 a_37178_5867# VSS.t87 nfet_03v3 ad=0.56p pd=2.56u as=0.56p ps=2.56u w=2u l=1u
X189 a_36888_2967# vbn.t95 a_37178_3547# VSS.t91 nfet_03v3 ad=0.56p pd=2.56u as=0.56p ps=2.56u w=2u l=1u
X190 a_37178_2387# vbn.t76 a_36888_1807# VSS.t93 nfet_03v3 ad=0.56p pd=2.56u as=0.9p ps=4.9u w=2u l=1u
X191 a_37178_3547# vbn.t439 a_36888_2967# VSS.t91 nfet_03v3 ad=0.56p pd=2.56u as=0.56p ps=2.56u w=2u l=1u
X192 a_36888_6447# vbn.t949 a_37178_7027# VSS.t85 nfet_03v3 ad=0.56p pd=2.56u as=0.56p ps=2.56u w=2u l=1u
X193 VSS.t104 vbn.t236 a_41854_1227# VSS.t95 nfet_03v3 ad=0.56p pd=2.56u as=0.56p ps=2.56u w=2u l=1u
X194 a_41854_1227# vbn.t238 a_41564_1807# VSS.t94 nfet_03v3 ad=0.9p pd=4.9u as=0.56p ps=2.56u w=2u l=1u
X195 a_41564_6447# vbn.t782 a_41854_5867# VSS.t86 nfet_03v3 ad=0.56p pd=2.56u as=0.56p ps=2.56u w=2u l=1u
X196 a_36888_4127# vbn.t468 a_37178_3547# VSS.t90 nfet_03v3 ad=0.56p pd=2.56u as=0.56p ps=2.56u w=2u l=1u
X197 a_36888_2967# vbn.t93 a_37178_3547# VSS.t91 nfet_03v3 ad=0.56p pd=2.56u as=0.56p ps=2.56u w=2u l=1u
X198 a_37178_2387# vbn.t74 a_36888_1807# VSS.t93 nfet_03v3 ad=0.56p pd=2.56u as=0.56p ps=2.56u w=2u l=1u
X199 a_36866_9481# a_36866_9481# VDD.t11 VDD.t10 pfet_03v3 ad=3.92p pd=14.56u as=3.92p ps=14.56u w=14u l=14u
X200 a_36888_5287# vbn.t520 a_37178_4707# VSS.t88 nfet_03v3 ad=0.56p pd=2.56u as=0.56p ps=2.56u w=2u l=1u
X201 a_36888_5287# vbn.t929 a_37178_5867# VSS.t79 nfet_03v3 ad=0.56p pd=2.56u as=0.56p ps=2.56u w=2u l=1u
X202 a_37178_8187# vbn.t659 a_36888_7607# VSS.t83 nfet_03v3 ad=0.56p pd=2.56u as=0.56p ps=2.56u w=2u l=1u
X203 a_6206_14# bitb4.t0 VSS.t134 VSS.t133 nfet_03v3 ad=0.45p pd=2.9u as=0.45p ps=2.9u w=1u l=0.28u
X204 w_36826_300# vbn.t805 a_37178_1227# VSS.t95 nfet_03v3 ad=0.9p pd=4.9u as=0.56p ps=2.56u w=2u l=1u
X205 a_36866_9481# vbn.t702 a_37178_8187# VSS.t82 nfet_03v3 ad=0.56p pd=2.56u as=0.56p ps=2.56u w=2u l=1u
X206 a_36888_6447# vbn.t179 a_37178_7027# VSS.t85 nfet_03v3 ad=0.56p pd=2.56u as=0.56p ps=2.56u w=2u l=1u
X207 a_41854_8187# vbn.t321 a_41564_7607# VSS.t83 nfet_03v3 ad=0.56p pd=2.56u as=0.9p ps=4.9u w=2u l=1u
X208 a_37178_2387# vbn.t387 a_36888_1807# VSS.t93 nfet_03v3 ad=0.56p pd=2.56u as=0.56p ps=2.56u w=2u l=1u
X209 a_37178_7027# vbn.t607 a_36888_6447# VSS.t85 nfet_03v3 ad=0.56p pd=2.56u as=0.56p ps=2.56u w=2u l=1u
X210 a_37178_2387# vbn.t858 a_36888_2967# VSS.t80 nfet_03v3 ad=0.56p pd=2.56u as=0.56p ps=2.56u w=2u l=1u
X211 a_36888_7607# vbn.t650 a_37178_7027# VSS.t84 nfet_03v3 ad=0.56p pd=2.56u as=0.56p ps=2.56u w=2u l=1u
X212 a_41564_2967# vbn.t253 a_41854_2387# VSS.t92 nfet_03v3 ad=0.56p pd=2.56u as=0.56p ps=2.56u w=2u l=1u
X213 a_41564_5287# vbn.t285 a_41854_4707# VSS.t88 nfet_03v3 ad=0.56p pd=2.56u as=0.56p ps=2.56u w=2u l=1u
X214 a_41854_5867# vbn.t287 a_41564_5287# VSS.t87 nfet_03v3 ad=0.9p pd=4.9u as=0.56p ps=2.56u w=2u l=1u
X215 a_37178_1227# vbn.t333 w_36826_300# VSS.t95 nfet_03v3 ad=0.56p pd=2.56u as=0.56p ps=2.56u w=2u l=1u
X216 a_37178_3547# vbn.t108 a_36888_4127# VSS.t90 nfet_03v3 ad=0.56p pd=2.56u as=0.56p ps=2.56u w=2u l=1u
X217 a_37178_3547# vbn.t98 a_36888_2967# VSS.t91 nfet_03v3 ad=0.56p pd=2.56u as=0.56p ps=2.56u w=2u l=1u
X218 a_36888_7607# vbn.t664 a_37178_8187# VSS.t83 nfet_03v3 ad=0.56p pd=2.56u as=0.56p ps=2.56u w=2u l=1u
X219 a_36888_6447# vbn.t177 a_37178_7027# VSS.t85 nfet_03v3 ad=0.56p pd=2.56u as=0.56p ps=2.56u w=2u l=1u
X220 a_41564_1807# vbn.t241 a_41854_1227# VSS.t94 nfet_03v3 ad=0.56p pd=2.56u as=0.56p ps=2.56u w=2u l=1u
X221 a_37178_2387# vbn.t834 a_36888_1807# VSS.t93 nfet_03v3 ad=0.56p pd=2.56u as=0.56p ps=2.56u w=2u l=1u
X222 a_36888_5287# vbn.t903 a_37178_4707# VSS.t88 nfet_03v3 ad=0.9p pd=4.9u as=0.56p ps=2.56u w=2u l=1u
X223 a_41854_2387# vbn.t732 a_41564_1807# VSS.t93 nfet_03v3 ad=0.56p pd=2.56u as=0.56p ps=2.56u w=2u l=1u
X224 VSS.t43 vbnf.t23 vg.t0 VSS.t23 nfet_03v3 ad=0.336p pd=1.76u as=0.336p ps=1.76u w=1.2u l=5.335u
X225 a_37178_5867# vbn.t942 a_36888_6447# VSS.t80 nfet_03v3 ad=0.56p pd=2.56u as=0.56p ps=2.56u w=2u l=1u
X226 a_37178_7027# vbn.t655 a_36888_7607# VSS.t84 nfet_03v3 ad=0.56p pd=2.56u as=0.56p ps=2.56u w=2u l=1u
X227 a_41564_6447# vbn.t295 a_41854_5867# VSS.t86 nfet_03v3 ad=0.56p pd=2.56u as=0.56p ps=2.56u w=2u l=1u
X228 w_36826_300# vbn.t338 a_37178_1227# VSS.t95 nfet_03v3 ad=0.56p pd=2.56u as=0.56p ps=2.56u w=2u l=1u
X229 a_36888_2967# vbn.t103 a_37178_3547# VSS.t91 nfet_03v3 ad=0.56p pd=2.56u as=0.56p ps=2.56u w=2u l=1u
X230 a_37178_7027# vbn.t182 a_36888_6447# VSS.t85 nfet_03v3 ad=0.56p pd=2.56u as=0.56p ps=2.56u w=2u l=1u
X231 a_36888_1807# vbn.t390 a_37178_2387# VSS.t93 nfet_03v3 ad=0.56p pd=2.56u as=0.56p ps=2.56u w=2u l=1u
X232 a_37178_4707# vbn.t529 a_36888_5287# VSS.t88 nfet_03v3 ad=0.56p pd=2.56u as=0.56p ps=2.56u w=2u l=1u
X233 a_36888_4127# vbn.t494 a_37178_4707# VSS.t89 nfet_03v3 ad=0.56p pd=2.56u as=0.56p ps=2.56u w=2u l=1u
X234 a_37178_8187# vbn.t206 a_36888_7607# VSS.t83 nfet_03v3 ad=0.56p pd=2.56u as=0.56p ps=2.56u w=2u l=1u
X235 VSS.t154 VDD_LS.t31 VSS.t154 VSS.t153 nfet_03v3 ad=22.113p pd=99.18u as=0 ps=0 w=49.14u l=10u
X236 a_41854_2387# vbn.t256 a_41564_2967# VSS.t92 nfet_03v3 ad=0.56p pd=2.56u as=0.56p ps=2.56u w=2u l=1u
X237 a_41564_5287# vbn.t290 a_41854_5867# VSS.t87 nfet_03v3 ad=0.56p pd=2.56u as=0.56p ps=2.56u w=2u l=1u
X238 a_37178_4707# vbn.t120 a_36888_4127# VSS.t89 nfet_03v3 ad=0.56p pd=2.56u as=0.56p ps=2.56u w=2u l=1u
X239 a_36888_2967# vbn.t101 a_37178_3547# VSS.t91 nfet_03v3 ad=0.56p pd=2.56u as=0.56p ps=2.56u w=2u l=1u
X240 a_37178_7027# vbn.t966 a_36888_7607# VSS.t84 nfet_03v3 ad=0.56p pd=2.56u as=0.56p ps=2.56u w=2u l=1u
X241 a_36888_1807# vbn.t845 a_37178_2387# VSS.t79 nfet_03v3 ad=0.56p pd=2.56u as=0.56p ps=2.56u w=2u l=1u
X242 VDD_LS.t9 q1 a_n7286_7514# VDD_LS.t8 pfet_03v3 ad=0.336p pd=1.76u as=1.2p ps=4.4u w=1.2u l=0.28u
X243 a_37178_1227# vbn.t822 a_36888_1807# VSS.t94 nfet_03v3 ad=0.56p pd=2.56u as=0.56p ps=2.56u w=2u l=1u
X244 a_36888_5287# vbn.t534 a_37178_4707# VSS.t88 nfet_03v3 ad=0.56p pd=2.56u as=0.56p ps=2.56u w=2u l=1u
X245 a_36888_6447# vbn.t187 a_37178_7027# VSS.t85 nfet_03v3 ad=0.56p pd=2.56u as=0.56p ps=2.56u w=2u l=1u
X246 a_36888_7607# vbn.t638 a_37178_7027# VSS.t84 nfet_03v3 ad=0.56p pd=2.56u as=0.56p ps=2.56u w=2u l=1u
X247 a_n4642_7514# ls.t5 a_n4810_7514# VDD_LS.t19 pfet_03v3 ad=2p pd=6u as=0.56p ps=2.56u w=2u l=0.28u
X248 a_n4642_7514# a_n5549_6703# VSS.t8 VSS.t7 nfet_03v3 ad=1p pd=4u as=0.28p ps=1.56u w=1u l=0.28u
X249 VDD.t13 a_36866_9481# a_36866_9481# VDD.t12 pfet_03v3 ad=3.92p pd=14.56u as=3.92p ps=14.56u w=14u l=14u
X250 a_36866_9481# vbn.t690 a_37178_8187# VSS.t82 nfet_03v3 ad=0.56p pd=2.56u as=0.56p ps=2.56u w=2u l=1u
X251 a_36888_4127# vbn.t482 a_37178_3547# VSS.t90 nfet_03v3 ad=0.56p pd=2.56u as=0.56p ps=2.56u w=2u l=1u
X252 a_36888_2967# vbn.t458 a_37178_3547# VSS.t91 nfet_03v3 ad=0.56p pd=2.56u as=0.56p ps=2.56u w=2u l=1u
X253 a_41854_5867# vbn.t298 a_41564_6447# VSS.t86 nfet_03v3 ad=0.56p pd=2.56u as=0.56p ps=2.56u w=2u l=1u
X254 a_36888_4127# vbn.t125 a_37178_4707# VSS.t89 nfet_03v3 ad=0.56p pd=2.56u as=0.56p ps=2.56u w=2u l=1u
X255 a_36888_6447# vbn.t185 a_37178_7027# VSS.t85 nfet_03v3 ad=0.56p pd=2.56u as=0.56p ps=2.56u w=2u l=1u
X256 a_37178_7027# vbn.t194 a_36888_7607# VSS.t84 nfet_03v3 ad=0.56p pd=2.56u as=0.56p ps=2.56u w=2u l=1u
X257 a_41854_2387# vbn.t245 a_41564_1807# VSS.t93 nfet_03v3 ad=0.9p pd=4.9u as=0.56p ps=2.56u w=2u l=1u
X258 a_37178_8187# vbn.t218 a_36866_9481# VSS.t82 nfet_03v3 ad=0.56p pd=2.56u as=0.56p ps=2.56u w=2u l=1u
X259 a_36888_1807# vbn.t364 a_37178_1227# VSS.t94 nfet_03v3 ad=0.56p pd=2.56u as=0.56p ps=2.56u w=2u l=1u
X260 vbnf.t9 bit0.t0 a_6356_6633# VSS.t152 nfet_03v3 ad=0.9p pd=4.9u as=0.9p ps=4.9u w=2u l=0.28u
X261 a_37178_5867# vbn.t920 a_36888_5287# VSS.t87 nfet_03v3 ad=0.56p pd=2.56u as=0.56p ps=2.56u w=2u l=1u
X262 vg.t12 a_996_6587# a0.t1 VSS.t33 nfet_03v3 ad=0.9p pd=4.9u as=0.9p ps=4.9u w=2u l=0.28u
X263 a_36888_7607# vbn.t969 a_37178_7027# VSS.t81 nfet_03v3 ad=0.56p pd=2.56u as=0.56p ps=2.56u w=2u l=1u
X264 a_36888_2967# vbn.t867 a_37178_3547# VSS.t91 nfet_03v3 ad=0.56p pd=2.56u as=0.56p ps=2.56u w=2u l=1u
X265 a_36888_6447# vbn.t626 a_37178_7027# VSS.t85 nfet_03v3 ad=0.56p pd=2.56u as=0.56p ps=2.56u w=2u l=1u
X266 a_37178_3547# vbn.t487 a_36888_4127# VSS.t90 nfet_03v3 ad=0.56p pd=2.56u as=0.56p ps=2.56u w=2u l=1u
X267 VSS.t122 a_6206_14# vg.t27 VSS.t23 nfet_03v3 ad=0.336p pd=1.76u as=0.336p ps=1.76u w=1.2u l=5.335u
X268 a_36888_7607# vbn.t678 a_37178_8187# VSS.t83 nfet_03v3 ad=0.56p pd=2.56u as=0.56p ps=2.56u w=2u l=1u
X269 a_36866_9481# vbn.t223 a_37178_8187# VSS.t82 nfet_03v3 ad=0.56p pd=2.56u as=0.56p ps=2.56u w=2u l=1u
X270 w_36826_300# vbn.t326 a_37178_1227# VSS.t95 nfet_03v3 ad=0.56p pd=2.56u as=0.56p ps=2.56u w=2u l=1u
X271 a_37178_3547# vbn.t461 a_36888_2967# VSS.t91 nfet_03v3 ad=0.56p pd=2.56u as=0.9p ps=4.9u w=2u l=1u
X272 a_37178_1227# vbn.t369 a_36888_1807# VSS.t94 nfet_03v3 ad=0.56p pd=2.56u as=0.56p ps=2.56u w=2u l=1u
X273 VSS.t118 a_6206_14# vg.t35 VSS.t23 nfet_03v3 ad=0.336p pd=1.76u as=0.336p ps=1.76u w=1.2u l=5.335u
X274 a_41564_1807# vbn.t248 a_41854_2387# VSS.t93 nfet_03v3 ad=0.56p pd=2.56u as=0.56p ps=2.56u w=2u l=1u
X275 a_36888_5287# vbn.t560 a_37178_5867# VSS.t87 nfet_03v3 ad=0.56p pd=2.56u as=0.56p ps=2.56u w=2u l=1u
X276 a_37178_1227# vbn.t36 w_36826_300# VSS.t95 nfet_03v3 ad=0.56p pd=2.56u as=0.56p ps=2.56u w=2u l=1u
X277 a_37178_3547# vbn.t882 a_36888_4127# VSS.t90 nfet_03v3 ad=0.56p pd=2.56u as=0.56p ps=2.56u w=2u l=1u
X278 a_36888_6447# vbn.t951 a_37178_7027# VSS.t85 nfet_03v3 ad=0.56p pd=2.56u as=0.56p ps=2.56u w=2u l=1u
X279 a_37178_8187# vbn.t683 a_36888_7607# VSS.t83 nfet_03v3 ad=0.56p pd=2.56u as=0.56p ps=2.56u w=2u l=1u
X280 vbnf.t6 bitb3.t1 a_6206_896# VDD.t42 pfet_03v3 ad=2.25p pd=10.9u as=2.25p ps=10.9u w=5u l=0.28u
X281 a_36888_4127# vbn.t470 a_37178_3547# VSS.t90 nfet_03v3 ad=0.56p pd=2.56u as=0.56p ps=2.56u w=2u l=1u
X282 a_37178_3547# vbn.t870 a_36888_2967# VSS.t91 nfet_03v3 ad=0.56p pd=2.56u as=0.56p ps=2.56u w=2u l=1u
X283 a_37178_7027# vbn.t629 a_36888_6447# VSS.t85 nfet_03v3 ad=0.56p pd=2.56u as=0.9p ps=4.9u w=2u l=1u
X284 a_36888_5287# vbn.t522 a_37178_4707# VSS.t88 nfet_03v3 ad=0.56p pd=2.56u as=0.56p ps=2.56u w=2u l=1u
X285 a_37178_4707# vbn.t513 a_36888_4127# VSS.t89 nfet_03v3 ad=0.56p pd=2.56u as=0.56p ps=2.56u w=2u l=1u
X286 a_36888_2967# vbn.t406 a_37178_2387# VSS.t92 nfet_03v3 ad=0.9p pd=4.9u as=0.56p ps=2.56u w=2u l=1u
X287 a_37178_5867# vbn.t565 a_36888_5287# VSS.t87 nfet_03v3 ad=0.56p pd=2.56u as=0.56p ps=2.56u w=2u l=1u
X288 w_36826_300# vbn.t41 a_37178_1227# VSS.t95 nfet_03v3 ad=0.56p pd=2.56u as=0.56p ps=2.56u w=2u l=1u
X289 VSS.t160 VDD_LS.t28 VSS.t160 VSS.t159 nfet_03v3 ad=13.7592p pd=49.7u as=0 ps=0 w=49.14u l=10u
X290 VSS.t28 q1 a_n6436_6531# VSS.t27 nfet_03v3 ad=0.168p pd=1.16u as=0.168p ps=1.16u w=0.6u l=0.28u
X291 a_37178_3547# vbn.t110 a_36888_4127# VSS.t90 nfet_03v3 ad=0.56p pd=2.56u as=0.56p ps=2.56u w=2u l=1u
X292 a_37178_4707# vbn.t134 a_36888_5287# VSS.t88 nfet_03v3 ad=0.56p pd=2.56u as=0.56p ps=2.56u w=2u l=1u
X293 a_37178_4707# vbn.t511 a_36888_4127# VSS.t89 nfet_03v3 ad=0.56p pd=2.56u as=0.56p ps=2.56u w=2u l=1u
X294 a_36888_1807# vbn.t372 a_37178_1227# VSS.t94 nfet_03v3 ad=0.56p pd=2.56u as=0.56p ps=2.56u w=2u l=1u
X295 a_37178_8187# vbn.t980 a_36888_7607# VSS.t83 nfet_03v3 ad=0.56p pd=2.56u as=0.56p ps=2.56u w=2u l=1u
X296 a_37178_2387# vbn.t836 a_36888_1807# VSS.t93 nfet_03v3 ad=0.56p pd=2.56u as=0.56p ps=2.56u w=2u l=1u
X297 a_41564_7607# vbn.t794 a_41854_7027# VSS.t84 nfet_03v3 ad=0.56p pd=2.56u as=0.56p ps=2.56u w=2u l=1u
X298 a_37178_4707# vbn.t894 a_36888_4127# VSS.t89 nfet_03v3 ad=0.56p pd=2.56u as=0.56p ps=2.56u w=2u l=1u
X299 a_36888_4127# vbn.t885 a_37178_3547# VSS.t81 nfet_03v3 ad=0.56p pd=2.56u as=0.56p ps=2.56u w=2u l=1u
X300 a_36888_7607# vbn.t666 a_37178_8187# VSS.t83 nfet_03v3 ad=0.56p pd=2.56u as=0.56p ps=2.56u w=2u l=1u
X301 a_36888_6447# vbn.t574 a_37178_5867# VSS.t86 nfet_03v3 ad=0.9p pd=4.9u as=0.56p ps=2.56u w=2u l=1u
X302 a_37178_7027# vbn.t954 a_36888_6447# VSS.t85 nfet_03v3 ad=0.56p pd=2.56u as=0.56p ps=2.56u w=2u l=1u
X303 a_37178_8187# vbn.t709 a_36866_9481# VSS.t82 nfet_03v3 ad=0.56p pd=2.56u as=0.56p ps=2.56u w=2u l=1u
X304 a_37178_1227# vbn.t357 a_36888_1807# VSS.t94 nfet_03v3 ad=0.56p pd=2.56u as=0.56p ps=2.56u w=2u l=1u
X305 a_41564_7607# vbn.t792 a_41854_7027# VSS.t84 nfet_03v3 ad=0.56p pd=2.56u as=0.56p ps=2.56u w=2u l=1u
X306 a_41854_4707# vbn.t758 a_41564_4127# VSS.t89 nfet_03v3 ad=0.56p pd=2.56u as=0.56p ps=2.56u w=2u l=1u
X307 a_36888_5287# vbn.t139 a_37178_4707# VSS.t88 nfet_03v3 ad=0.56p pd=2.56u as=0.56p ps=2.56u w=2u l=1u
X308 a_37178_8187# vbn.t208 a_36888_7607# VSS.t83 nfet_03v3 ad=0.56p pd=2.56u as=0.56p ps=2.56u w=2u l=1u
X309 a_36888_4127# vbn.t516 a_37178_4707# VSS.t89 nfet_03v3 ad=0.56p pd=2.56u as=0.56p ps=2.56u w=2u l=1u
X310 a_37178_2387# vbn.t409 a_36888_2967# VSS.t92 nfet_03v3 ad=0.56p pd=2.56u as=0.56p ps=2.56u w=2u l=1u
X311 VSS.t68 vctrl.t0 vg.t18 VSS.t19 nfet_03v3 ad=0.54p pd=3.3u as=0.336p ps=1.76u w=1.2u l=21.335u
X312 a_36888_5287# vbn.t568 a_37178_5867# VSS.t87 nfet_03v3 ad=0.56p pd=2.56u as=0.56p ps=2.56u w=2u l=1u
X313 a_41854_3547# vbn.t261 a_41564_2967# VSS.t91 nfet_03v3 ad=0.56p pd=2.56u as=0.56p ps=2.56u w=2u l=1u
X314 a_37178_8187# vbn.t707 a_36866_9481# VSS.t82 nfet_03v3 ad=0.56p pd=2.56u as=0.56p ps=2.56u w=2u l=1u
X315 a_36888_1807# vbn.t392 a_37178_2387# VSS.t93 nfet_03v3 ad=0.56p pd=2.56u as=0.56p ps=2.56u w=2u l=1u
X316 a_36888_2967# vbn.t77 a_37178_2387# VSS.t92 nfet_03v3 ad=0.9p pd=4.9u as=0.56p ps=2.56u w=2u l=1u
X317 a_37178_8187# vbn.t992 a_36866_9481# VSS.t82 nfet_03v3 ad=0.56p pd=2.56u as=0.56p ps=2.56u w=2u l=1u
X318 a_36888_7607# vbn.t983 a_37178_8187# VSS.t81 nfet_03v3 ad=0.56p pd=2.56u as=0.56p ps=2.56u w=2u l=1u
X319 a_41854_7027# vbn.t797 a_41564_7607# VSS.t84 nfet_03v3 ad=0.56p pd=2.56u as=0.9p ps=4.9u w=2u l=1u
X320 a_36888_4127# vbn.t897 a_37178_4707# VSS.t89 nfet_03v3 ad=0.56p pd=2.56u as=0.56p ps=2.56u w=2u l=1u
X321 a_41854_8187# vbn.t13 vbn.t14 VSS.t82 nfet_03v3 ad=0.56p pd=2.56u as=0.56p ps=2.56u w=2u l=1u
X322 a_37178_5867# vbn.t577 a_36888_6447# VSS.t86 nfet_03v3 ad=0.56p pd=2.56u as=0.56p ps=2.56u w=2u l=1u
X323 a_37178_5867# vbn.t553 a_36888_5287# VSS.t87 nfet_03v3 ad=0.56p pd=2.56u as=0.56p ps=2.56u w=2u l=1u
X324 a_37178_1227# vbn.t345 w_36826_300# VSS.t95 nfet_03v3 ad=0.56p pd=2.56u as=0.56p ps=2.56u w=2u l=1u
X325 a_36866_9481# vbn.t712 a_37178_8187# VSS.t82 nfet_03v3 ad=0.56p pd=2.56u as=0.56p ps=2.56u w=2u l=1u
X326 a_41854_7027# vbn.t303 a_41564_6447# VSS.t85 nfet_03v3 ad=0.56p pd=2.56u as=0.56p ps=2.56u w=2u l=1u
X327 a_36888_2967# vbn.t444 a_37178_3547# VSS.t91 nfet_03v3 ad=0.56p pd=2.56u as=0.56p ps=2.56u w=2u l=1u
X328 a_37178_2387# vbn.t397 a_36888_1807# VSS.t93 nfet_03v3 ad=0.56p pd=2.56u as=0.56p ps=2.56u w=2u l=1u
X329 a_36888_6447# vbn.t161 a_37178_5867# VSS.t86 nfet_03v3 ad=0.9p pd=4.9u as=0.56p ps=2.56u w=2u l=1u
X330 a_37178_1227# vbn.t58 a_36888_1807# VSS.t94 nfet_03v3 ad=0.56p pd=2.56u as=0.56p ps=2.56u w=2u l=1u
X331 a_37178_1227# vbn.t343 w_36826_300# VSS.t95 nfet_03v3 ad=0.56p pd=2.56u as=0.56p ps=2.56u w=2u l=1u
X332 a_36888_4127# vbn.t127 a_37178_4707# VSS.t89 nfet_03v3 ad=0.56p pd=2.56u as=0.56p ps=2.56u w=2u l=1u
X333 a_n3607_6703# a_n3101_6703# VDD_LS.t21 VDD_LS.t20 pfet_03v3 ad=1.5p pd=5u as=0.675p ps=3.9u w=1.5u l=0.28u
X334 a_37178_4707# vbn.t902 a_36888_4127# VSS.t78 nfet_03v3 ad=0.56p pd=2.56u as=0.9p ps=4.9u w=2u l=1u
X335 a_41564_4127# vbn.t752 a_41854_3547# VSS.t90 nfet_03v3 ad=0.56p pd=2.56u as=0.56p ps=2.56u w=2u l=1u
X336 a_37178_1227# vbn.t810 w_36826_300# VSS.t95 nfet_03v3 ad=0.56p pd=2.56u as=0.56p ps=2.56u w=2u l=1u
X337 a_36866_9481# vbn.t995 a_37178_8187# VSS.t82 nfet_03v3 ad=0.56p pd=2.56u as=0.56p ps=2.56u w=2u l=1u
X338 a_36888_6447# vbn.t612 a_37178_7027# VSS.t85 nfet_03v3 ad=0.56p pd=2.56u as=0.56p ps=2.56u w=2u l=1u
X339 a_37178_4707# vbn.t541 a_36888_5287# VSS.t88 nfet_03v3 ad=0.56p pd=2.56u as=0.56p ps=2.56u w=2u l=1u
X340 a_37178_3547# vbn.t449 a_36888_2967# VSS.t91 nfet_03v3 ad=0.56p pd=2.56u as=0.56p ps=2.56u w=2u l=1u
X341 a_36888_2967# vbn.t863 a_37178_3547# VSS.t91 nfet_03v3 ad=0.56p pd=2.56u as=0.56p ps=2.56u w=2u l=1u
X342 a_41854_1227# vbn.t716 VSS.t100 VSS.t95 nfet_03v3 ad=0.56p pd=2.56u as=0.56p ps=2.56u w=2u l=1u
X343 a_41564_4127# vbn.t750 a_41854_3547# VSS.t90 nfet_03v3 ad=0.56p pd=2.56u as=0.56p ps=2.56u w=2u l=1u
X344 w_36826_300# vbn.t348 a_37178_1227# VSS.t95 nfet_03v3 ad=0.56p pd=2.56u as=0.56p ps=2.56u w=2u l=1u
X345 a_37178_4707# vbn.t132 a_36888_4127# VSS.t89 nfet_03v3 ad=0.56p pd=2.56u as=0.9p ps=4.9u w=2u l=1u
X346 VSS.t51 vbnf.t17 VSS.t51 VSS.t50 nfet_03v3 ad=13.7592p pd=49.7u as=0 ps=0 w=49.14u l=10u
X347 a_37178_4707# vbn.t539 a_36888_5287# VSS.t88 nfet_03v3 ad=0.56p pd=2.56u as=0.56p ps=2.56u w=2u l=1u
X348 a_37178_3547# vbn.t447 a_36888_2967# VSS.t91 nfet_03v3 ad=0.56p pd=2.56u as=0.56p ps=2.56u w=2u l=1u
X349 a_37178_2387# vbn.t423 a_36888_2967# VSS.t92 nfet_03v3 ad=0.56p pd=2.56u as=0.56p ps=2.56u w=2u l=1u
X350 a_36888_1807# vbn.t400 a_37178_2387# VSS.t93 nfet_03v3 ad=0.56p pd=2.56u as=0.56p ps=2.56u w=2u l=1u
X351 a_37178_5867# vbn.t156 a_36888_5287# VSS.t87 nfet_03v3 ad=0.56p pd=2.56u as=0.56p ps=2.56u w=2u l=1u
X352 a_36866_9481# vbn.t225 a_37178_8187# VSS.t82 nfet_03v3 ad=0.56p pd=2.56u as=0.56p ps=2.56u w=2u l=1u
X353 VSS.t39 vbnf.t20 VSS.t39 VSS.t38 nfet_03v3 ad=22.113p pd=99.18u as=0 ps=0 w=49.14u l=10u
X354 a_37178_8187# vbn.t1000 a_36866_9481# VSS.t78 nfet_03v3 ad=0.56p pd=2.56u as=0.9p ps=4.9u w=2u l=1u
X355 a_41564_7607# vbn.t801 a_41854_8187# VSS.t83 nfet_03v3 ad=0.56p pd=2.56u as=0.56p ps=2.56u w=2u l=1u
X356 a_37178_4707# vbn.t908 a_36888_5287# VSS.t88 nfet_03v3 ad=0.56p pd=2.56u as=0.56p ps=2.56u w=2u l=1u
X357 a_37178_7027# vbn.t617 a_36888_6447# VSS.t85 nfet_03v3 ad=0.56p pd=2.56u as=0.56p ps=2.56u w=2u l=1u
X358 a_36888_6447# vbn.t947 a_37178_7027# VSS.t85 nfet_03v3 ad=0.56p pd=2.56u as=0.56p ps=2.56u w=2u l=1u
X359 a_41854_3547# vbn.t755 a_41564_4127# VSS.t90 nfet_03v3 ad=0.56p pd=2.56u as=0.9p ps=4.9u w=2u l=1u
X360 a_37178_4707# vbn.t130 a_36888_4127# VSS.t89 nfet_03v3 ad=0.56p pd=2.56u as=0.56p ps=2.56u w=2u l=1u
X361 w_36826_300# vbn.t813 a_37178_1227# VSS.t95 nfet_03v3 ad=0.56p pd=2.56u as=0.56p ps=2.56u w=2u l=1u
X362 a_36888_7607# vbn.t632 a_37178_7027# VSS.t84 nfet_03v3 ad=0.56p pd=2.56u as=0.56p ps=2.56u w=2u l=1u
X363 a_37178_2387# vbn.t385 a_36888_1807# VSS.t93 nfet_03v3 ad=0.56p pd=2.56u as=0.56p ps=2.56u w=2u l=1u
X364 a_41564_7607# vbn.t799 a_41854_8187# VSS.t83 nfet_03v3 ad=0.56p pd=2.56u as=0.56p ps=2.56u w=2u l=1u
X365 a_41854_4707# vbn.t765 a_41564_5287# VSS.t88 nfet_03v3 ad=0.56p pd=2.56u as=0.56p ps=2.56u w=2u l=1u
X366 a_36888_2967# vbn.t452 a_37178_3547# VSS.t91 nfet_03v3 ad=0.56p pd=2.56u as=0.56p ps=2.56u w=2u l=1u
X367 a_37178_7027# vbn.t615 a_36888_6447# VSS.t85 nfet_03v3 ad=0.56p pd=2.56u as=0.56p ps=2.56u w=2u l=1u
X368 a_37178_5867# vbn.t591 a_36888_6447# VSS.t86 nfet_03v3 ad=0.56p pd=2.56u as=0.56p ps=2.56u w=2u l=1u
X369 a_36888_5287# vbn.t544 a_37178_4707# VSS.t88 nfet_03v3 ad=0.56p pd=2.56u as=0.56p ps=2.56u w=2u l=1u
X370 a_37178_4707# vbn.t499 a_36888_4127# VSS.t89 nfet_03v3 ad=0.56p pd=2.56u as=0.56p ps=2.56u w=2u l=1u
X371 a_n7601_6703# a_n7286_7514# VDD_LS.t3 VDD_LS.t2 pfet_03v3 ad=1.2p pd=4.4u as=0.54p ps=3.3u w=1.2u l=0.28u
X372 a_41854_1227# vbn.t721 a_41564_1807# VSS.t94 nfet_03v3 ad=0.9p pd=4.9u as=0.56p ps=2.56u w=2u l=1u
X373 a_37178_8187# vbn.t230 a_36866_9481# VSS.t82 nfet_03v3 ad=0.56p pd=2.56u as=0.9p ps=4.9u w=2u l=1u
X374 a_41564_7607# vbn.t313 a_41854_7027# VSS.t84 nfet_03v3 ad=0.56p pd=2.56u as=0.56p ps=2.56u w=2u l=1u
X375 a_n6694_7514# a_n7601_6703# VSS.t141 VSS.t140 nfet_03v3 ad=0.6p pd=3.2u as=0.168p ps=1.16u w=0.6u l=0.28u
X376 w_36826_300# vbn.t43 a_37178_1227# VSS.t95 nfet_03v3 ad=0.56p pd=2.56u as=0.56p ps=2.56u w=2u l=1u
X377 a_37178_1227# vbn.t818 w_36826_300# VSS.t78 nfet_03v3 ad=0.56p pd=2.56u as=0.9p ps=4.9u w=2u l=1u
X378 a_37178_8187# vbn.t228 a_36866_9481# VSS.t82 nfet_03v3 ad=0.56p pd=2.56u as=0.56p ps=2.56u w=2u l=1u
X379 a_41854_8187# vbn.t804 a_41564_7607# VSS.t83 nfet_03v3 ad=0.56p pd=2.56u as=0.9p ps=4.9u w=2u l=1u
X380 a_36888_5287# vbn.t911 a_37178_4707# VSS.t88 nfet_03v3 ad=0.56p pd=2.56u as=0.56p ps=2.56u w=2u l=1u
X381 a_36888_2967# vbn.t851 a_37178_2387# VSS.t92 nfet_03v3 ad=0.56p pd=2.56u as=0.56p ps=2.56u w=2u l=1u
X382 a_36888_6447# vbn.t620 a_37178_7027# VSS.t85 nfet_03v3 ad=0.56p pd=2.56u as=0.56p ps=2.56u w=2u l=1u
X383 a_1632_6633# a_452_6633# vg.t42 VSS.t149 nfet_03v3 ad=0.9p pd=4.9u as=0.9p ps=4.9u w=2u l=0.28u
X384 VSS.t47 vbnf.t19 VSS.t47 VSS.t46 nfet_03v3 ad=13.7592p pd=49.7u as=0 ps=0 w=49.14u l=10u
X385 a_36888_7607# vbn.t959 a_37178_7027# VSS.t84 nfet_03v3 ad=0.9p pd=4.9u as=0.56p ps=2.56u w=2u l=1u
X386 a_37178_4707# vbn.t890 a_36888_4127# VSS.t89 nfet_03v3 ad=0.56p pd=2.56u as=0.56p ps=2.56u w=2u l=1u
X387 a_41564_1807# vbn.t726 a_41854_1227# VSS.t94 nfet_03v3 ad=0.56p pd=2.56u as=0.56p ps=2.56u w=2u l=1u
X388 a_37178_8187# vbn.t695 a_36866_9481# VSS.t82 nfet_03v3 ad=0.56p pd=2.56u as=0.56p ps=2.56u w=2u l=1u
X389 a_41854_4707# vbn.t760 a_41564_4127# VSS.t89 nfet_03v3 ad=0.56p pd=2.56u as=0.56p ps=2.56u w=2u l=1u
X390 a_37178_3547# vbn.t435 a_36888_2967# VSS.t91 nfet_03v3 ad=0.56p pd=2.56u as=0.56p ps=2.56u w=2u l=1u
X391 a_41854_5867# vbn.t770 a_41564_5287# VSS.t87 nfet_03v3 ad=0.9p pd=4.9u as=0.56p ps=2.56u w=2u l=1u
X392 a_41854_3547# vbn.t265 a_41564_2967# VSS.t91 nfet_03v3 ad=0.56p pd=2.56u as=0.9p ps=4.9u w=2u l=1u
X393 a_37178_7027# vbn.t641 a_36888_7607# VSS.t84 nfet_03v3 ad=0.56p pd=2.56u as=0.56p ps=2.56u w=2u l=1u
X394 a_36888_4127# vbn.t502 a_37178_4707# VSS.t89 nfet_03v3 ad=0.56p pd=2.56u as=0.56p ps=2.56u w=2u l=1u
X395 a_37178_1227# vbn.t48 w_36826_300# VSS.t95 nfet_03v3 ad=0.56p pd=2.56u as=0.9p ps=4.9u w=2u l=1u
X396 VSS.t41 vbnf.t25 vg.t21 VSS.t23 nfet_03v3 ad=0.336p pd=1.76u as=0.336p ps=1.76u w=1.2u l=5.335u
X397 a_36888_2967# vbn.t81 a_37178_2387# VSS.t92 nfet_03v3 ad=0.56p pd=2.56u as=0.56p ps=2.56u w=2u l=1u
X398 a_37178_2387# vbn.t72 a_36888_1807# VSS.t93 nfet_03v3 ad=0.56p pd=2.56u as=0.56p ps=2.56u w=2u l=1u
X399 a_37178_2387# vbn.t411 a_36888_2967# VSS.t92 nfet_03v3 ad=0.56p pd=2.56u as=0.56p ps=2.56u w=2u l=1u
X400 a_36888_5287# vbn.t141 a_37178_4707# VSS.t88 nfet_03v3 ad=0.56p pd=2.56u as=0.56p ps=2.56u w=2u l=1u
X401 a_36888_6447# vbn.t935 a_37178_5867# VSS.t86 nfet_03v3 ad=0.56p pd=2.56u as=0.56p ps=2.56u w=2u l=1u
X402 a_37178_4707# vbn.t916 a_36888_5287# VSS.t78 nfet_03v3 ad=0.56p pd=2.56u as=0.9p ps=4.9u w=2u l=1u
X403 a_37178_1227# vbn.t46 w_36826_300# VSS.t95 nfet_03v3 ad=0.56p pd=2.56u as=0.56p ps=2.56u w=2u l=1u
X404 a_37178_8187# vbn.t988 a_36866_9481# VSS.t82 nfet_03v3 ad=0.56p pd=2.56u as=0.56p ps=2.56u w=2u l=1u
X405 a_37178_7027# vbn.t603 a_36888_6447# VSS.t85 nfet_03v3 ad=0.56p pd=2.56u as=0.56p ps=2.56u w=2u l=1u
X406 a_36888_4127# vbn.t464 a_37178_3547# VSS.t90 nfet_03v3 ad=0.56p pd=2.56u as=0.56p ps=2.56u w=2u l=1u
X407 a_36888_2967# vbn.t440 a_37178_3547# VSS.t91 nfet_03v3 ad=0.56p pd=2.56u as=0.56p ps=2.56u w=2u l=1u
X408 a_36888_2967# vbn.t79 a_37178_2387# VSS.t92 nfet_03v3 ad=0.56p pd=2.56u as=0.56p ps=2.56u w=2u l=1u
X409 a_36888_4127# vbn.t901 a_37178_4707# VSS.t79 nfet_03v3 ad=0.56p pd=2.56u as=0.56p ps=2.56u w=2u l=1u
X410 a_41854_8187# vbn.t9 vbn.t10 VSS.t82 nfet_03v3 ad=0.56p pd=2.56u as=0.56p ps=2.56u w=2u l=1u
X411 a_41564_5287# vbn.t775 a_41854_5867# VSS.t87 nfet_03v3 ad=0.56p pd=2.56u as=0.56p ps=2.56u w=2u l=1u
X412 a_41854_7027# vbn.t307 a_41564_6447# VSS.t85 nfet_03v3 ad=0.56p pd=2.56u as=0.9p ps=4.9u w=2u l=1u
X413 a_36888_7607# vbn.t646 a_37178_7027# VSS.t84 nfet_03v3 ad=0.56p pd=2.56u as=0.56p ps=2.56u w=2u l=1u
X414 a_37178_1227# vbn.t331 w_36826_300# VSS.t95 nfet_03v3 ad=0.56p pd=2.56u as=0.56p ps=2.56u w=2u l=1u
X415 a_36866_9481# vbn.t698 a_37178_8187# VSS.t82 nfet_03v3 ad=0.56p pd=2.56u as=0.56p ps=2.56u w=2u l=1u
X416 a_37178_4707# vbn.t146 a_36888_5287# VSS.t88 nfet_03v3 ad=0.56p pd=2.56u as=0.9p ps=4.9u w=2u l=1u
X417 a_36888_6447# vbn.t165 a_37178_5867# VSS.t86 nfet_03v3 ad=0.56p pd=2.56u as=0.56p ps=2.56u w=2u l=1u
X418 a_37178_1227# vbn.t830 a_36888_1807# VSS.t80 nfet_03v3 ad=0.56p pd=2.56u as=0.56p ps=2.56u w=2u l=1u
X419 a_37178_5867# vbn.t579 a_36888_6447# VSS.t86 nfet_03v3 ad=0.56p pd=2.56u as=0.56p ps=2.56u w=2u l=1u
X420 a_41564_1807# vbn.t239 a_41854_1227# VSS.t94 nfet_03v3 ad=0.56p pd=2.56u as=0.56p ps=2.56u w=2u l=1u
X421 a_41564_4127# vbn.t271 a_41854_3547# VSS.t90 nfet_03v3 ad=0.56p pd=2.56u as=0.56p ps=2.56u w=2u l=1u
X422 a_41854_4707# vbn.t273 a_41564_4127# VSS.t89 nfet_03v3 ad=0.9p pd=4.9u as=0.56p ps=2.56u w=2u l=1u
X423 VSS.t10 a_n7872_8894# VSS.t10 VSS.t9 nfet_03v3 ad=7.2p pd=32.9u as=0 ps=0 w=16u l=16u
X424 VSS.t112 a_6206_14# vg.t25 VSS.t23 nfet_03v3 ad=0.336p pd=1.76u as=0.336p ps=1.76u w=1.2u l=5.335u
X425 a_36888_6447# vbn.t608 a_37178_7027# VSS.t85 nfet_03v3 ad=0.56p pd=2.56u as=0.56p ps=2.56u w=2u l=1u
X426 a_37178_3547# vbn.t94 a_36888_2967# VSS.t91 nfet_03v3 ad=0.56p pd=2.56u as=0.56p ps=2.56u w=2u l=1u
X427 a_37178_2387# vbn.t84 a_36888_2967# VSS.t92 nfet_03v3 ad=0.56p pd=2.56u as=0.56p ps=2.56u w=2u l=1u
X428 a_36888_7607# vbn.t660 a_37178_8187# VSS.t83 nfet_03v3 ad=0.56p pd=2.56u as=0.56p ps=2.56u w=2u l=1u
X429 a_37178_4707# vbn.t144 a_36888_5287# VSS.t88 nfet_03v3 ad=0.56p pd=2.56u as=0.56p ps=2.56u w=2u l=1u
X430 a_36888_6447# vbn.t163 a_37178_5867# VSS.t86 nfet_03v3 ad=0.56p pd=2.56u as=0.56p ps=2.56u w=2u l=1u
X431 a_36866_9481# vbn.t999 a_37178_8187# VSS.t79 nfet_03v3 ad=0.56p pd=2.56u as=0.56p ps=2.56u w=2u l=1u
X432 vbn.t3 a_36866_9481# VDD.t15 VDD.t14 pfet_03v3 ad=3.92p pd=14.56u as=3.92p ps=14.56u w=14u l=14u
X433 a_36888_4127# vbn.t875 a_37178_3547# VSS.t90 nfet_03v3 ad=0.9p pd=4.9u as=0.56p ps=2.56u w=2u l=1u
X434 a_37178_1227# vbn.t806 w_36826_300# VSS.t95 nfet_03v3 ad=0.56p pd=2.56u as=0.56p ps=2.56u w=2u l=1u
X435 a_37178_4707# vbn.t527 a_36888_5287# VSS.t88 nfet_03v3 ad=0.56p pd=2.56u as=0.56p ps=2.56u w=2u l=1u
X436 a_41854_1227# vbn.t718 VSS.t98 VSS.t95 nfet_03v3 ad=0.56p pd=2.56u as=0.56p ps=2.56u w=2u l=1u
X437 a_41854_2387# vbn.t728 a_41564_1807# VSS.t93 nfet_03v3 ad=0.9p pd=4.9u as=0.56p ps=2.56u w=2u l=1u
X438 a_37178_5867# vbn.t928 a_36888_5287# VSS.t80 nfet_03v3 ad=0.56p pd=2.56u as=0.56p ps=2.56u w=2u l=1u
X439 a_37178_3547# vbn.t473 a_36888_4127# VSS.t90 nfet_03v3 ad=0.56p pd=2.56u as=0.56p ps=2.56u w=2u l=1u
X440 a_41564_5287# vbn.t288 a_41854_5867# VSS.t87 nfet_03v3 ad=0.56p pd=2.56u as=0.56p ps=2.56u w=2u l=1u
X441 w_36826_300# vbn.t334 a_37178_1227# VSS.t95 nfet_03v3 ad=0.56p pd=2.56u as=0.56p ps=2.56u w=2u l=1u
X442 a_36888_2967# vbn.t89 a_37178_2387# VSS.t92 nfet_03v3 ad=0.56p pd=2.56u as=0.56p ps=2.56u w=2u l=1u
X443 a_37178_5867# vbn.t168 a_36888_6447# VSS.t86 nfet_03v3 ad=0.56p pd=2.56u as=0.56p ps=2.56u w=2u l=1u
X444 a_37178_7027# vbn.t178 a_36888_6447# VSS.t85 nfet_03v3 ad=0.56p pd=2.56u as=0.56p ps=2.56u w=2u l=1u
X445 a_41564_7607# vbn.t320 a_41854_8187# VSS.t83 nfet_03v3 ad=0.56p pd=2.56u as=0.56p ps=2.56u w=2u l=1u
X446 a_41854_8187# vbn.t31 vbn.t32 VSS.t82 nfet_03v3 ad=0.9p pd=4.9u as=0.56p ps=2.56u w=2u l=1u
X447 a_41854_1227# vbn.t242 a_41564_1807# VSS.t94 nfet_03v3 ad=0.56p pd=2.56u as=0.56p ps=2.56u w=2u l=1u
X448 a_41564_4127# vbn.t276 a_41854_4707# VSS.t89 nfet_03v3 ad=0.56p pd=2.56u as=0.56p ps=2.56u w=2u l=1u
X449 VSS.t130 ls.t3 a_n4384_6451# VSS.t129 nfet_03v3 ad=0.28p pd=1.56u as=0.28p ps=1.56u w=1u l=0.28u
X450 a_37178_4707# vbn.t904 a_36888_5287# VSS.t88 nfet_03v3 ad=0.56p pd=2.56u as=0.56p ps=2.56u w=2u l=1u
X451 a_36888_2967# vbn.t87 a_37178_2387# VSS.t92 nfet_03v3 ad=0.56p pd=2.56u as=0.56p ps=2.56u w=2u l=1u
X452 a_36888_7607# vbn.t973 a_37178_8187# VSS.t83 nfet_03v3 ad=0.9p pd=4.9u as=0.56p ps=2.56u w=2u l=1u
X453 w_36826_300# vbn.t817 a_37178_1227# VSS.t79 nfet_03v3 ad=0.56p pd=2.56u as=0.56p ps=2.56u w=2u l=1u
X454 a_41854_4707# vbn.t767 a_41564_5287# VSS.t88 nfet_03v3 ad=0.56p pd=2.56u as=0.56p ps=2.56u w=2u l=1u
X455 a_41564_1807# vbn.t733 a_41854_2387# VSS.t93 nfet_03v3 ad=0.56p pd=2.56u as=0.56p ps=2.56u w=2u l=1u
X456 vbnf.t1 bitb2.t1 a_6206_4704# VDD.t18 pfet_03v3 ad=2.25p pd=10.9u as=2.25p ps=10.9u w=5u l=0.28u
X457 a_36888_4127# vbn.t478 a_37178_3547# VSS.t90 nfet_03v3 ad=0.56p pd=2.56u as=0.56p ps=2.56u w=2u l=1u
X458 a_36888_5287# vbn.t530 a_37178_4707# VSS.t88 nfet_03v3 ad=0.56p pd=2.56u as=0.56p ps=2.56u w=2u l=1u
X459 a_36888_6447# vbn.t173 a_37178_5867# VSS.t86 nfet_03v3 ad=0.56p pd=2.56u as=0.56p ps=2.56u w=2u l=1u
X460 vbnf.t10 bit4.t0 a_6206_14# VSS.t163 nfet_03v3 ad=0.9p pd=4.9u as=0.9p ps=4.9u w=2u l=0.28u
X461 a_37178_8187# vbn.t669 a_36888_7607# VSS.t83 nfet_03v3 ad=0.56p pd=2.56u as=0.56p ps=2.56u w=2u l=1u
X462 a_36888_7607# vbn.t634 a_37178_7027# VSS.t84 nfet_03v3 ad=0.56p pd=2.56u as=0.56p ps=2.56u w=2u l=1u
X463 VDD_LS.t18 ls.t6 a_n5234_7514# VDD_LS.t17 pfet_03v3 ad=0.56p pd=2.56u as=2p ps=6u w=2u l=0.28u
X464 a_36888_2967# vbn.t454 a_37178_3547# VSS.t91 nfet_03v3 ad=0.56p pd=2.56u as=0.56p ps=2.56u w=2u l=1u
X465 a_36888_2967# vbn.t430 a_37178_2387# VSS.t92 nfet_03v3 ad=0.56p pd=2.56u as=0.56p ps=2.56u w=2u l=1u
X466 a_41854_1227# vbn.t231 VSS.t109 VSS.t95 nfet_03v3 ad=0.9p pd=4.9u as=0.56p ps=2.56u w=2u l=1u
X467 a_41854_5867# vbn.t291 a_41564_5287# VSS.t87 nfet_03v3 ad=0.56p pd=2.56u as=0.56p ps=2.56u w=2u l=1u
X468 a_36888_6447# vbn.t171 a_37178_5867# VSS.t86 nfet_03v3 ad=0.56p pd=2.56u as=0.56p ps=2.56u w=2u l=1u
X469 a_37178_7027# vbn.t190 a_36888_7607# VSS.t84 nfet_03v3 ad=0.56p pd=2.56u as=0.56p ps=2.56u w=2u l=1u
X470 vbn.t26 vbn.t25 a_41854_8187# VSS.t82 nfet_03v3 ad=0.56p pd=2.56u as=0.56p ps=2.56u w=2u l=1u
X471 a_36888_5287# vbn.t915 a_37178_4707# VSS.t79 nfet_03v3 ad=0.56p pd=2.56u as=0.56p ps=2.56u w=2u l=1u
X472 a_37178_4707# vbn.t892 a_36888_4127# VSS.t89 nfet_03v3 ad=0.56p pd=2.56u as=0.56p ps=2.56u w=2u l=1u
X473 a_36888_7607# vbn.t674 a_37178_8187# VSS.t83 nfet_03v3 ad=0.56p pd=2.56u as=0.56p ps=2.56u w=2u l=1u
X474 a_36888_2967# vbn.t853 a_37178_2387# VSS.t92 nfet_03v3 ad=0.56p pd=2.56u as=0.56p ps=2.56u w=2u l=1u
X475 a_37178_2387# vbn.t844 a_36888_1807# VSS.t80 nfet_03v3 ad=0.56p pd=2.56u as=0.56p ps=2.56u w=2u l=1u
X476 a_37178_3547# vbn.t459 a_36888_2967# VSS.t91 nfet_03v3 ad=0.56p pd=2.56u as=0.56p ps=2.56u w=2u l=1u
X477 a_36888_6447# vbn.t622 a_37178_7027# VSS.t85 nfet_03v3 ad=0.56p pd=2.56u as=0.56p ps=2.56u w=2u l=1u
X478 a_36888_6447# vbn.t598 a_37178_5867# VSS.t86 nfet_03v3 ad=0.56p pd=2.56u as=0.56p ps=2.56u w=2u l=1u
X479 a_36888_7607# vbn.t195 a_37178_7027# VSS.t84 nfet_03v3 ad=0.56p pd=2.56u as=0.56p ps=2.56u w=2u l=1u
X480 a_41564_1807# vbn.t246 a_41854_2387# VSS.t93 nfet_03v3 ad=0.56p pd=2.56u as=0.56p ps=2.56u w=2u l=1u
X481 a_41854_4707# vbn.t280 a_41564_5287# VSS.t88 nfet_03v3 ad=0.9p pd=4.9u as=0.56p ps=2.56u w=2u l=1u
X482 a_36888_4127# vbn.t504 a_37178_4707# VSS.t89 nfet_03v3 ad=0.56p pd=2.56u as=0.56p ps=2.56u w=2u l=1u
X483 a_37178_2387# vbn.t433 a_36888_2967# VSS.t92 nfet_03v3 ad=0.56p pd=2.56u as=0.9p ps=4.9u w=2u l=1u
X484 VSS.t106 vbn.t234 a_41854_1227# VSS.t95 nfet_03v3 ad=0.56p pd=2.56u as=0.56p ps=2.56u w=2u l=1u
X485 w_36826_300# w_37991_300# VSS nwell r_width=2u r_length=5.025u
X486 a_n6436_6531# a_n6694_7514# a_n7286_7514# VSS.t25 nfet_03v3 ad=0.168p pd=1.16u as=0.6p ps=3.2u w=0.6u l=0.28u
X487 a_37178_8187# vbn.t990 a_36866_9481# VSS.t82 nfet_03v3 ad=0.56p pd=2.56u as=0.56p ps=2.56u w=2u l=1u
X488 a_37178_3547# vbn.t868 a_36888_2967# VSS.t91 nfet_03v3 ad=0.56p pd=2.56u as=0.56p ps=2.56u w=2u l=1u
X489 a_37178_7027# vbn.t627 a_36888_6447# VSS.t85 nfet_03v3 ad=0.56p pd=2.56u as=0.56p ps=2.56u w=2u l=1u
X490 a_36888_6447# vbn.t937 a_37178_5867# VSS.t86 nfet_03v3 ad=0.56p pd=2.56u as=0.56p ps=2.56u w=2u l=1u
X491 a_36888_1807# vbn.t350 a_37178_1227# VSS.t94 nfet_03v3 ad=0.9p pd=4.9u as=0.56p ps=2.56u w=2u l=1u
X492 a_36888_4127# vbn.t466 a_37178_3547# VSS.t90 nfet_03v3 ad=0.56p pd=2.56u as=0.56p ps=2.56u w=2u l=1u
X493 a_36888_2967# vbn.t442 a_37178_3547# VSS.t91 nfet_03v3 ad=0.56p pd=2.56u as=0.56p ps=2.56u w=2u l=1u
X494 a_37178_2387# vbn.t856 a_36888_2967# VSS.t92 nfet_03v3 ad=0.56p pd=2.56u as=0.56p ps=2.56u w=2u l=1u
X495 a_37178_5867# vbn.t601 a_36888_6447# VSS.t86 nfet_03v3 ad=0.56p pd=2.56u as=0.9p ps=4.9u w=2u l=1u
X496 a_37178_4707# vbn.t509 a_36888_4127# VSS.t89 nfet_03v3 ad=0.56p pd=2.56u as=0.56p ps=2.56u w=2u l=1u
X497 a_41854_2387# vbn.t249 a_41564_1807# VSS.t93 nfet_03v3 ad=0.56p pd=2.56u as=0.56p ps=2.56u w=2u l=1u
X498 a_41564_5287# vbn.t283 a_41854_4707# VSS.t88 nfet_03v3 ad=0.56p pd=2.56u as=0.56p ps=2.56u w=2u l=1u
X499 a_7096_6633# bitb1.t0 VSS.t67 VSS.t66 nfet_03v3 ad=0.45p pd=2.9u as=0.45p ps=2.9u w=1u l=0.28u
X500 a_36866_9481# vbn.t700 a_37178_8187# VSS.t82 nfet_03v3 ad=0.56p pd=2.56u as=0.56p ps=2.56u w=2u l=1u
X501 a_37178_3547# vbn.t106 a_36888_4127# VSS.t90 nfet_03v3 ad=0.56p pd=2.56u as=0.56p ps=2.56u w=2u l=1u
X502 a_37178_3547# vbn.t96 a_36888_2967# VSS.t91 nfet_03v3 ad=0.56p pd=2.56u as=0.56p ps=2.56u w=2u l=1u
X503 a_37178_7027# vbn.t952 a_36888_6447# VSS.t85 nfet_03v3 ad=0.56p pd=2.56u as=0.56p ps=2.56u w=2u l=1u
X504 vg.t38 a_6206_14# VSS.t127 VSS.t11 nfet_03v3 ad=0.336p pd=1.76u as=0.336p ps=1.76u w=1.2u l=5.335u
X505 a_37178_1227# vbn.t808 w_36826_300# VSS.t95 nfet_03v3 ad=0.56p pd=2.56u as=0.56p ps=2.56u w=2u l=1u
X506 VSS.t61 vbnf.t12 VSS.t61 VSS.t60 nfet_03v3 ad=13.7592p pd=49.7u as=0 ps=0 w=49.14u l=10u
X507 a_36888_6447# vbn.t610 a_37178_7027# VSS.t85 nfet_03v3 ad=0.56p pd=2.56u as=0.56p ps=2.56u w=2u l=1u
X508 VSS.t21 a_6206_896# vg.t3 VSS.t13 nfet_03v3 ad=0.54p pd=3.3u as=0.336p ps=1.76u w=1.2u l=5.335u
X509 a_36888_2967# vbn.t871 a_37178_3547# VSS.t81 nfet_03v3 ad=0.56p pd=2.56u as=0.56p ps=2.56u w=2u l=1u
X510 a_36888_7607# vbn.t662 a_37178_8187# VSS.t83 nfet_03v3 ad=0.56p pd=2.56u as=0.56p ps=2.56u w=2u l=1u
X511 a_37178_7027# vbn.t653 a_36888_7607# VSS.t84 nfet_03v3 ad=0.56p pd=2.56u as=0.56p ps=2.56u w=2u l=1u
X512 a_36888_5287# vbn.t546 a_37178_5867# VSS.t87 nfet_03v3 ad=0.9p pd=4.9u as=0.56p ps=2.56u w=2u l=1u
X513 a_37178_5867# vbn.t940 a_36888_6447# VSS.t86 nfet_03v3 ad=0.56p pd=2.56u as=0.56p ps=2.56u w=2u l=1u
X514 a_37178_8187# vbn.t705 a_36866_9481# VSS.t82 nfet_03v3 ad=0.56p pd=2.56u as=0.56p ps=2.56u w=2u l=1u
X515 a_36888_4127# vbn.t111 a_37178_3547# VSS.t90 nfet_03v3 ad=0.56p pd=2.56u as=0.56p ps=2.56u w=2u l=1u
X516 a_37178_7027# vbn.t180 a_36888_6447# VSS.t85 nfet_03v3 ad=0.56p pd=2.56u as=0.56p ps=2.56u w=2u l=1u
X517 a_37178_1227# vbn.t353 a_36888_1807# VSS.t94 nfet_03v3 ad=0.56p pd=2.56u as=0.56p ps=2.56u w=2u l=1u
X518 a_37178_8187# vbn.t204 a_36888_7607# VSS.t83 nfet_03v3 ad=0.56p pd=2.56u as=0.56p ps=2.56u w=2u l=1u
X519 a_36888_4127# vbn.t512 a_37178_4707# VSS.t89 nfet_03v3 ad=0.56p pd=2.56u as=0.56p ps=2.56u w=2u l=1u
X520 a_37178_7027# vbn.t651 a_36888_7607# VSS.t84 nfet_03v3 ad=0.56p pd=2.56u as=0.56p ps=2.56u w=2u l=1u
X521 a_36888_1807# vbn.t49 a_37178_1227# VSS.t94 nfet_03v3 ad=0.9p pd=4.9u as=0.56p ps=2.56u w=2u l=1u
X522 a_41854_2387# vbn.t254 a_41564_2967# VSS.t92 nfet_03v3 ad=0.56p pd=2.56u as=0.56p ps=2.56u w=2u l=1u
X523 w_36826_300# vbn.t336 a_37178_1227# VSS.t95 nfet_03v3 ad=0.56p pd=2.56u as=0.56p ps=2.56u w=2u l=1u
X524 a_37178_4707# vbn.t906 a_36888_5287# VSS.t88 nfet_03v3 ad=0.56p pd=2.56u as=0.56p ps=2.56u w=2u l=1u
X525 a_37178_7027# vbn.t964 a_36888_7607# VSS.t84 nfet_03v3 ad=0.56p pd=2.56u as=0.56p ps=2.56u w=2u l=1u
X526 a_36888_6447# vbn.t955 a_37178_7027# VSS.t81 nfet_03v3 ad=0.56p pd=2.56u as=0.56p ps=2.56u w=2u l=1u
X527 vg.t13 a_6206_4704# VSS.t36 VSS.t17 nfet_03v3 ad=0.336p pd=1.76u as=0.336p ps=1.76u w=1.2u l=5.335u
X528 a_41854_7027# vbn.t793 a_41564_7607# VSS.t84 nfet_03v3 ad=0.56p pd=2.56u as=0.56p ps=2.56u w=2u l=1u
X529 a_37178_4707# vbn.t497 a_36888_4127# VSS.t89 nfet_03v3 ad=0.56p pd=2.56u as=0.56p ps=2.56u w=2u l=1u
X530 a_36888_7607# vbn.t209 a_37178_8187# VSS.t83 nfet_03v3 ad=0.56p pd=2.56u as=0.56p ps=2.56u w=2u l=1u
X531 a_36888_7607# vbn.t656 a_37178_7027# VSS.t84 nfet_03v3 ad=0.56p pd=2.56u as=0.56p ps=2.56u w=2u l=1u
X532 a_37178_5867# vbn.t549 a_36888_5287# VSS.t87 nfet_03v3 ad=0.56p pd=2.56u as=0.56p ps=2.56u w=2u l=1u
X533 a_37178_1227# vbn.t341 w_36826_300# VSS.t95 nfet_03v3 ad=0.56p pd=2.56u as=0.56p ps=2.56u w=2u l=1u
X534 a_41854_5867# vbn.t296 a_41564_6447# VSS.t86 nfet_03v3 ad=0.56p pd=2.56u as=0.56p ps=2.56u w=2u l=1u
X535 VSS.t57 vbnf.t14 VSS.t57 VSS.t56 nfet_03v3 ad=13.7592p pd=49.7u as=0 ps=0 w=49.14u l=10u
X536 a_36866_9481# vbn.t708 a_37178_8187# VSS.t82 nfet_03v3 ad=0.56p pd=2.56u as=0.56p ps=2.56u w=2u l=1u
X537 a_36888_5287# vbn.t532 a_37178_4707# VSS.t88 nfet_03v3 ad=0.56p pd=2.56u as=0.56p ps=2.56u w=2u l=1u
X538 a_36888_2967# vbn.t416 a_37178_2387# VSS.t92 nfet_03v3 ad=0.56p pd=2.56u as=0.56p ps=2.56u w=2u l=1u
X539 a_36888_5287# vbn.t147 a_37178_5867# VSS.t87 nfet_03v3 ad=0.9p pd=4.9u as=0.56p ps=2.56u w=2u l=1u
X540 a_36888_7607# vbn.t967 a_37178_7027# VSS.t84 nfet_03v3 ad=0.56p pd=2.56u as=0.56p ps=2.56u w=2u l=1u
X541 a_41564_2967# vbn.t745 a_41854_3547# VSS.t91 nfet_03v3 ad=0.56p pd=2.56u as=0.56p ps=2.56u w=2u l=1u
X542 a_37178_8187# vbn.t693 a_36866_9481# VSS.t82 nfet_03v3 ad=0.56p pd=2.56u as=0.56p ps=2.56u w=2u l=1u
X543 a_36888_1807# vbn.t378 a_37178_2387# VSS.t93 nfet_03v3 ad=0.9p pd=4.9u as=0.56p ps=2.56u w=2u l=1u
X544 a_37178_3547# vbn.t485 a_36888_4127# VSS.t90 nfet_03v3 ad=0.56p pd=2.56u as=0.56p ps=2.56u w=2u l=1u
X545 a_36888_6447# vbn.t584 a_37178_5867# VSS.t86 nfet_03v3 ad=0.56p pd=2.56u as=0.56p ps=2.56u w=2u l=1u
X546 a_37178_4707# vbn.t537 a_36888_5287# VSS.t88 nfet_03v3 ad=0.56p pd=2.56u as=0.56p ps=2.56u w=2u l=1u
X547 a_37178_2387# vbn.t421 a_36888_2967# VSS.t92 nfet_03v3 ad=0.56p pd=2.56u as=0.56p ps=2.56u w=2u l=1u
X548 VSS.t124 a_6206_14# vg.t29 VSS.t13 nfet_03v3 ad=0.54p pd=3.3u as=0.336p ps=1.76u w=1.2u l=5.335u
X549 VSS.t45 vbnf.t21 vg.t40 VSS.t19 nfet_03v3 ad=0.336p pd=1.76u as=0.336p ps=1.76u w=1.2u l=5.335u
X550 a_36888_2967# vbn.t849 a_37178_2387# VSS.t92 nfet_03v3 ad=0.56p pd=2.56u as=0.56p ps=2.56u w=2u l=1u
X551 a_41564_2967# vbn.t743 a_41854_3547# VSS.t91 nfet_03v3 ad=0.56p pd=2.56u as=0.56p ps=2.56u w=2u l=1u
X552 w_36826_300# vbn.t344 a_37178_1227# VSS.t95 nfet_03v3 ad=0.56p pd=2.56u as=0.56p ps=2.56u w=2u l=1u
X553 VSS.t119 a_6206_14# vg.t36 VSS.t13 nfet_03v3 ad=0.54p pd=3.3u as=0.336p ps=1.76u w=1.2u l=5.335u
X554 a_37178_3547# vbn.t483 a_36888_4127# VSS.t90 nfet_03v3 ad=0.56p pd=2.56u as=0.56p ps=2.56u w=2u l=1u
X555 a_37178_1227# vbn.t367 a_36888_1807# VSS.t94 nfet_03v3 ad=0.56p pd=2.56u as=0.56p ps=2.56u w=2u l=1u
X556 a_37178_2387# vbn.t419 a_36888_2967# VSS.t92 nfet_03v3 ad=0.56p pd=2.56u as=0.56p ps=2.56u w=2u l=1u
X557 a_37178_4707# vbn.t128 a_36888_4127# VSS.t89 nfet_03v3 ad=0.56p pd=2.56u as=0.56p ps=2.56u w=2u l=1u
X558 a_36888_7607# vbn.t197 a_37178_7027# VSS.t84 nfet_03v3 ad=0.56p pd=2.56u as=0.56p ps=2.56u w=2u l=1u
X559 a_37178_7027# vbn.t972 a_36888_7607# VSS.t78 nfet_03v3 ad=0.56p pd=2.56u as=0.9p ps=4.9u w=2u l=1u
X560 a_41564_6447# vbn.t787 a_41854_7027# VSS.t85 nfet_03v3 ad=0.56p pd=2.56u as=0.56p ps=2.56u w=2u l=1u
X561 a_n7872_8894# ls.t2 VSS.t137 ppolyf_u_1k r_width=1u r_length=0.15912m
X562 VDD.t25 VSS.t164 a_60550_8387# VDD.t24 pfet_03v3 ad=0.225p pd=1.9u as=0.225p ps=1.9u w=0.5u l=10u
X563 a_37178_3547# vbn.t880 a_36888_4127# VSS.t90 nfet_03v3 ad=0.56p pd=2.56u as=0.56p ps=2.56u w=2u l=1u
X564 a_37178_8187# vbn.t681 a_36888_7607# VSS.t83 nfet_03v3 ad=0.56p pd=2.56u as=0.56p ps=2.56u w=2u l=1u
X565 a_37178_5867# vbn.t589 a_36888_6447# VSS.t86 nfet_03v3 ad=0.56p pd=2.56u as=0.56p ps=2.56u w=2u l=1u
X566 a_36888_6447# vbn.t933 a_37178_5867# VSS.t86 nfet_03v3 ad=0.56p pd=2.56u as=0.56p ps=2.56u w=2u l=1u
X567 a_37178_1227# vbn.t329 w_36826_300# VSS.t95 nfet_03v3 ad=0.56p pd=2.56u as=0.56p ps=2.56u w=2u l=1u
X568 a_41564_6447# vbn.t785 a_41854_7027# VSS.t85 nfet_03v3 ad=0.56p pd=2.56u as=0.56p ps=2.56u w=2u l=1u
X569 a_41854_3547# vbn.t751 a_41564_4127# VSS.t90 nfet_03v3 ad=0.56p pd=2.56u as=0.56p ps=2.56u w=2u l=1u
X570 a_41854_3547# vbn.t748 a_41564_2967# VSS.t91 nfet_03v3 ad=0.56p pd=2.56u as=0.9p ps=4.9u w=2u l=1u
X571 a_37178_2387# vbn.t381 a_36888_1807# VSS.t93 nfet_03v3 ad=0.56p pd=2.56u as=0.56p ps=2.56u w=2u l=1u
X572 vg.t10 a_7096_6633# VSS.t32 VSS.t17 nfet_03v3 ad=0.336p pd=1.76u as=0.336p ps=1.76u w=1.2u l=5.335u
X573 a_36888_4127# vbn.t488 a_37178_3547# VSS.t90 nfet_03v3 ad=0.56p pd=2.56u as=0.56p ps=2.56u w=2u l=1u
X574 vbnf.t3 bitb0.t1 a_6356_6633# VDD.t22 pfet_03v3 ad=2.25p pd=10.9u as=2.25p ps=10.9u w=5u l=0.28u
X575 a_37178_8187# vbn.t679 a_36888_7607# VSS.t83 nfet_03v3 ad=0.56p pd=2.56u as=0.56p ps=2.56u w=2u l=1u
X576 a_37178_5867# vbn.t587 a_36888_6447# VSS.t86 nfet_03v3 ad=0.56p pd=2.56u as=0.56p ps=2.56u w=2u l=1u
X577 a_37178_5867# vbn.t563 a_36888_5287# VSS.t87 nfet_03v3 ad=0.56p pd=2.56u as=0.56p ps=2.56u w=2u l=1u
X578 a_36888_5287# vbn.t540 a_37178_4707# VSS.t88 nfet_03v3 ad=0.56p pd=2.56u as=0.56p ps=2.56u w=2u l=1u
X579 a_36888_2967# vbn.t424 a_37178_2387# VSS.t92 nfet_03v3 ad=0.56p pd=2.56u as=0.56p ps=2.56u w=2u l=1u
X580 a_37178_7027# vbn.t202 a_36888_7607# VSS.t84 nfet_03v3 ad=0.56p pd=2.56u as=0.9p ps=4.9u w=2u l=1u
X581 VDD.t1 a_996_6587# a0.t0 VDD.t0 pfet_03v3 ad=2.25p pd=10.9u as=2.25p ps=10.9u w=5u l=0.28u
X582 a_36888_1807# vbn.t63 a_37178_2387# VSS.t93 nfet_03v3 ad=0.9p pd=4.9u as=0.56p ps=2.56u w=2u l=1u
X583 a_37178_8187# vbn.t226 a_36866_9481# VSS.t82 nfet_03v3 ad=0.56p pd=2.56u as=0.56p ps=2.56u w=2u l=1u
X584 ck.t1 a_n8217_6703# VDD_LS.t1 VDD_LS.t0 pfet_03v3 ad=2.5p pd=7u as=1.125p ps=5.9u w=2.5u l=0.28u
X585 a_n5549_6703# a_n5234_7514# VDD_LS.t12 VDD_LS.t11 pfet_03v3 ad=2p pd=6u as=0.9p ps=4.9u w=2u l=0.28u
X586 VDD.t29 vg.t48 VDD.t29 VDD.t28 pfet_03v3 ad=13.419p pd=60.54u as=0 ps=0 w=29.82u l=4.12u
X587 vg.t1 a_6206_896# VSS.t18 VSS.t17 nfet_03v3 ad=0.336p pd=1.76u as=0.336p ps=1.76u w=1.2u l=5.335u
X588 a_37178_8187# vbn.t978 a_36888_7607# VSS.t83 nfet_03v3 ad=0.56p pd=2.56u as=0.56p ps=2.56u w=2u l=1u
X589 a_37178_7027# vbn.t200 a_36888_7607# VSS.t84 nfet_03v3 ad=0.56p pd=2.56u as=0.56p ps=2.56u w=2u l=1u
X590 a_36888_1807# vbn.t823 a_37178_1227# VSS.t94 nfet_03v3 ad=0.56p pd=2.56u as=0.56p ps=2.56u w=2u l=1u
X591 a_41854_7027# vbn.t790 a_41564_6447# VSS.t85 nfet_03v3 ad=0.56p pd=2.56u as=0.9p ps=4.9u w=2u l=1u
X592 a_37178_4707# vbn.t525 a_36888_5287# VSS.t88 nfet_03v3 ad=0.56p pd=2.56u as=0.56p ps=2.56u w=2u l=1u
X593 a_36888_4127# vbn.t883 a_37178_3547# VSS.t90 nfet_03v3 ad=0.56p pd=2.56u as=0.56p ps=2.56u w=2u l=1u
X594 a_41854_8187# vbn.t800 a_41564_7607# VSS.t83 nfet_03v3 ad=0.56p pd=2.56u as=0.56p ps=2.56u w=2u l=1u
X595 a_36888_7607# vbn.t684 a_37178_8187# VSS.t83 nfet_03v3 ad=0.56p pd=2.56u as=0.56p ps=2.56u w=2u l=1u
X596 a_37178_7027# vbn.t639 a_36888_7607# VSS.t84 nfet_03v3 ad=0.56p pd=2.56u as=0.56p ps=2.56u w=2u l=1u
X597 a_36888_6447# vbn.t592 a_37178_5867# VSS.t86 nfet_03v3 ad=0.56p pd=2.56u as=0.56p ps=2.56u w=2u l=1u
X598 a_41854_4707# vbn.t756 a_41564_4127# VSS.t89 nfet_03v3 ad=0.9p pd=4.9u as=0.56p ps=2.56u w=2u l=1u
X599 a_37178_2387# vbn.t407 a_36888_2967# VSS.t92 nfet_03v3 ad=0.56p pd=2.56u as=0.56p ps=2.56u w=2u l=1u
X600 a_41854_2387# vbn.t258 a_41564_2967# VSS.t92 nfet_03v3 ad=0.56p pd=2.56u as=0.9p ps=4.9u w=2u l=1u
X601 a_36888_4127# vbn.t113 a_37178_3547# VSS.t90 nfet_03v3 ad=0.56p pd=2.56u as=0.56p ps=2.56u w=2u l=1u
X602 a_36888_1807# vbn.t53 a_37178_1227# VSS.t94 nfet_03v3 ad=0.56p pd=2.56u as=0.56p ps=2.56u w=2u l=1u
X603 a_37178_1227# vbn.t44 w_36826_300# VSS.t95 nfet_03v3 ad=0.56p pd=2.56u as=0.56p ps=2.56u w=2u l=1u
X604 a_37178_1227# vbn.t355 a_36888_1807# VSS.t94 nfet_03v3 ad=0.56p pd=2.56u as=0.56p ps=2.56u w=2u l=1u
X605 a_37178_3547# vbn.t888 a_36888_4127# VSS.t78 nfet_03v3 ad=0.56p pd=2.56u as=0.9p ps=4.9u w=2u l=1u
X606 a_36888_7607# vbn.t981 a_37178_8187# VSS.t83 nfet_03v3 ad=0.56p pd=2.56u as=0.56p ps=2.56u w=2u l=1u
X607 a_36888_5287# vbn.t921 a_37178_5867# VSS.t87 nfet_03v3 ad=0.56p pd=2.56u as=0.56p ps=2.56u w=2u l=1u
X608 a_37178_7027# vbn.t960 a_36888_7607# VSS.t84 nfet_03v3 ad=0.56p pd=2.56u as=0.56p ps=2.56u w=2u l=1u
X609 a_41564_4127# vbn.t761 a_41854_4707# VSS.t89 nfet_03v3 ad=0.56p pd=2.56u as=0.56p ps=2.56u w=2u l=1u
X610 a_36888_1807# vbn.t51 a_37178_1227# VSS.t94 nfet_03v3 ad=0.56p pd=2.56u as=0.56p ps=2.56u w=2u l=1u
X611 a_6206_4704# bitb2.t0 VSS.t65 VSS.t64 nfet_03v3 ad=0.45p pd=2.9u as=0.45p ps=2.9u w=1u l=0.28u
X612 a_41854_7027# vbn.t795 a_41564_7607# VSS.t84 nfet_03v3 ad=0.56p pd=2.56u as=0.56p ps=2.56u w=2u l=1u
X613 a_36888_2967# vbn.t436 a_37178_3547# VSS.t91 nfet_03v3 ad=0.56p pd=2.56u as=0.56p ps=2.56u w=2u l=1u
X614 a_36888_2967# vbn.t412 a_37178_2387# VSS.t92 nfet_03v3 ad=0.56p pd=2.56u as=0.56p ps=2.56u w=2u l=1u
X615 a_41854_8187# vbn.t17 vbn.t18 VSS.t82 nfet_03v3 ad=0.9p pd=4.9u as=0.56p ps=2.56u w=2u l=1u
X616 a_37178_5867# vbn.t575 a_36888_6447# VSS.t86 nfet_03v3 ad=0.56p pd=2.56u as=0.56p ps=2.56u w=2u l=1u
X617 a_36888_7607# vbn.t642 a_37178_7027# VSS.t84 nfet_03v3 ad=0.56p pd=2.56u as=0.56p ps=2.56u w=2u l=1u
X618 a_37178_3547# vbn.t118 a_36888_4127# VSS.t90 nfet_03v3 ad=0.56p pd=2.56u as=0.9p ps=4.9u w=2u l=1u
X619 a_41854_5867# vbn.t300 a_41564_6447# VSS.t86 nfet_03v3 ad=0.56p pd=2.56u as=0.9p ps=4.9u w=2u l=1u
X620 a_37178_2387# vbn.t395 a_36888_1807# VSS.t93 nfet_03v3 ad=0.56p pd=2.56u as=0.56p ps=2.56u w=2u l=1u
X621 ls.t1 a_n3607_6703# VDD_LS.t16 VDD_LS.t15 pfet_03v3 ad=3p pd=8u as=1.35p ps=6.9u w=3u l=0.28u
X622 a_37178_4707# vbn.t142 a_36888_5287# VSS.t88 nfet_03v3 ad=0.56p pd=2.56u as=0.56p ps=2.56u w=2u l=1u
X623 a_36888_5287# vbn.t151 a_37178_5867# VSS.t87 nfet_03v3 ad=0.56p pd=2.56u as=0.56p ps=2.56u w=2u l=1u
X624 a_36888_7607# vbn.t211 a_37178_8187# VSS.t83 nfet_03v3 ad=0.56p pd=2.56u as=0.56p ps=2.56u w=2u l=1u
X625 a_37178_8187# vbn.t986 a_36888_7607# VSS.t78 nfet_03v3 ad=0.56p pd=2.56u as=0.9p ps=4.9u w=2u l=1u
X626 a_37178_5867# vbn.t551 a_36888_5287# VSS.t87 nfet_03v3 ad=0.56p pd=2.56u as=0.56p ps=2.56u w=2u l=1u
X627 a_41564_2967# vbn.t264 a_41854_3547# VSS.t91 nfet_03v3 ad=0.56p pd=2.56u as=0.56p ps=2.56u w=2u l=1u
X628 a_37178_3547# vbn.t116 a_36888_4127# VSS.t90 nfet_03v3 ad=0.56p pd=2.56u as=0.56p ps=2.56u w=2u l=1u
X629 a_37178_1227# vbn.t56 a_36888_1807# VSS.t94 nfet_03v3 ad=0.56p pd=2.56u as=0.56p ps=2.56u w=2u l=1u
X630 a_n5549_6703# ls.t4 a_n5128_6451# VSS.t128 nfet_03v3 ad=1p pd=4u as=0.28p ps=1.56u w=1u l=0.28u
X631 a_36888_6447# vbn.t604 a_37178_7027# VSS.t85 nfet_03v3 ad=0.56p pd=2.56u as=0.56p ps=2.56u w=2u l=1u
X632 a_36888_6447# vbn.t580 a_37178_5867# VSS.t86 nfet_03v3 ad=0.56p pd=2.56u as=0.56p ps=2.56u w=2u l=1u
X633 a_37178_2387# vbn.t80 a_36888_2967# VSS.t92 nfet_03v3 ad=0.56p pd=2.56u as=0.56p ps=2.56u w=2u l=1u
X634 a_36888_7607# vbn.t971 a_37178_7027# VSS.t79 nfet_03v3 ad=0.56p pd=2.56u as=0.56p ps=2.56u w=2u l=1u
X635 vbn.t8 vbn.t7 a_41854_8187# VSS.t82 nfet_03v3 ad=0.56p pd=2.56u as=0.56p ps=2.56u w=2u l=1u
X636 a_36888_5287# vbn.t149 a_37178_5867# VSS.t87 nfet_03v3 ad=0.56p pd=2.56u as=0.56p ps=2.56u w=2u l=1u
X637 a_37178_3547# vbn.t471 a_36888_4127# VSS.t90 nfet_03v3 ad=0.56p pd=2.56u as=0.56p ps=2.56u w=2u l=1u
X638 a_36888_2967# vbn.t861 a_37178_3547# VSS.t91 nfet_03v3 ad=0.9p pd=4.9u as=0.56p ps=2.56u w=2u l=1u
X639 a_41854_1227# vbn.t714 VSS.t102 VSS.t95 nfet_03v3 ad=0.9p pd=4.9u as=0.56p ps=2.56u w=2u l=1u
X640 a_37178_8187# vbn.t216 a_36888_7607# VSS.t83 nfet_03v3 ad=0.56p pd=2.56u as=0.9p ps=4.9u w=2u l=1u
X641 a_37178_4707# vbn.t900 a_36888_4127# VSS.t80 nfet_03v3 ad=0.56p pd=2.56u as=0.56p ps=2.56u w=2u l=1u
X642 a_41564_4127# vbn.t274 a_41854_4707# VSS.t89 nfet_03v3 ad=0.56p pd=2.56u as=0.56p ps=2.56u w=2u l=1u
X643 a_37178_3547# vbn.t445 a_36888_2967# VSS.t91 nfet_03v3 ad=0.56p pd=2.56u as=0.56p ps=2.56u w=2u l=1u
X644 a_36888_1807# vbn.t61 a_37178_1227# VSS.t94 nfet_03v3 ad=0.56p pd=2.56u as=0.56p ps=2.56u w=2u l=1u
X645 a_41564_6447# vbn.t306 a_41854_7027# VSS.t85 nfet_03v3 ad=0.56p pd=2.56u as=0.56p ps=2.56u w=2u l=1u
X646 a_41854_7027# vbn.t308 a_41564_7607# VSS.t84 nfet_03v3 ad=0.9p pd=4.9u as=0.56p ps=2.56u w=2u l=1u
X647 VSS.t158 VDD_LS.t29 VSS.t158 VSS.t157 nfet_03v3 ad=13.7592p pd=49.7u as=0 ps=0 w=49.14u l=10u
X648 a_37178_5867# vbn.t154 a_36888_5287# VSS.t87 nfet_03v3 ad=0.56p pd=2.56u as=0.56p ps=2.56u w=2u l=1u
X649 VSS.t37 a_6206_4704# vg.t14 VSS.t13 nfet_03v3 ad=0.54p pd=3.3u as=0.336p ps=1.76u w=1.2u l=5.335u
X650 a_37178_5867# vbn.t164 a_36888_6447# VSS.t86 nfet_03v3 ad=0.56p pd=2.56u as=0.56p ps=2.56u w=2u l=1u
X651 a_37178_8187# vbn.t214 a_36888_7607# VSS.t83 nfet_03v3 ad=0.56p pd=2.56u as=0.56p ps=2.56u w=2u l=1u
X652 a_36888_1807# vbn.t837 a_37178_2387# VSS.t93 nfet_03v3 ad=0.56p pd=2.56u as=0.56p ps=2.56u w=2u l=1u
X653 a_37178_3547# vbn.t876 a_36888_4127# VSS.t90 nfet_03v3 ad=0.56p pd=2.56u as=0.56p ps=2.56u w=2u l=1u
X654 a_36888_1807# vbn.t59 a_37178_1227# VSS.t94 nfet_03v3 ad=0.56p pd=2.56u as=0.56p ps=2.56u w=2u l=1u
X655 a_36888_6447# vbn.t945 a_37178_7027# VSS.t85 nfet_03v3 ad=0.9p pd=4.9u as=0.56p ps=2.56u w=2u l=1u
X656 a_41854_3547# vbn.t753 a_41564_4127# VSS.t90 nfet_03v3 ad=0.56p pd=2.56u as=0.56p ps=2.56u w=2u l=1u
X657 VSS.t97 vbn.t719 a_41854_1227# VSS.t95 nfet_03v3 ad=0.56p pd=2.56u as=0.56p ps=2.56u w=2u l=1u
X658 a_37178_8187# vbn.t667 a_36888_7607# VSS.t83 nfet_03v3 ad=0.56p pd=2.56u as=0.56p ps=2.56u w=2u l=1u
X659 a_37178_8187# vbn.t998 a_36866_9481# VSS.t80 nfet_03v3 ad=0.56p pd=2.56u as=0.56p ps=2.56u w=2u l=1u
X660 a_41854_4707# vbn.t763 a_41564_5287# VSS.t88 nfet_03v3 ad=0.9p pd=4.9u as=0.56p ps=2.56u w=2u l=1u
X661 a_36888_4127# vbn.t474 a_37178_3547# VSS.t90 nfet_03v3 ad=0.56p pd=2.56u as=0.56p ps=2.56u w=2u l=1u
X662 a_36888_2967# vbn.t450 a_37178_3547# VSS.t91 nfet_03v3 ad=0.56p pd=2.56u as=0.56p ps=2.56u w=2u l=1u
X663 a_37178_7027# vbn.t613 a_36888_6447# VSS.t85 nfet_03v3 ad=0.56p pd=2.56u as=0.56p ps=2.56u w=2u l=1u
X664 a_36888_5287# vbn.t159 a_37178_5867# VSS.t87 nfet_03v3 ad=0.56p pd=2.56u as=0.56p ps=2.56u w=2u l=1u
X665 vbn.t30 vbn.t29 a_41854_8187# VSS.t82 nfet_03v3 ad=0.56p pd=2.56u as=0.56p ps=2.56u w=2u l=1u
X666 ck.t0 a_n8217_6703# VSS.t2 VSS.t1 nfet_03v3 ad=1p pd=4u as=0.45p ps=2.9u w=1u l=0.28u
X667 a_36888_1807# vbn.t67 a_37178_2387# VSS.t93 nfet_03v3 ad=0.56p pd=2.56u as=0.56p ps=2.56u w=2u l=1u
X668 a_41854_4707# vbn.t277 a_41564_4127# VSS.t89 nfet_03v3 ad=0.56p pd=2.56u as=0.56p ps=2.56u w=2u l=1u
X669 a_36888_1807# vbn.t374 a_37178_1227# VSS.t94 nfet_03v3 ad=0.56p pd=2.56u as=0.56p ps=2.56u w=2u l=1u
X670 a_37178_2387# vbn.t383 a_36888_1807# VSS.t93 nfet_03v3 ad=0.56p pd=2.56u as=0.56p ps=2.56u w=2u l=1u
X671 a_36888_2967# vbn.t426 a_37178_2387# VSS.t92 nfet_03v3 ad=0.56p pd=2.56u as=0.56p ps=2.56u w=2u l=1u
X672 a_41564_7607# vbn.t311 a_41854_7027# VSS.t84 nfet_03v3 ad=0.56p pd=2.56u as=0.56p ps=2.56u w=2u l=1u
X673 a_36888_5287# vbn.t157 a_37178_5867# VSS.t87 nfet_03v3 ad=0.56p pd=2.56u as=0.56p ps=2.56u w=2u l=1u
X674 a_37178_8187# vbn.t974 a_36888_7607# VSS.t83 nfet_03v3 ad=0.56p pd=2.56u as=0.56p ps=2.56u w=2u l=1u
X675 a_36888_4127# vbn.t887 a_37178_3547# VSS.t79 nfet_03v3 ad=0.56p pd=2.56u as=0.56p ps=2.56u w=2u l=1u
X676 a_41564_5287# vbn.t768 a_41854_4707# VSS.t88 nfet_03v3 ad=0.56p pd=2.56u as=0.56p ps=2.56u w=2u l=1u
X677 a_36888_1807# vbn.t65 a_37178_2387# VSS.t93 nfet_03v3 ad=0.56p pd=2.56u as=0.56p ps=2.56u w=2u l=1u
X678 a_n7180_6531# a_n7286_7514# VSS.t4 VSS.t3 nfet_03v3 ad=0.168p pd=1.16u as=0.27p ps=2.1u w=0.6u l=0.28u
X679 a_41854_8187# vbn.t802 a_41564_7607# VSS.t83 nfet_03v3 ad=0.56p pd=2.56u as=0.56p ps=2.56u w=2u l=1u
X680 a_36888_6447# vbn.t618 a_37178_7027# VSS.t85 nfet_03v3 ad=0.56p pd=2.56u as=0.56p ps=2.56u w=2u l=1u
X681 a_36888_7607# vbn.t670 a_37178_8187# VSS.t83 nfet_03v3 ad=0.56p pd=2.56u as=0.56p ps=2.56u w=2u l=1u
X682 a_36888_1807# vbn.t825 a_37178_1227# VSS.t94 nfet_03v3 ad=0.56p pd=2.56u as=0.56p ps=2.56u w=2u l=1u
X683 a_37178_1227# vbn.t816 w_36826_300# VSS.t80 nfet_03v3 ad=0.56p pd=2.56u as=0.56p ps=2.56u w=2u l=1u
X684 a_37178_2387# vbn.t431 a_36888_2967# VSS.t92 nfet_03v3 ad=0.56p pd=2.56u as=0.56p ps=2.56u w=2u l=1u
X685 VSS.t108 vbn.t232 a_41854_1227# VSS.t95 nfet_03v3 ad=0.56p pd=2.56u as=0.56p ps=2.56u w=2u l=1u
X686 a_41854_3547# vbn.t266 a_41564_4127# VSS.t90 nfet_03v3 ad=0.9p pd=4.9u as=0.56p ps=2.56u w=2u l=1u
X687 a_36888_6447# vbn.t594 a_37178_5867# VSS.t86 nfet_03v3 ad=0.56p pd=2.56u as=0.56p ps=2.56u w=2u l=1u
X688 a_36888_5287# vbn.t570 a_37178_5867# VSS.t87 nfet_03v3 ad=0.56p pd=2.56u as=0.56p ps=2.56u w=2u l=1u
X689 a_41854_8187# vbn.t23 vbn.t24 VSS.t82 nfet_03v3 ad=0.56p pd=2.56u as=0.56p ps=2.56u w=2u l=1u
X690 VSS.t14 a_6206_896# vg.t2 VSS.t13 nfet_03v3 ad=0.54p pd=3.3u as=0.336p ps=1.76u w=1.2u l=5.335u
X691 a_37178_2387# vbn.t70 a_36888_1807# VSS.t93 nfet_03v3 ad=0.56p pd=2.56u as=0.56p ps=2.56u w=2u l=1u
X692 a_37178_1227# vbn.t377 a_36888_1807# VSS.t94 nfet_03v3 ad=0.56p pd=2.56u as=0.9p ps=4.9u w=2u l=1u
X693 a_36888_7607# vbn.t985 a_37178_8187# VSS.t79 nfet_03v3 ad=0.56p pd=2.56u as=0.56p ps=2.56u w=2u l=1u
X694 a_37178_7027# vbn.t962 a_36888_7607# VSS.t84 nfet_03v3 ad=0.56p pd=2.56u as=0.56p ps=2.56u w=2u l=1u
X695 VDD.t37 vg.t44 VDD.t37 VDD.t36 pfet_03v3 ad=8.3496p pd=30.38u as=0 ps=0 w=29.82u l=4.12u
X696 a_37178_2387# vbn.t854 a_36888_2967# VSS.t92 nfet_03v3 ad=0.56p pd=2.56u as=0.56p ps=2.56u w=2u l=1u
X697 a_37178_5867# vbn.t599 a_36888_6447# VSS.t86 nfet_03v3 ad=0.56p pd=2.56u as=0.56p ps=2.56u w=2u l=1u
X698 a_36888_5287# vbn.t923 a_37178_5867# VSS.t87 nfet_03v3 ad=0.56p pd=2.56u as=0.56p ps=2.56u w=2u l=1u
X699 a_37178_4707# vbn.t914 a_36888_5287# VSS.t80 nfet_03v3 ad=0.56p pd=2.56u as=0.56p ps=2.56u w=2u l=1u
X700 a_41564_5287# vbn.t281 a_41854_4707# VSS.t88 nfet_03v3 ad=0.56p pd=2.56u as=0.56p ps=2.56u w=2u l=1u
X701 a_41854_8187# vbn.t315 a_41564_7607# VSS.t83 nfet_03v3 ad=0.9p pd=4.9u as=0.56p ps=2.56u w=2u l=1u
X702 a_36888_1807# vbn.t75 a_37178_2387# VSS.t93 nfet_03v3 ad=0.56p pd=2.56u as=0.56p ps=2.56u w=2u l=1u
X703 a_37178_1227# vbn.t828 a_36888_1807# VSS.t94 nfet_03v3 ad=0.56p pd=2.56u as=0.56p ps=2.56u w=2u l=1u
X704 a_36888_2967# vbn.t438 a_37178_3547# VSS.t91 nfet_03v3 ad=0.56p pd=2.56u as=0.56p ps=2.56u w=2u l=1u
X705 a_36888_2967# vbn.t414 a_37178_2387# VSS.t92 nfet_03v3 ad=0.56p pd=2.56u as=0.56p ps=2.56u w=2u l=1u
X706 a_41854_1227# vbn.t235 VSS.t105 VSS.t95 nfet_03v3 ad=0.56p pd=2.56u as=0.56p ps=2.56u w=2u l=1u
X707 VSS.t114 a_6206_14# vg.t24 VSS.t13 nfet_03v3 ad=0.54p pd=3.3u as=0.336p ps=1.76u w=1.2u l=5.335u
X708 vg.t31 a_6206_14# VSS.t116 VSS.t17 nfet_03v3 ad=0.336p pd=1.76u as=0.336p ps=1.76u w=1.2u l=5.335u
X709 vg.t33 a_6206_14# VSS.t126 VSS.t17 nfet_03v3 ad=0.336p pd=1.76u as=0.336p ps=1.76u w=1.2u l=5.335u
X710 VSS.t53 vbnf.t16 VSS.t53 VSS.t52 nfet_03v3 ad=13.7592p pd=49.7u as=0 ps=0 w=49.14u l=10u
X711 a_41564_4127# vbn.t269 a_41854_3547# VSS.t90 nfet_03v3 ad=0.56p pd=2.56u as=0.56p ps=2.56u w=2u l=1u
X712 a_1632_6633# a_452_6633# VDD.t44 VDD.t43 pfet_03v3 ad=2.25p pd=10.9u as=2.25p ps=10.9u w=5u l=0.28u
X713 a_36888_7607# vbn.t644 a_37178_7027# VSS.t84 nfet_03v3 ad=0.56p pd=2.56u as=0.56p ps=2.56u w=2u l=1u
X714 a_37178_5867# vbn.t573 a_36888_5287# VSS.t87 nfet_03v3 ad=0.56p pd=2.56u as=0.9p ps=4.9u w=2u l=1u
X715 a_37178_3547# vbn.t92 a_36888_2967# VSS.t91 nfet_03v3 ad=0.56p pd=2.56u as=0.56p ps=2.56u w=2u l=1u
X716 a_37178_2387# vbn.t82 a_36888_2967# VSS.t92 nfet_03v3 ad=0.56p pd=2.56u as=0.56p ps=2.56u w=2u l=1u
X717 a_36888_1807# vbn.t73 a_37178_2387# VSS.t93 nfet_03v3 ad=0.56p pd=2.56u as=0.56p ps=2.56u w=2u l=1u
X718 a_37178_5867# vbn.t938 a_36888_6447# VSS.t86 nfet_03v3 ad=0.56p pd=2.56u as=0.56p ps=2.56u w=2u l=1u
X719 vbn.t0 a_36866_9481# VDD.t3 VDD.t2 pfet_03v3 ad=3.92p pd=14.56u as=6.3p ps=28.9u w=14u l=14u
X720 a_36888_6447# vbn.t606 a_37178_7027# VSS.t85 nfet_03v3 ad=0.56p pd=2.56u as=0.56p ps=2.56u w=2u l=1u
X721 a_36888_6447# vbn.t582 a_37178_5867# VSS.t86 nfet_03v3 ad=0.56p pd=2.56u as=0.56p ps=2.56u w=2u l=1u
X722 a_36888_4127# vbn.t490 a_37178_4707# VSS.t89 nfet_03v3 ad=0.9p pd=4.9u as=0.56p ps=2.56u w=2u l=1u
X723 a_36888_2967# vbn.t857 a_37178_2387# VSS.t81 nfet_03v3 ad=0.56p pd=2.56u as=0.56p ps=2.56u w=2u l=1u
X724 a_37178_7027# vbn.t649 a_36888_7607# VSS.t84 nfet_03v3 ad=0.56p pd=2.56u as=0.56p ps=2.56u w=2u l=1u
X725 a_37178_5867# vbn.t926 a_36888_5287# VSS.t87 nfet_03v3 ad=0.56p pd=2.56u as=0.56p ps=2.56u w=2u l=1u
X726 a_41854_4707# vbn.t284 a_41564_5287# VSS.t88 nfet_03v3 ad=0.56p pd=2.56u as=0.56p ps=2.56u w=2u l=1u
X727 a_41564_7607# vbn.t318 a_41854_8187# VSS.t83 nfet_03v3 ad=0.56p pd=2.56u as=0.56p ps=2.56u w=2u l=1u
X728 a_36888_1807# vbn.t402 a_37178_2387# VSS.t93 nfet_03v3 ad=0.56p pd=2.56u as=0.56p ps=2.56u w=2u l=1u
X729 a_36888_2967# vbn.t97 a_37178_3547# VSS.t91 nfet_03v3 ad=0.56p pd=2.56u as=0.56p ps=2.56u w=2u l=1u
X730 a_37178_5867# vbn.t166 a_36888_6447# VSS.t86 nfet_03v3 ad=0.56p pd=2.56u as=0.56p ps=2.56u w=2u l=1u
X731 a_37178_7027# vbn.t176 a_36888_6447# VSS.t85 nfet_03v3 ad=0.56p pd=2.56u as=0.56p ps=2.56u w=2u l=1u
X732 vg.t22 vbnf.t26 VSS.t40 VSS.t17 nfet_03v3 ad=0.336p pd=1.76u as=0.336p ps=1.76u w=1.2u l=5.335u
X733 a_41854_1227# vbn.t240 a_41564_1807# VSS.t94 nfet_03v3 ad=0.56p pd=2.56u as=0.56p ps=2.56u w=2u l=1u
X734 a_37178_3547# vbn.t878 a_36888_4127# VSS.t90 nfet_03v3 ad=0.56p pd=2.56u as=0.56p ps=2.56u w=2u l=1u
X735 a_36888_6447# vbn.t941 a_37178_5867# VSS.t81 nfet_03v3 ad=0.56p pd=2.56u as=0.56p ps=2.56u w=2u l=1u
X736 a_36866_9481# vbn.t686 a_37178_8187# VSS.t82 nfet_03v3 ad=0.9p pd=4.9u as=0.56p ps=2.56u w=2u l=1u
X737 VSS.t49 vbnf.t18 VSS.t49 VSS.t48 nfet_03v3 ad=13.7592p pd=49.7u as=0 ps=0 w=49.14u l=10u
X738 a_36888_1807# vbn.t839 a_37178_2387# VSS.t93 nfet_03v3 ad=0.56p pd=2.56u as=0.56p ps=2.56u w=2u l=1u
X739 vg.t9 a_6356_6633# VSS.t30 VSS.t29 nfet_03v3 ad=0.336p pd=1.76u as=0.54p ps=3.3u w=1.2u l=5.335u
X740 a_36888_6447# vbn.t181 a_37178_7027# VSS.t85 nfet_03v3 ad=0.56p pd=2.56u as=0.56p ps=2.56u w=2u l=1u
X741 vbn.t33 vbnf.t5 VSS.t142 ppolyf_u_1k r_width=1u r_length=0.97023m
X742 a_37178_4707# vbn.t493 a_36888_4127# VSS.t89 nfet_03v3 ad=0.56p pd=2.56u as=0.56p ps=2.56u w=2u l=1u
X743 a_36888_7607# vbn.t652 a_37178_7027# VSS.t84 nfet_03v3 ad=0.56p pd=2.56u as=0.56p ps=2.56u w=2u l=1u
X744 a_36888_4127# vbn.t476 a_37178_3547# VSS.t90 nfet_03v3 ad=0.56p pd=2.56u as=0.56p ps=2.56u w=2u l=1u
X745 a_41854_5867# vbn.t289 a_41564_5287# VSS.t87 nfet_03v3 ad=0.56p pd=2.56u as=0.56p ps=2.56u w=2u l=1u
X746 a_36888_1807# vbn.t360 a_37178_1227# VSS.t94 nfet_03v3 ad=0.56p pd=2.56u as=0.56p ps=2.56u w=2u l=1u
X747 a_37178_2387# vbn.t405 a_36888_1807# VSS.t93 nfet_03v3 ad=0.56p pd=2.56u as=0.9p ps=4.9u w=2u l=1u
X748 vg.t37 a_6206_14# VSS.t120 VSS.t15 nfet_03v3 ad=0.336p pd=1.76u as=0.54p ps=3.3u w=1.2u l=5.335u
X749 a_37178_8187# vbn.t976 a_36888_7607# VSS.t83 nfet_03v3 ad=0.56p pd=2.56u as=0.56p ps=2.56u w=2u l=1u
X750 a_36888_4127# vbn.t119 a_37178_4707# VSS.t89 nfet_03v3 ad=0.9p pd=4.9u as=0.56p ps=2.56u w=2u l=1u
X751 vbnf.t8 bit1.t0 a_7096_6633# VSS.t151 nfet_03v3 ad=0.9p pd=4.9u as=0.9p ps=4.9u w=2u l=0.28u
X752 a_n7601_6703# q1 a_n7180_6531# VSS.t26 nfet_03v3 ad=0.6p pd=3.2u as=0.168p ps=1.16u w=0.6u l=0.28u
X753 a_37178_7027# vbn.t637 a_36888_7607# VSS.t84 nfet_03v3 ad=0.56p pd=2.56u as=0.56p ps=2.56u w=2u l=1u
X754 w_36826_300# vbn.t322 a_37178_1227# VSS.t95 nfet_03v3 ad=0.9p pd=4.9u as=0.56p ps=2.56u w=2u l=1u
X755 VDD_LS.t14 a_n2245_6719# a_n3101_6703# VDD_LS.t13 pfet_03v3 ad=0.225p pd=1.9u as=1.1p ps=5.4u w=0.5u l=0.28u
X756 a_n3607_6703# a_n3101_6703# VSS.t136 VSS.t135 nfet_03v3 ad=0.6p pd=3.2u as=0.27p ps=2.1u w=0.6u l=0.28u
X757 a_41564_2967# vbn.t738 a_41854_2387# VSS.t92 nfet_03v3 ad=0.56p pd=2.56u as=0.56p ps=2.56u w=2u l=1u
X758 a_37178_8187# vbn.t689 a_36866_9481# VSS.t82 nfet_03v3 ad=0.56p pd=2.56u as=0.56p ps=2.56u w=2u l=1u
X759 a_37178_1227# vbn.t365 a_36888_1807# VSS.t94 nfet_03v3 ad=0.56p pd=2.56u as=0.56p ps=2.56u w=2u l=1u
X760 a_37178_2387# vbn.t842 a_36888_1807# VSS.t93 nfet_03v3 ad=0.56p pd=2.56u as=0.56p ps=2.56u w=2u l=1u
X761 a_37178_3547# vbn.t481 a_36888_4127# VSS.t90 nfet_03v3 ad=0.56p pd=2.56u as=0.56p ps=2.56u w=2u l=1u
X762 a_37178_3547# vbn.t457 a_36888_2967# VSS.t91 nfet_03v3 ad=0.56p pd=2.56u as=0.56p ps=2.56u w=2u l=1u
X763 a_36888_1807# vbn.t821 a_37178_1227# VSS.t94 nfet_03v3 ad=0.56p pd=2.56u as=0.56p ps=2.56u w=2u l=1u
X764 a_36888_5287# vbn.t556 a_37178_5867# VSS.t87 nfet_03v3 ad=0.56p pd=2.56u as=0.56p ps=2.56u w=2u l=1u
X765 VDD.t33 vg.t46 VDD.t33 VDD.t32 pfet_03v3 ad=8.3496p pd=30.38u as=0 ps=0 w=29.82u l=4.12u
X766 a_36888_7607# vbn.t672 a_37178_8187# VSS.t83 nfet_03v3 ad=0.56p pd=2.56u as=0.56p ps=2.56u w=2u l=1u
X767 a_36866_9481# vbn.t217 a_37178_8187# VSS.t82 nfet_03v3 ad=0.9p pd=4.9u as=0.56p ps=2.56u w=2u l=1u
X768 a_41564_2967# vbn.t736 a_41854_2387# VSS.t92 nfet_03v3 ad=0.56p pd=2.56u as=0.56p ps=2.56u w=2u l=1u
X769 a_452_6633# a0.t2 vg.t19 VSS.t145 nfet_03v3 ad=0.9p pd=4.9u as=0.9p ps=4.9u w=2u l=0.28u
X770 a_37178_3547# vbn.t455 a_36888_2967# VSS.t91 nfet_03v3 ad=0.56p pd=2.56u as=0.56p ps=2.56u w=2u l=1u
X771 a_37178_1227# vbn.t363 a_36888_1807# VSS.t94 nfet_03v3 ad=0.56p pd=2.56u as=0.56p ps=2.56u w=2u l=1u
X772 vbnf.t4 bitb4.t1 a_6206_14# VDD.t23 pfet_03v3 ad=2.25p pd=10.9u as=2.25p ps=10.9u w=5u l=0.28u
X773 a_41564_6447# vbn.t780 a_41854_5867# VSS.t86 nfet_03v3 ad=0.56p pd=2.56u as=0.56p ps=2.56u w=2u l=1u
X774 a_37178_3547# vbn.t866 a_36888_2967# VSS.t91 nfet_03v3 ad=0.56p pd=2.56u as=0.56p ps=2.56u w=2u l=1u
X775 a_37178_7027# vbn.t625 a_36888_6447# VSS.t85 nfet_03v3 ad=0.56p pd=2.56u as=0.56p ps=2.56u w=2u l=1u
X776 a_36888_5287# vbn.t518 a_37178_4707# VSS.t88 nfet_03v3 ad=0.9p pd=4.9u as=0.56p ps=2.56u w=2u l=1u
X777 a_37178_8187# vbn.t677 a_36888_7607# VSS.t83 nfet_03v3 ad=0.56p pd=2.56u as=0.56p ps=2.56u w=2u l=1u
X778 a_37178_5867# vbn.t561 a_36888_5287# VSS.t87 nfet_03v3 ad=0.56p pd=2.56u as=0.56p ps=2.56u w=2u l=1u
X779 a_36888_5287# vbn.t919 a_37178_5867# VSS.t87 nfet_03v3 ad=0.56p pd=2.56u as=0.56p ps=2.56u w=2u l=1u
X780 a_37178_1227# vbn.t325 w_36826_300# VSS.t95 nfet_03v3 ad=0.56p pd=2.56u as=0.56p ps=2.56u w=2u l=1u
X781 a_41564_6447# vbn.t778 a_41854_5867# VSS.t86 nfet_03v3 ad=0.56p pd=2.56u as=0.56p ps=2.56u w=2u l=1u
X782 a_41854_3547# vbn.t744 a_41564_2967# VSS.t91 nfet_03v3 ad=0.56p pd=2.56u as=0.56p ps=2.56u w=2u l=1u
X783 a_41854_2387# vbn.t741 a_41564_2967# VSS.t92 nfet_03v3 ad=0.56p pd=2.56u as=0.9p ps=4.9u w=2u l=1u
X784 a_36888_1807# vbn.t368 a_37178_1227# VSS.t94 nfet_03v3 ad=0.56p pd=2.56u as=0.56p ps=2.56u w=2u l=1u
X785 a_n6862_7514# a_n7601_6703# VDD_LS.t26 VDD_LS.t25 pfet_03v3 ad=0.336p pd=1.76u as=0.336p ps=1.76u w=1.2u l=0.28u
X786 a_37178_7027# vbn.t623 a_36888_6447# VSS.t85 nfet_03v3 ad=0.56p pd=2.56u as=0.56p ps=2.56u w=2u l=1u
X787 a_37178_4707# vbn.t507 a_36888_4127# VSS.t89 nfet_03v3 ad=0.56p pd=2.56u as=0.56p ps=2.56u w=2u l=1u
X788 a_36888_4127# vbn.t484 a_37178_3547# VSS.t90 nfet_03v3 ad=0.56p pd=2.56u as=0.56p ps=2.56u w=2u l=1u
X789 a_36888_2967# vbn.t460 a_37178_3547# VSS.t91 nfet_03v3 ad=0.56p pd=2.56u as=0.56p ps=2.56u w=2u l=1u
X790 a_41854_2387# vbn.t247 a_41564_1807# VSS.t93 nfet_03v3 ad=0.56p pd=2.56u as=0.56p ps=2.56u w=2u l=1u
X791 VSS.t73 a_n2245_6719# a_n3101_6703# VSS.t72 nfet_03v3 ad=0.1686p pd=1.74u as=0.5448p ps=5.16u w=0.22u l=0.28u
X792 a_37178_5867# vbn.t559 a_36888_5287# VSS.t87 nfet_03v3 ad=0.56p pd=2.56u as=0.56p ps=2.56u w=2u l=1u
X793 w_36826_300# vbn.t35 a_37178_1227# VSS.t95 nfet_03v3 ad=0.9p pd=4.9u as=0.56p ps=2.56u w=2u l=1u
X794 a_37178_7027# vbn.t198 a_36888_7607# VSS.t84 nfet_03v3 ad=0.56p pd=2.56u as=0.56p ps=2.56u w=2u l=1u
X795 a_37178_7027# vbn.t950 a_36888_6447# VSS.t85 nfet_03v3 ad=0.56p pd=2.56u as=0.56p ps=2.56u w=2u l=1u
X796 vg.t4 a_6206_896# VSS.t22 VSS.t15 nfet_03v3 ad=0.336p pd=1.76u as=0.54p ps=3.3u w=1.2u l=5.335u
X797 a_37178_3547# vbn.t469 a_36888_4127# VSS.t90 nfet_03v3 ad=0.56p pd=2.56u as=0.56p ps=2.56u w=2u l=1u
X798 vg.t8 a_6206_896# VSS.t16 VSS.t15 nfet_03v3 ad=0.336p pd=1.76u as=0.54p ps=3.3u w=1.2u l=5.335u
X799 a_41854_7027# vbn.t786 a_41564_6447# VSS.t85 nfet_03v3 ad=0.56p pd=2.56u as=0.56p ps=2.56u w=2u l=1u
X800 a_41854_5867# vbn.t783 a_41564_6447# VSS.t86 nfet_03v3 ad=0.56p pd=2.56u as=0.9p ps=4.9u w=2u l=1u
X801 a_36888_2967# vbn.t869 a_37178_3547# VSS.t91 nfet_03v3 ad=0.56p pd=2.56u as=0.56p ps=2.56u w=2u l=1u
X802 a_36888_6447# vbn.t628 a_37178_7027# VSS.t85 nfet_03v3 ad=0.56p pd=2.56u as=0.56p ps=2.56u w=2u l=1u
X803 a_37178_4707# vbn.t521 a_36888_5287# VSS.t88 nfet_03v3 ad=0.56p pd=2.56u as=0.56p ps=2.56u w=2u l=1u
X804 a_37178_8187# vbn.t703 a_36866_9481# VSS.t82 nfet_03v3 ad=0.56p pd=2.56u as=0.56p ps=2.56u w=2u l=1u
X805 a_36888_7607# vbn.t680 a_37178_8187# VSS.t83 nfet_03v3 ad=0.56p pd=2.56u as=0.56p ps=2.56u w=2u l=1u
X806 a_36888_5287# vbn.t564 a_37178_5867# VSS.t87 nfet_03v3 ad=0.56p pd=2.56u as=0.56p ps=2.56u w=2u l=1u
X807 a_37178_1227# vbn.t351 a_36888_1807# VSS.t94 nfet_03v3 ad=0.56p pd=2.56u as=0.56p ps=2.56u w=2u l=1u
X808 a_36888_1807# vbn.t388 a_37178_2387# VSS.t93 nfet_03v3 ad=0.56p pd=2.56u as=0.56p ps=2.56u w=2u l=1u
X809 a_36888_5287# vbn.t133 a_37178_4707# VSS.t88 nfet_03v3 ad=0.9p pd=4.9u as=0.56p ps=2.56u w=2u l=1u
X810 a_41854_1227# vbn.t244 a_41564_1807# VSS.t94 nfet_03v3 ad=0.56p pd=2.56u as=0.9p ps=4.9u w=2u l=1u
X811 a_36888_2967# vbn.t99 a_37178_3547# VSS.t91 nfet_03v3 ad=0.56p pd=2.56u as=0.56p ps=2.56u w=2u l=1u
X812 a_36888_6447# vbn.t953 a_37178_7027# VSS.t85 nfet_03v3 ad=0.56p pd=2.56u as=0.56p ps=2.56u w=2u l=1u
X813 a_36888_4127# vbn.t893 a_37178_4707# VSS.t89 nfet_03v3 ad=0.56p pd=2.56u as=0.56p ps=2.56u w=2u l=1u
X814 a_37178_3547# vbn.t874 a_36888_2967# VSS.t78 nfet_03v3 ad=0.56p pd=2.56u as=0.9p ps=4.9u w=2u l=1u
X815 a_37178_8187# vbn.t665 a_36888_7607# VSS.t83 nfet_03v3 ad=0.56p pd=2.56u as=0.56p ps=2.56u w=2u l=1u
X816 a_37178_2387# vbn.t393 a_36888_1807# VSS.t93 nfet_03v3 ad=0.56p pd=2.56u as=0.56p ps=2.56u w=2u l=1u
X817 a_36888_1807# vbn.t356 a_37178_1227# VSS.t94 nfet_03v3 ad=0.56p pd=2.56u as=0.56p ps=2.56u w=2u l=1u
X818 a_n5128_6451# a_n5234_7514# VSS.t71 VSS.t70 nfet_03v3 ad=0.28p pd=1.56u as=0.45p ps=2.9u w=1u l=0.28u
X819 a_36888_1807# vbn.t835 a_37178_2387# VSS.t93 nfet_03v3 ad=0.56p pd=2.56u as=0.56p ps=2.56u w=2u l=1u
X820 a_41854_7027# vbn.t791 a_41564_7607# VSS.t84 nfet_03v3 ad=0.9p pd=4.9u as=0.56p ps=2.56u w=2u l=1u
X821 a_36888_2967# vbn.t408 a_37178_2387# VSS.t92 nfet_03v3 ad=0.56p pd=2.56u as=0.56p ps=2.56u w=2u l=1u
X822 a_37178_5867# vbn.t547 a_36888_5287# VSS.t87 nfet_03v3 ad=0.56p pd=2.56u as=0.56p ps=2.56u w=2u l=1u
X823 a_37178_1227# vbn.t339 w_36826_300# VSS.t95 nfet_03v3 ad=0.56p pd=2.56u as=0.56p ps=2.56u w=2u l=1u
X824 a_6206_896# bitb3.t0 VSS.t148 VSS.t147 nfet_03v3 ad=0.45p pd=2.9u as=0.45p ps=2.9u w=1u l=0.28u
X825 a_36888_4127# vbn.t123 a_37178_4707# VSS.t89 nfet_03v3 ad=0.56p pd=2.56u as=0.56p ps=2.56u w=2u l=1u
X826 a_37178_3547# vbn.t114 a_36888_4127# VSS.t90 nfet_03v3 ad=0.56p pd=2.56u as=0.56p ps=2.56u w=2u l=1u
X827 a_37178_3547# vbn.t104 a_36888_2967# VSS.t91 nfet_03v3 ad=0.56p pd=2.56u as=0.9p ps=4.9u w=2u l=1u
X828 a_41854_5867# vbn.t293 a_41564_5287# VSS.t87 nfet_03v3 ad=0.56p pd=2.56u as=0.9p ps=4.9u w=2u l=1u
X829 a_36888_6447# vbn.t183 a_37178_7027# VSS.t85 nfet_03v3 ad=0.56p pd=2.56u as=0.56p ps=2.56u w=2u l=1u
X830 a_37178_2387# vbn.t391 a_36888_1807# VSS.t93 nfet_03v3 ad=0.56p pd=2.56u as=0.56p ps=2.56u w=2u l=1u
X831 a_37178_7027# vbn.t958 a_36888_6447# VSS.t78 nfet_03v3 ad=0.56p pd=2.56u as=0.9p ps=4.9u w=2u l=1u
X832 a_37178_4707# vbn.t495 a_36888_4127# VSS.t89 nfet_03v3 ad=0.56p pd=2.56u as=0.56p ps=2.56u w=2u l=1u
X833 a_36866_9481# vbn.t991 a_37178_8187# VSS.t82 nfet_03v3 ad=0.56p pd=2.56u as=0.56p ps=2.56u w=2u l=1u
X834 a_41564_2967# vbn.t257 a_41854_2387# VSS.t92 nfet_03v3 ad=0.56p pd=2.56u as=0.56p ps=2.56u w=2u l=1u
X835 a_37178_3547# vbn.t102 a_36888_2967# VSS.t91 nfet_03v3 ad=0.56p pd=2.56u as=0.56p ps=2.56u w=2u l=1u
X836 a_37178_1227# vbn.t52 a_36888_1807# VSS.t94 nfet_03v3 ad=0.56p pd=2.56u as=0.56p ps=2.56u w=2u l=1u
X837 a_41564_7607# vbn.t796 a_41854_7027# VSS.t84 nfet_03v3 ad=0.56p pd=2.56u as=0.56p ps=2.56u w=2u l=1u
X838 a_36888_6447# vbn.t576 a_37178_5867# VSS.t86 nfet_03v3 ad=0.56p pd=2.56u as=0.56p ps=2.56u w=2u l=1u
X839 a_36888_5287# vbn.t552 a_37178_5867# VSS.t87 nfet_03v3 ad=0.56p pd=2.56u as=0.56p ps=2.56u w=2u l=1u
X840 a_36888_4127# vbn.t121 a_37178_4707# VSS.t89 nfet_03v3 ad=0.56p pd=2.56u as=0.56p ps=2.56u w=2u l=1u
X841 VSS.t20 a_6206_896# vg.t7 VSS.t19 nfet_03v3 ad=0.336p pd=1.76u as=0.336p ps=1.76u w=1.2u l=5.335u
X842 a_37178_3547# vbn.t443 a_36888_2967# VSS.t91 nfet_03v3 ad=0.56p pd=2.56u as=0.56p ps=2.56u w=2u l=1u
X843 a_37178_7027# vbn.t188 a_36888_6447# VSS.t85 nfet_03v3 ad=0.56p pd=2.56u as=0.9p ps=4.9u w=2u l=1u
X844 a_36888_1807# vbn.t396 a_37178_2387# VSS.t93 nfet_03v3 ad=0.56p pd=2.56u as=0.56p ps=2.56u w=2u l=1u
X845 a_37178_4707# vbn.t535 a_36888_5287# VSS.t88 nfet_03v3 ad=0.56p pd=2.56u as=0.56p ps=2.56u w=2u l=1u
X846 a_36888_2967# vbn.t847 a_37178_2387# VSS.t92 nfet_03v3 ad=0.9p pd=4.9u as=0.56p ps=2.56u w=2u l=1u
X847 a_37178_8187# vbn.t212 a_36888_7607# VSS.t83 nfet_03v3 ad=0.56p pd=2.56u as=0.56p ps=2.56u w=2u l=1u
X848 a_36866_9481# vbn.t221 a_37178_8187# VSS.t82 nfet_03v3 ad=0.56p pd=2.56u as=0.56p ps=2.56u w=2u l=1u
X849 a_37178_8187# vbn.t691 a_36866_9481# VSS.t82 nfet_03v3 ad=0.56p pd=2.56u as=0.56p ps=2.56u w=2u l=1u
X850 VSS.t24 a_6206_896# vg.t6 VSS.t23 nfet_03v3 ad=0.336p pd=1.76u as=0.336p ps=1.76u w=1.2u l=5.335u
X851 a_37178_4707# vbn.t126 a_36888_4127# VSS.t89 nfet_03v3 ad=0.56p pd=2.56u as=0.56p ps=2.56u w=2u l=1u
X852 a_41564_6447# vbn.t299 a_41854_5867# VSS.t86 nfet_03v3 ad=0.56p pd=2.56u as=0.56p ps=2.56u w=2u l=1u
X853 a_37178_2387# vbn.t417 a_36888_2967# VSS.t92 nfet_03v3 ad=0.56p pd=2.56u as=0.56p ps=2.56u w=2u l=1u
X854 a_37178_7027# vbn.t186 a_36888_6447# VSS.t85 nfet_03v3 ad=0.56p pd=2.56u as=0.56p ps=2.56u w=2u l=1u
X855 w_36826_300# vbn.t809 a_37178_1227# VSS.t95 nfet_03v3 ad=0.56p pd=2.56u as=0.56p ps=2.56u w=2u l=1u
X856 a_37178_5867# vbn.t150 a_36888_5287# VSS.t87 nfet_03v3 ad=0.56p pd=2.56u as=0.56p ps=2.56u w=2u l=1u
X857 a_36866_9481# vbn.t219 a_37178_8187# VSS.t82 nfet_03v3 ad=0.56p pd=2.56u as=0.56p ps=2.56u w=2u l=1u
X858 VSS.t63 vbnf.t11 VSS.t63 VSS.t62 nfet_03v3 ad=13.7592p pd=49.7u as=0 ps=0 w=49.14u l=10u
X859 a_37178_3547# vbn.t862 a_36888_2967# VSS.t91 nfet_03v3 ad=0.56p pd=2.56u as=0.56p ps=2.56u w=2u l=1u
X860 a_37178_7027# vbn.t611 a_36888_6447# VSS.t85 nfet_03v3 ad=0.56p pd=2.56u as=0.56p ps=2.56u w=2u l=1u
X861 a_36888_6447# vbn.t931 a_37178_5867# VSS.t86 nfet_03v3 ad=0.9p pd=4.9u as=0.56p ps=2.56u w=2u l=1u
X862 a_41854_3547# vbn.t749 a_41564_4127# VSS.t90 nfet_03v3 ad=0.9p pd=4.9u as=0.56p ps=2.56u w=2u l=1u
X863 a_41854_3547# vbn.t746 a_41564_2967# VSS.t91 nfet_03v3 ad=0.56p pd=2.56u as=0.56p ps=2.56u w=2u l=1u
X864 a_37178_7027# vbn.t970 a_36888_7607# VSS.t80 nfet_03v3 ad=0.56p pd=2.56u as=0.56p ps=2.56u w=2u l=1u
X865 a_41564_7607# vbn.t309 a_41854_7027# VSS.t84 nfet_03v3 ad=0.56p pd=2.56u as=0.56p ps=2.56u w=2u l=1u
X866 a_37178_2387# vbn.t379 a_36888_1807# VSS.t93 nfet_03v3 ad=0.56p pd=2.56u as=0.56p ps=2.56u w=2u l=1u
X867 a_36888_2967# vbn.t446 a_37178_3547# VSS.t91 nfet_03v3 ad=0.56p pd=2.56u as=0.56p ps=2.56u w=2u l=1u
X868 a_36888_2967# vbn.t422 a_37178_2387# VSS.t92 nfet_03v3 ad=0.56p pd=2.56u as=0.56p ps=2.56u w=2u l=1u
X869 a_36888_4127# vbn.t131 a_37178_4707# VSS.t89 nfet_03v3 ad=0.56p pd=2.56u as=0.56p ps=2.56u w=2u l=1u
X870 a_41854_2387# vbn.t251 a_41564_1807# VSS.t93 nfet_03v3 ad=0.56p pd=2.56u as=0.9p ps=4.9u w=2u l=1u
X871 a_37178_5867# vbn.t585 a_36888_6447# VSS.t86 nfet_03v3 ad=0.56p pd=2.56u as=0.56p ps=2.56u w=2u l=1u
X872 w_36826_300# vbn.t39 a_37178_1227# VSS.t95 nfet_03v3 ad=0.56p pd=2.56u as=0.56p ps=2.56u w=2u l=1u
X873 a_n6694_7514# q1 a_n6862_7514# VDD_LS.t10 pfet_03v3 ad=1.2p pd=4.4u as=0.336p ps=1.76u w=1.2u l=0.28u
X874 a_37178_8187# vbn.t224 a_36866_9481# VSS.t82 nfet_03v3 ad=0.56p pd=2.56u as=0.56p ps=2.56u w=2u l=1u
X875 a_37178_1227# vbn.t327 w_36826_300# VSS.t95 nfet_03v3 ad=0.56p pd=2.56u as=0.56p ps=2.56u w=2u l=1u
X876 a_36888_1807# vbn.t370 a_37178_1227# VSS.t94 nfet_03v3 ad=0.56p pd=2.56u as=0.56p ps=2.56u w=2u l=1u
X877 a_36888_5287# vbn.t907 a_37178_4707# VSS.t88 nfet_03v3 ad=0.56p pd=2.56u as=0.56p ps=2.56u w=2u l=1u
X878 a_36888_4127# vbn.t129 a_37178_4707# VSS.t89 nfet_03v3 ad=0.56p pd=2.56u as=0.56p ps=2.56u w=2u l=1u
X879 a_37178_7027# vbn.t946 a_36888_6447# VSS.t85 nfet_03v3 ad=0.56p pd=2.56u as=0.56p ps=2.56u w=2u l=1u
X880 a_41564_4127# vbn.t754 a_41854_3547# VSS.t90 nfet_03v3 ad=0.56p pd=2.56u as=0.56p ps=2.56u w=2u l=1u
X881 w_36826_300# vbn.t37 a_37178_1227# VSS.t95 nfet_03v3 ad=0.56p pd=2.56u as=0.56p ps=2.56u w=2u l=1u
X882 a_36888_2967# vbn.t873 a_37178_3547# VSS.t79 nfet_03v3 ad=0.56p pd=2.56u as=0.56p ps=2.56u w=2u l=1u
X883 a_41854_7027# vbn.t788 a_41564_6447# VSS.t85 nfet_03v3 ad=0.56p pd=2.56u as=0.56p ps=2.56u w=2u l=1u
X884 a_36888_1807# vbn.t384 a_37178_2387# VSS.t93 nfet_03v3 ad=0.56p pd=2.56u as=0.56p ps=2.56u w=2u l=1u
X885 a_41854_8187# vbn.t798 a_41564_7607# VSS.t83 nfet_03v3 ad=0.9p pd=4.9u as=0.56p ps=2.56u w=2u l=1u
X886 a_36888_6447# vbn.t614 a_37178_7027# VSS.t85 nfet_03v3 ad=0.56p pd=2.56u as=0.56p ps=2.56u w=2u l=1u
X887 a_36888_6447# vbn.t590 a_37178_5867# VSS.t86 nfet_03v3 ad=0.56p pd=2.56u as=0.56p ps=2.56u w=2u l=1u
X888 VSS.t123 a_6206_14# vg.t28 VSS.t19 nfet_03v3 ad=0.336p pd=1.76u as=0.336p ps=1.76u w=1.2u l=5.335u
X889 a_36888_5287# vbn.t137 a_37178_4707# VSS.t88 nfet_03v3 ad=0.56p pd=2.56u as=0.56p ps=2.56u w=2u l=1u
X890 a_36866_9481# vbn.t229 a_37178_8187# VSS.t82 nfet_03v3 ad=0.56p pd=2.56u as=0.56p ps=2.56u w=2u l=1u
X891 a_37178_4707# vbn.t523 a_36888_5287# VSS.t88 nfet_03v3 ad=0.56p pd=2.56u as=0.56p ps=2.56u w=2u l=1u
X892 a_36888_4127# vbn.t514 a_37178_4707# VSS.t89 nfet_03v3 ad=0.56p pd=2.56u as=0.56p ps=2.56u w=2u l=1u
X893 a_41854_7027# vbn.t312 a_41564_7607# VSS.t84 nfet_03v3 ad=0.56p pd=2.56u as=0.56p ps=2.56u w=2u l=1u
X894 a_37178_1227# vbn.t375 a_36888_1807# VSS.t94 nfet_03v3 ad=0.56p pd=2.56u as=0.56p ps=2.56u w=2u l=1u
X895 a_41854_3547# vbn.t259 a_41564_2967# VSS.t91 nfet_03v3 ad=0.9p pd=4.9u as=0.56p ps=2.56u w=2u l=1u
X896 VSS.t35 a_6206_4704# vg.t16 VSS.t19 nfet_03v3 ad=0.336p pd=1.76u as=0.336p ps=1.76u w=1.2u l=5.335u
X897 VSS.t59 vbnf.t13 VSS.t59 VSS.t58 nfet_03v3 ad=13.7592p pd=49.7u as=0 ps=0 w=49.14u l=10u
X898 VDD.t17 a_36866_9481# vbn.t1 VDD.t16 pfet_03v3 ad=6.3p pd=28.9u as=3.92p ps=14.56u w=14u l=14u
X899 a_36888_5287# vbn.t566 a_37178_5867# VSS.t87 nfet_03v3 ad=0.56p pd=2.56u as=0.56p ps=2.56u w=2u l=1u
X900 a_37178_1227# vbn.t42 w_36826_300# VSS.t95 nfet_03v3 ad=0.56p pd=2.56u as=0.56p ps=2.56u w=2u l=1u
X901 a_37178_2387# vbn.t66 a_36888_1807# VSS.t93 nfet_03v3 ad=0.56p pd=2.56u as=0.56p ps=2.56u w=2u l=1u
X902 a_36888_5287# vbn.t135 a_37178_4707# VSS.t88 nfet_03v3 ad=0.56p pd=2.56u as=0.56p ps=2.56u w=2u l=1u
X903 a_36866_9481# vbn.t227 a_37178_8187# VSS.t82 nfet_03v3 ad=0.56p pd=2.56u as=0.56p ps=2.56u w=2u l=1u
X904 VDD.t5 a_36866_9481# vbn.t2 VDD.t4 pfet_03v3 ad=3.92p pd=14.56u as=3.92p ps=14.56u w=14u l=14u
X905 a_36888_6447# vbn.t957 a_37178_7027# VSS.t79 nfet_03v3 ad=0.56p pd=2.56u as=0.56p ps=2.56u w=2u l=1u
X906 a_41564_7607# vbn.t803 a_41854_8187# VSS.t83 nfet_03v3 ad=0.56p pd=2.56u as=0.56p ps=2.56u w=2u l=1u
X907 a_1867_7085# a_1632_6633# vg.t20 VSS.t77 nfet_03v3 ad=0.9p pd=4.9u as=0.9p ps=4.9u w=2u l=0.28u
X908 a_37178_3547# vbn.t886 a_36888_4127# VSS.t80 nfet_03v3 ad=0.56p pd=2.56u as=0.56p ps=2.56u w=2u l=1u
X909 a_37178_1227# vbn.t826 a_36888_1807# VSS.t94 nfet_03v3 ad=0.56p pd=2.56u as=0.56p ps=2.56u w=2u l=1u
X910 a_36888_4127# vbn.t895 a_37178_4707# VSS.t89 nfet_03v3 ad=0.56p pd=2.56u as=0.56p ps=2.56u w=2u l=1u
X911 a_37178_5867# vbn.t571 a_36888_5287# VSS.t87 nfet_03v3 ad=0.56p pd=2.56u as=0.56p ps=2.56u w=2u l=1u
X912 w_36826_300# vbn.t47 a_37178_1227# VSS.t95 nfet_03v3 ad=0.56p pd=2.56u as=0.56p ps=2.56u w=2u l=1u
X913 a_41564_4127# vbn.t267 a_41854_3547# VSS.t90 nfet_03v3 ad=0.56p pd=2.56u as=0.56p ps=2.56u w=2u l=1u
X914 a_41854_7027# vbn.t301 a_41564_6447# VSS.t85 nfet_03v3 ad=0.9p pd=4.9u as=0.56p ps=2.56u w=2u l=1u
X915 a_36866_9481# vbn.t710 a_37178_8187# VSS.t82 nfet_03v3 ad=0.56p pd=2.56u as=0.56p ps=2.56u w=2u l=1u
X916 a_37178_4707# vbn.t140 a_36888_5287# VSS.t88 nfet_03v3 ad=0.56p pd=2.56u as=0.56p ps=2.56u w=2u l=1u
X917 a_36888_1807# vbn.t358 a_37178_1227# VSS.t94 nfet_03v3 ad=0.56p pd=2.56u as=0.56p ps=2.56u w=2u l=1u
X918 a_37178_4707# vbn.t517 a_36888_4127# VSS.t89 nfet_03v3 ad=0.56p pd=2.56u as=0.9p ps=4.9u w=2u l=1u
X919 a_36888_2967# vbn.t410 a_37178_2387# VSS.t92 nfet_03v3 ad=0.56p pd=2.56u as=0.56p ps=2.56u w=2u l=1u
X920 vbn.t4 a_60550_8387# a_36866_9481# VSS.t69 nfet_03v3 ad=0.45p pd=2.9u as=0.45p ps=2.9u w=1u l=0.28u
X921 a_41564_2967# vbn.t262 a_41854_3547# VSS.t91 nfet_03v3 ad=0.56p pd=2.56u as=0.56p ps=2.56u w=2u l=1u
X922 a_37178_1227# vbn.t54 a_36888_1807# VSS.t94 nfet_03v3 ad=0.56p pd=2.56u as=0.56p ps=2.56u w=2u l=1u
X923 w_36826_300# vbn.t45 a_37178_1227# VSS.t95 nfet_03v3 ad=0.56p pd=2.56u as=0.56p ps=2.56u w=2u l=1u
X924 a_37178_2387# vbn.t78 a_36888_2967# VSS.t92 nfet_03v3 ad=0.56p pd=2.56u as=0.56p ps=2.56u w=2u l=1u
X925 vg.t30 a_6206_14# VSS.t115 VSS.t15 nfet_03v3 ad=0.336p pd=1.76u as=0.54p ps=3.3u w=1.2u l=5.335u
X926 a_36866_9481# vbn.t993 a_37178_8187# VSS.t82 nfet_03v3 ad=0.56p pd=2.56u as=0.56p ps=2.56u w=2u l=1u
X927 a_37178_8187# vbn.t984 a_36888_7607# VSS.t80 nfet_03v3 ad=0.56p pd=2.56u as=0.56p ps=2.56u w=2u l=1u
X928 a_37178_5867# vbn.t924 a_36888_5287# VSS.t87 nfet_03v3 ad=0.56p pd=2.56u as=0.56p ps=2.56u w=2u l=1u
X929 a_41564_7607# vbn.t316 a_41854_8187# VSS.t83 nfet_03v3 ad=0.56p pd=2.56u as=0.56p ps=2.56u w=2u l=1u
X930 a_36888_5287# vbn.t145 a_37178_4707# VSS.t88 nfet_03v3 ad=0.56p pd=2.56u as=0.56p ps=2.56u w=2u l=1u
X931 a_36888_1807# vbn.t829 a_37178_1227# VSS.t81 nfet_03v3 ad=0.56p pd=2.56u as=0.56p ps=2.56u w=2u l=1u
X932 a_36888_6447# vbn.t578 a_37178_5867# VSS.t86 nfet_03v3 ad=0.56p pd=2.56u as=0.56p ps=2.56u w=2u l=1u
X933 a_36888_5287# vbn.t554 a_37178_5867# VSS.t87 nfet_03v3 ad=0.56p pd=2.56u as=0.56p ps=2.56u w=2u l=1u
X934 a_37178_4707# vbn.t898 a_36888_4127# VSS.t89 nfet_03v3 ad=0.56p pd=2.56u as=0.56p ps=2.56u w=2u l=1u
X935 a_41854_3547# vbn.t270 a_41564_4127# VSS.t90 nfet_03v3 ad=0.56p pd=2.56u as=0.56p ps=2.56u w=2u l=1u
X936 a_41564_6447# vbn.t304 a_41854_7027# VSS.t85 nfet_03v3 ad=0.56p pd=2.56u as=0.56p ps=2.56u w=2u l=1u
X937 w_36826_300# vbn.t346 a_37178_1227# VSS.t95 nfet_03v3 ad=0.56p pd=2.56u as=0.56p ps=2.56u w=2u l=1u
X938 a_37178_8187# vbn.t713 a_36866_9481# VSS.t82 nfet_03v3 ad=0.56p pd=2.56u as=0.9p ps=4.9u w=2u l=1u
X939 a_36888_1807# vbn.t398 a_37178_2387# VSS.t93 nfet_03v3 ad=0.56p pd=2.56u as=0.56p ps=2.56u w=2u l=1u
X940 a_36888_2967# vbn.t83 a_37178_2387# VSS.t92 nfet_03v3 ad=0.56p pd=2.56u as=0.56p ps=2.56u w=2u l=1u
X941 a_36888_5287# vbn.t143 a_37178_4707# VSS.t88 nfet_03v3 ad=0.56p pd=2.56u as=0.56p ps=2.56u w=2u l=1u
X942 a_37178_5867# vbn.t152 a_36888_5287# VSS.t87 nfet_03v3 ad=0.56p pd=2.56u as=0.56p ps=2.56u w=2u l=1u
X943 a_37178_5867# vbn.t162 a_36888_6447# VSS.t86 nfet_03v3 ad=0.56p pd=2.56u as=0.56p ps=2.56u w=2u l=1u
X944 vg.t26 a_6206_14# VSS.t121 VSS.t11 nfet_03v3 ad=0.336p pd=1.76u as=0.336p ps=1.76u w=1.2u l=5.335u
X945 a_37178_3547# vbn.t864 a_36888_2967# VSS.t91 nfet_03v3 ad=0.56p pd=2.56u as=0.56p ps=2.56u w=2u l=1u
X946 vg.t15 a_6206_4704# VSS.t34 VSS.t15 nfet_03v3 ad=0.336p pd=1.76u as=0.54p ps=3.3u w=1.2u l=5.335u
X947 a_36888_7607# vbn.t630 a_37178_7027# VSS.t84 nfet_03v3 ad=0.9p pd=4.9u as=0.56p ps=2.56u w=2u l=1u
X948 w_36826_300# vbn.t811 a_37178_1227# VSS.t95 nfet_03v3 ad=0.56p pd=2.56u as=0.56p ps=2.56u w=2u l=1u
X949 a_37178_8187# vbn.t996 a_36866_9481# VSS.t82 nfet_03v3 ad=0.56p pd=2.56u as=0.56p ps=2.56u w=2u l=1u
X950 a_36888_5287# vbn.t927 a_37178_5867# VSS.t81 nfet_03v3 ad=0.56p pd=2.56u as=0.56p ps=2.56u w=2u l=1u
X951 a_36888_5287# vbn.t542 a_37178_4707# VSS.t88 nfet_03v3 ad=0.56p pd=2.56u as=0.56p ps=2.56u w=2u l=1u
X952 a_41854_8187# vbn.t319 a_41564_7607# VSS.t83 nfet_03v3 ad=0.56p pd=2.56u as=0.56p ps=2.56u w=2u l=1u
X953 a_37178_2387# vbn.t403 a_36888_1807# VSS.t93 nfet_03v3 ad=0.56p pd=2.56u as=0.56p ps=2.56u w=2u l=1u
X954 a_36888_6447# vbn.t167 a_37178_5867# VSS.t86 nfet_03v3 ad=0.56p pd=2.56u as=0.56p ps=2.56u w=2u l=1u
X955 ls.t0 a_n3607_6703# VSS.t76 VSS.t75 nfet_03v3 ad=1.2p pd=4.4u as=0.54p ps=3.3u w=1.2u l=0.28u
X956 a_41854_4707# vbn.t275 a_41564_4127# VSS.t89 nfet_03v3 ad=0.56p pd=2.56u as=0.56p ps=2.56u w=2u l=1u
X957 a_37178_1227# vbn.t349 w_36826_300# VSS.t95 nfet_03v3 ad=0.56p pd=2.56u as=0.9p ps=4.9u w=2u l=1u
X958 vg.t32 a_6206_14# VSS.t125 VSS.t15 nfet_03v3 ad=0.336p pd=1.76u as=0.54p ps=3.3u w=1.2u l=5.335u
X959 a_37178_7027# vbn.t948 a_36888_6447# VSS.t85 nfet_03v3 ad=0.56p pd=2.56u as=0.56p ps=2.56u w=2u l=1u
X960 a_36888_2967# vbn.t448 a_37178_3547# VSS.t91 nfet_03v3 ad=0.56p pd=2.56u as=0.56p ps=2.56u w=2u l=1u
X961 a_36888_5287# vbn.t909 a_37178_4707# VSS.t88 nfet_03v3 ad=0.56p pd=2.56u as=0.56p ps=2.56u w=2u l=1u
X962 a_37178_2387# vbn.t840 a_36888_1807# VSS.t93 nfet_03v3 ad=0.56p pd=2.56u as=0.56p ps=2.56u w=2u l=1u
X963 a_41564_1807# vbn.t724 a_41854_1227# VSS.t94 nfet_03v3 ad=0.56p pd=2.56u as=0.56p ps=2.56u w=2u l=1u
X964 a_37178_7027# vbn.t633 a_36888_7607# VSS.t84 nfet_03v3 ad=0.56p pd=2.56u as=0.56p ps=2.56u w=2u l=1u
X965 a_37178_1227# vbn.t814 w_36826_300# VSS.t95 nfet_03v3 ad=0.56p pd=2.56u as=0.56p ps=2.56u w=2u l=1u
X966 w_37991_300# VSS.t144 VSS.t143 nplus_u r_width=2u r_length=100u
X967 a_36888_1807# vbn.t386 a_37178_2387# VSS.t93 nfet_03v3 ad=0.56p pd=2.56u as=0.56p ps=2.56u w=2u l=1u
X968 a_36888_6447# vbn.t616 a_37178_7027# VSS.t85 nfet_03v3 ad=0.56p pd=2.56u as=0.56p ps=2.56u w=2u l=1u
X969 a_37178_4707# vbn.t545 a_36888_5287# VSS.t88 nfet_03v3 ad=0.56p pd=2.56u as=0.9p ps=4.9u w=2u l=1u
X970 a_36888_4127# vbn.t500 a_37178_4707# VSS.t89 nfet_03v3 ad=0.56p pd=2.56u as=0.56p ps=2.56u w=2u l=1u
X971 a_37178_3547# vbn.t453 a_36888_2967# VSS.t91 nfet_03v3 ad=0.56p pd=2.56u as=0.56p ps=2.56u w=2u l=1u
X972 a_37178_2387# vbn.t429 a_36888_2967# VSS.t92 nfet_03v3 ad=0.56p pd=2.56u as=0.56p ps=2.56u w=2u l=1u
X973 a_41854_8187# vbn.t27 vbn.t28 VSS.t82 nfet_03v3 ad=0.56p pd=2.56u as=0.56p ps=2.56u w=2u l=1u
X974 a_996_6587# a_1867_7085# vg.t41 VSS.t146 nfet_03v3 ad=0.9p pd=4.9u as=0.9p ps=4.9u w=2u l=0.28u
X975 a_36888_7607# vbn.t189 a_37178_7027# VSS.t84 nfet_03v3 ad=0.9p pd=4.9u as=0.56p ps=2.56u w=2u l=1u
X976 a_41564_1807# vbn.t722 a_41854_1227# VSS.t94 nfet_03v3 ad=0.56p pd=2.56u as=0.56p ps=2.56u w=2u l=1u
X977 a_37178_2387# vbn.t68 a_36888_1807# VSS.t93 nfet_03v3 ad=0.56p pd=2.56u as=0.56p ps=2.56u w=2u l=1u
X978 a_37178_2387# vbn.t427 a_36888_2967# VSS.t92 nfet_03v3 ad=0.56p pd=2.56u as=0.56p ps=2.56u w=2u l=1u
X979 a_n7872_8894# VSS.t165 a_n2245_6719# VDD_LS.t22 pfet_03v3 ad=0.2808p pd=2.76u as=0.2808p ps=2.76u w=0.22u l=2u
X980 a_36888_4127# vbn.t462 a_37178_3547# VSS.t90 nfet_03v3 ad=0.9p pd=4.9u as=0.56p ps=2.56u w=2u l=1u
X981 vg.t17 vbnf.t22 VSS.t44 VSS.t11 nfet_03v3 ad=0.336p pd=1.76u as=0.336p ps=1.76u w=1.2u l=5.335u
X982 a_41564_5287# vbn.t773 a_41854_5867# VSS.t87 nfet_03v3 ad=0.56p pd=2.56u as=0.56p ps=2.56u w=2u l=1u
X983 a_37178_4707# vbn.t912 a_36888_5287# VSS.t88 nfet_03v3 ad=0.56p pd=2.56u as=0.56p ps=2.56u w=2u l=1u
X984 a_37178_2387# vbn.t852 a_36888_2967# VSS.t92 nfet_03v3 ad=0.56p pd=2.56u as=0.56p ps=2.56u w=2u l=1u
X985 a_36888_1807# vbn.t843 a_37178_2387# VSS.t81 nfet_03v3 ad=0.56p pd=2.56u as=0.56p ps=2.56u w=2u l=1u
X986 a_37178_7027# vbn.t621 a_36888_6447# VSS.t85 nfet_03v3 ad=0.56p pd=2.56u as=0.56p ps=2.56u w=2u l=1u
X987 a_37178_5867# vbn.t597 a_36888_6447# VSS.t86 nfet_03v3 ad=0.56p pd=2.56u as=0.56p ps=2.56u w=2u l=1u
X988 a_37178_4707# vbn.t505 a_36888_4127# VSS.t89 nfet_03v3 ad=0.56p pd=2.56u as=0.56p ps=2.56u w=2u l=1u
X989 a_36888_4127# vbn.t891 a_37178_4707# VSS.t89 nfet_03v3 ad=0.56p pd=2.56u as=0.56p ps=2.56u w=2u l=1u
X990 a_41854_1227# vbn.t727 a_41564_1807# VSS.t94 nfet_03v3 ad=0.56p pd=2.56u as=0.9p ps=4.9u w=2u l=1u
X991 vg.t39 vbnf.t24 VSS.t42 VSS.t11 nfet_03v3 ad=0.336p pd=1.76u as=0.336p ps=1.76u w=1.2u l=5.335u
X992 a_36866_9481# vbn.t696 a_37178_8187# VSS.t82 nfet_03v3 ad=0.56p pd=2.56u as=0.56p ps=2.56u w=2u l=1u
X993 a_41564_5287# vbn.t771 a_41854_5867# VSS.t87 nfet_03v3 ad=0.56p pd=2.56u as=0.56p ps=2.56u w=2u l=1u
X994 a_41854_2387# vbn.t737 a_41564_2967# VSS.t92 nfet_03v3 ad=0.56p pd=2.56u as=0.56p ps=2.56u w=2u l=1u
X995 a_41854_1227# vbn.t233 VSS.t107 VSS.t95 nfet_03v3 ad=0.56p pd=2.56u as=0.56p ps=2.56u w=2u l=1u
X996 VSS.t156 VDD_LS.t30 VSS.t156 VSS.t155 nfet_03v3 ad=13.7592p pd=49.7u as=0 ps=0 w=49.14u l=10u
X997 a_37178_5867# vbn.t595 a_36888_6447# VSS.t86 nfet_03v3 ad=0.56p pd=2.56u as=0.56p ps=2.56u w=2u l=1u
X998 a_37178_4707# vbn.t503 a_36888_4127# VSS.t89 nfet_03v3 ad=0.56p pd=2.56u as=0.56p ps=2.56u w=2u l=1u
X999 a_36888_2967# vbn.t456 a_37178_3547# VSS.t91 nfet_03v3 ad=0.56p pd=2.56u as=0.56p ps=2.56u w=2u l=1u
X1000 a_36888_2967# vbn.t432 a_37178_2387# VSS.t92 nfet_03v3 ad=0.56p pd=2.56u as=0.56p ps=2.56u w=2u l=1u
X1001 a_37178_5867# vbn.t936 a_36888_6447# VSS.t86 nfet_03v3 ad=0.56p pd=2.56u as=0.56p ps=2.56u w=2u l=1u
X1002 a_36888_7607# vbn.t658 a_37178_8187# VSS.t83 nfet_03v3 ad=0.9p pd=4.9u as=0.56p ps=2.56u w=2u l=1u
X1003 a_37178_8187# vbn.t701 a_36866_9481# VSS.t82 nfet_03v3 ad=0.56p pd=2.56u as=0.56p ps=2.56u w=2u l=1u
X1004 a_36866_9481# vbn.t989 a_37178_8187# VSS.t82 nfet_03v3 ad=0.56p pd=2.56u as=0.56p ps=2.56u w=2u l=1u
X1005 a_37178_3547# vbn.t465 a_36888_4127# VSS.t90 nfet_03v3 ad=0.56p pd=2.56u as=0.56p ps=2.56u w=2u l=1u
X1006 a_37178_3547# vbn.t441 a_36888_2967# VSS.t91 nfet_03v3 ad=0.56p pd=2.56u as=0.56p ps=2.56u w=2u l=1u
X1007 a_41854_5867# vbn.t779 a_41564_6447# VSS.t86 nfet_03v3 ad=0.56p pd=2.56u as=0.56p ps=2.56u w=2u l=1u
X1008 a_41854_5867# vbn.t776 a_41564_5287# VSS.t87 nfet_03v3 ad=0.56p pd=2.56u as=0.9p ps=4.9u w=2u l=1u
X1009 a_36888_2967# vbn.t855 a_37178_2387# VSS.t92 nfet_03v3 ad=0.56p pd=2.56u as=0.56p ps=2.56u w=2u l=1u
X1010 a_37178_7027# vbn.t647 a_36888_7607# VSS.t84 nfet_03v3 ad=0.56p pd=2.56u as=0.56p ps=2.56u w=2u l=1u
X1011 a_36888_6447# vbn.t624 a_37178_7027# VSS.t85 nfet_03v3 ad=0.56p pd=2.56u as=0.56p ps=2.56u w=2u l=1u
X1012 a_36888_6447# vbn.t600 a_37178_5867# VSS.t86 nfet_03v3 ad=0.56p pd=2.56u as=0.56p ps=2.56u w=2u l=1u
X1013 a_36888_4127# vbn.t508 a_37178_4707# VSS.t89 nfet_03v3 ad=0.56p pd=2.56u as=0.56p ps=2.56u w=2u l=1u
X1014 w_36826_300# vbn.t332 a_37178_1227# VSS.t95 nfet_03v3 ad=0.56p pd=2.56u as=0.56p ps=2.56u w=2u l=1u
X1015 a_37178_8187# vbn.t699 a_36866_9481# VSS.t82 nfet_03v3 ad=0.56p pd=2.56u as=0.56p ps=2.56u w=2u l=1u
X1016 a_36888_4127# vbn.t105 a_37178_3547# VSS.t90 nfet_03v3 ad=0.9p pd=4.9u as=0.56p ps=2.56u w=2u l=1u
X1017 a_41854_4707# vbn.t282 a_41564_5287# VSS.t88 nfet_03v3 ad=0.56p pd=2.56u as=0.56p ps=2.56u w=2u l=1u
X1018 VSS.t31 a_7096_6633# vg.t11 VSS.t19 nfet_03v3 ad=0.336p pd=1.76u as=0.336p ps=1.76u w=1.2u l=5.335u
X1019 a_41564_1807# vbn.t731 a_41854_2387# VSS.t93 nfet_03v3 ad=0.56p pd=2.56u as=0.56p ps=2.56u w=2u l=1u
X1020 a_37178_7027# vbn.t609 a_36888_6447# VSS.t85 nfet_03v3 ad=0.56p pd=2.56u as=0.56p ps=2.56u w=2u l=1u
X1021 a_36888_2967# vbn.t85 a_37178_2387# VSS.t92 nfet_03v3 ad=0.56p pd=2.56u as=0.56p ps=2.56u w=2u l=1u
X1022 a_36888_6447# vbn.t939 a_37178_5867# VSS.t86 nfet_03v3 ad=0.56p pd=2.56u as=0.56p ps=2.56u w=2u l=1u
X1023 a_37178_2387# vbn.t860 a_36888_2967# VSS.t78 nfet_03v3 ad=0.56p pd=2.56u as=0.9p ps=4.9u w=2u l=1u
X1024 a_37178_8187# vbn.t661 a_36888_7607# VSS.t83 nfet_03v3 ad=0.56p pd=2.56u as=0.56p ps=2.56u w=2u l=1u
X1025 a_37178_1227# vbn.t337 w_36826_300# VSS.t95 nfet_03v3 ad=0.56p pd=2.56u as=0.56p ps=2.56u w=2u l=1u
X1026 w_36826_300# vbn.t807 a_37178_1227# VSS.t95 nfet_03v3 ad=0.56p pd=2.56u as=0.56p ps=2.56u w=2u l=1u
X1027 a_36866_9481# vbn.t704 a_37178_8187# VSS.t82 nfet_03v3 ad=0.56p pd=2.56u as=0.56p ps=2.56u w=2u l=1u
X1028 VDD_LS.t24 a_n7601_6703# a_n8217_6703# VDD_LS.t23 pfet_03v3 ad=0.675p pd=3.9u as=1.5p ps=5u w=1.5u l=0.28u
X1029 a_36888_5287# vbn.t528 a_37178_4707# VSS.t88 nfet_03v3 ad=0.56p pd=2.56u as=0.56p ps=2.56u w=2u l=1u
X1030 a_37178_4707# vbn.t491 a_36888_4127# VSS.t89 nfet_03v3 ad=0.56p pd=2.56u as=0.56p ps=2.56u w=2u l=1u
X1031 a_36888_1807# vbn.t352 a_37178_1227# VSS.t94 nfet_03v3 ad=0.56p pd=2.56u as=0.56p ps=2.56u w=2u l=1u
X1032 a_36888_7607# vbn.t203 a_37178_8187# VSS.t83 nfet_03v3 ad=0.9p pd=4.9u as=0.56p ps=2.56u w=2u l=1u
X1033 a_41854_4707# vbn.t279 a_41564_4127# VSS.t89 nfet_03v3 ad=0.56p pd=2.56u as=0.9p ps=4.9u w=2u l=1u
X1034 a_41564_1807# vbn.t729 a_41854_2387# VSS.t93 nfet_03v3 ad=0.56p pd=2.56u as=0.56p ps=2.56u w=2u l=1u
X1035 a_37178_1227# vbn.t335 w_36826_300# VSS.t95 nfet_03v3 ad=0.56p pd=2.56u as=0.56p ps=2.56u w=2u l=1u
X1036 VSS.t113 a_6206_14# vg.t23 VSS.t19 nfet_03v3 ad=0.336p pd=1.76u as=0.336p ps=1.76u w=1.2u l=5.335u
X1037 a_37178_3547# vbn.t100 a_36888_2967# VSS.t91 nfet_03v3 ad=0.56p pd=2.56u as=0.56p ps=2.56u w=2u l=1u
X1038 a_37178_2387# vbn.t90 a_36888_2967# VSS.t92 nfet_03v3 ad=0.56p pd=2.56u as=0.9p ps=4.9u w=2u l=1u
X1039 a_36888_6447# vbn.t169 a_37178_5867# VSS.t86 nfet_03v3 ad=0.56p pd=2.56u as=0.56p ps=2.56u w=2u l=1u
X1040 a_36888_7607# vbn.t963 a_37178_7027# VSS.t84 nfet_03v3 ad=0.56p pd=2.56u as=0.56p ps=2.56u w=2u l=1u
X1041 a_37178_5867# vbn.t944 a_36888_6447# VSS.t78 nfet_03v3 ad=0.56p pd=2.56u as=0.9p ps=4.9u w=2u l=1u
X1042 a_41564_1807# vbn.t243 a_41854_1227# VSS.t94 nfet_03v3 ad=0.56p pd=2.56u as=0.56p ps=2.56u w=2u l=1u
X1043 a_37178_4707# vbn.t533 a_36888_5287# VSS.t88 nfet_03v3 ad=0.56p pd=2.56u as=0.56p ps=2.56u w=2u l=1u
X1044 a_36888_4127# vbn.t496 a_37178_4707# VSS.t89 nfet_03v3 ad=0.56p pd=2.56u as=0.56p ps=2.56u w=2u l=1u
X1045 a_36888_5287# vbn.t905 a_37178_4707# VSS.t88 nfet_03v3 ad=0.56p pd=2.56u as=0.56p ps=2.56u w=2u l=1u
X1046 a_41854_2387# vbn.t734 a_41564_1807# VSS.t93 nfet_03v3 ad=0.56p pd=2.56u as=0.9p ps=4.9u w=2u l=1u
X1047 a_36888_5287# vbn.t548 a_37178_5867# VSS.t87 nfet_03v3 ad=0.56p pd=2.56u as=0.56p ps=2.56u w=2u l=1u
X1048 a_37178_2387# vbn.t88 a_36888_2967# VSS.t92 nfet_03v3 ad=0.56p pd=2.56u as=0.56p ps=2.56u w=2u l=1u
X1049 a_37178_8187# vbn.t687 a_36866_9481# VSS.t82 nfet_03v3 ad=0.56p pd=2.56u as=0.56p ps=2.56u w=2u l=1u
X1050 w_36826_300# vbn.t340 a_37178_1227# VSS.t95 nfet_03v3 ad=0.56p pd=2.56u as=0.56p ps=2.56u w=2u l=1u
X1051 VDD.t39 vg.t43 VDD.t39 VDD.t38 pfet_03v3 ad=8.3496p pd=30.38u as=0 ps=0 w=29.82u l=4.12u
X1052 a_36888_1807# vbn.t819 a_37178_1227# VSS.t94 nfet_03v3 ad=0.9p pd=4.9u as=0.56p ps=2.56u w=2u l=1u
X1053 a_37178_3547# vbn.t479 a_36888_4127# VSS.t90 nfet_03v3 ad=0.56p pd=2.56u as=0.56p ps=2.56u w=2u l=1u
X1054 a_37178_2387# vbn.t415 a_36888_2967# VSS.t92 nfet_03v3 ad=0.56p pd=2.56u as=0.56p ps=2.56u w=2u l=1u
X1055 a_41854_8187# vbn.t19 vbn.t20 VSS.t82 nfet_03v3 ad=0.56p pd=2.56u as=0.9p ps=4.9u w=2u l=1u
X1056 a_37178_4707# vbn.t531 a_36888_5287# VSS.t88 nfet_03v3 ad=0.56p pd=2.56u as=0.56p ps=2.56u w=2u l=1u
X1057 a_37178_5867# vbn.t174 a_36888_6447# VSS.t86 nfet_03v3 ad=0.56p pd=2.56u as=0.9p ps=4.9u w=2u l=1u
X1058 a_37178_7027# vbn.t184 a_36888_6447# VSS.t85 nfet_03v3 ad=0.56p pd=2.56u as=0.56p ps=2.56u w=2u l=1u
X1059 a_36888_7607# vbn.t193 a_37178_7027# VSS.t84 nfet_03v3 ad=0.56p pd=2.56u as=0.56p ps=2.56u w=2u l=1u
X1060 a_37178_7027# vbn.t635 a_36888_7607# VSS.t84 nfet_03v3 ad=0.56p pd=2.56u as=0.56p ps=2.56u w=2u l=1u
X1061 VSS.t55 vbnf.t15 VSS.t55 VSS.t54 nfet_03v3 ad=13.7592p pd=49.7u as=0 ps=0 w=49.14u l=10u
X1062 a_37178_1227# vbn.t361 a_36888_1807# VSS.t94 nfet_03v3 ad=0.56p pd=2.56u as=0.56p ps=2.56u w=2u l=1u
X1063 a_37178_4707# vbn.t122 a_36888_4127# VSS.t89 nfet_03v3 ad=0.56p pd=2.56u as=0.56p ps=2.56u w=2u l=1u
X1064 a_41564_5287# vbn.t292 a_41854_5867# VSS.t87 nfet_03v3 ad=0.56p pd=2.56u as=0.56p ps=2.56u w=2u l=1u
X1065 a_37178_5867# vbn.t172 a_36888_6447# VSS.t86 nfet_03v3 ad=0.56p pd=2.56u as=0.56p ps=2.56u w=2u l=1u
X1066 a_36888_7607# vbn.t191 a_37178_7027# VSS.t84 nfet_03v3 ad=0.56p pd=2.56u as=0.56p ps=2.56u w=2u l=1u
X1067 a_36866_9481# vbn.t692 a_37178_8187# VSS.t82 nfet_03v3 ad=0.56p pd=2.56u as=0.56p ps=2.56u w=2u l=1u
X1068 a_37178_2387# vbn.t848 a_36888_2967# VSS.t92 nfet_03v3 ad=0.56p pd=2.56u as=0.56p ps=2.56u w=2u l=1u
X1069 a_37178_8187# vbn.t675 a_36888_7607# VSS.t83 nfet_03v3 ad=0.56p pd=2.56u as=0.56p ps=2.56u w=2u l=1u
X1070 a_37178_5867# vbn.t583 a_36888_6447# VSS.t86 nfet_03v3 ad=0.56p pd=2.56u as=0.56p ps=2.56u w=2u l=1u
X1071 a_36888_5287# vbn.t536 a_37178_4707# VSS.t88 nfet_03v3 ad=0.56p pd=2.56u as=0.56p ps=2.56u w=2u l=1u
X1072 vbnf.t2 bitb1.t1 a_7096_6633# VDD.t19 pfet_03v3 ad=2.25p pd=10.9u as=2.25p ps=10.9u w=5u l=0.28u
X1073 a_36888_5287# vbn.t917 a_37178_5867# VSS.t87 nfet_03v3 ad=0.9p pd=4.9u as=0.56p ps=2.56u w=2u l=1u
X1074 a_41854_3547# vbn.t742 a_41564_2967# VSS.t91 nfet_03v3 ad=0.9p pd=4.9u as=0.56p ps=2.56u w=2u l=1u
X1075 a_41854_2387# vbn.t739 a_41564_2967# VSS.t92 nfet_03v3 ad=0.56p pd=2.56u as=0.56p ps=2.56u w=2u l=1u
X1076 a_37178_1227# vbn.t323 w_36826_300# VSS.t95 nfet_03v3 ad=0.56p pd=2.56u as=0.56p ps=2.56u w=2u l=1u
X1077 a_41854_1227# vbn.t237 VSS.t103 VSS.t95 nfet_03v3 ad=0.56p pd=2.56u as=0.9p ps=4.9u w=2u l=1u
X1078 a_36888_1807# vbn.t366 a_37178_1227# VSS.t94 nfet_03v3 ad=0.56p pd=2.56u as=0.56p ps=2.56u w=2u l=1u
X1079 vbnf.t0 bit3.t0 a_6206_896# VSS.t0 nfet_03v3 ad=0.9p pd=4.9u as=0.9p ps=4.9u w=2u l=0.28u
X1080 a_36888_2967# vbn.t418 a_37178_2387# VSS.t92 nfet_03v3 ad=0.56p pd=2.56u as=0.56p ps=2.56u w=2u l=1u
X1081 a_37178_5867# vbn.t557 a_36888_5287# VSS.t87 nfet_03v3 ad=0.56p pd=2.56u as=0.56p ps=2.56u w=2u l=1u
X1082 a_37178_7027# vbn.t196 a_36888_7607# VSS.t84 nfet_03v3 ad=0.56p pd=2.56u as=0.56p ps=2.56u w=2u l=1u
X1083 a_36888_4127# vbn.t879 a_37178_3547# VSS.t90 nfet_03v3 ad=0.56p pd=2.56u as=0.56p ps=2.56u w=2u l=1u
X1084 a_37178_8187# vbn.t220 a_36866_9481# VSS.t82 nfet_03v3 ad=0.56p pd=2.56u as=0.56p ps=2.56u w=2u l=1u
X1085 a_37178_5867# vbn.t932 a_36888_6447# VSS.t86 nfet_03v3 ad=0.56p pd=2.56u as=0.56p ps=2.56u w=2u l=1u
X1086 a_41564_2967# vbn.t747 a_41854_3547# VSS.t91 nfet_03v3 ad=0.56p pd=2.56u as=0.56p ps=2.56u w=2u l=1u
X1087 w_36826_300# vbn.t328 a_37178_1227# VSS.t95 nfet_03v3 ad=0.56p pd=2.56u as=0.56p ps=2.56u w=2u l=1u
X1088 a_41854_7027# vbn.t784 a_41564_6447# VSS.t85 nfet_03v3 ad=0.9p pd=4.9u as=0.56p ps=2.56u w=2u l=1u
X1089 a_41854_5867# vbn.t781 a_41564_6447# VSS.t86 nfet_03v3 ad=0.56p pd=2.56u as=0.56p ps=2.56u w=2u l=1u
X1090 a_37178_4707# vbn.t519 a_36888_5287# VSS.t88 nfet_03v3 ad=0.56p pd=2.56u as=0.56p ps=2.56u w=2u l=1u
X1091 a_36888_1807# vbn.t380 a_37178_2387# VSS.t93 nfet_03v3 ad=0.56p pd=2.56u as=0.56p ps=2.56u w=2u l=1u
X1092 a_36888_2967# vbn.t859 a_37178_2387# VSS.t79 nfet_03v3 ad=0.56p pd=2.56u as=0.56p ps=2.56u w=2u l=1u
X1093 a_36888_7607# vbn.t201 a_37178_7027# VSS.t84 nfet_03v3 ad=0.56p pd=2.56u as=0.56p ps=2.56u w=2u l=1u
X1094 a_41854_4707# vbn.t286 a_41564_5287# VSS.t88 nfet_03v3 ad=0.56p pd=2.56u as=0.9p ps=4.9u w=2u l=1u
X1095 a_452_6633# a0.t3 VDD.t27 VDD.t26 pfet_03v3 ad=2.25p pd=10.9u as=2.25p ps=10.9u w=5u l=0.28u
X1096 a_36888_6447# vbn.t586 a_37178_5867# VSS.t86 nfet_03v3 ad=0.56p pd=2.56u as=0.56p ps=2.56u w=2u l=1u
X1097 a_36888_5287# vbn.t562 a_37178_5867# VSS.t87 nfet_03v3 ad=0.56p pd=2.56u as=0.56p ps=2.56u w=2u l=1u
X1098 a_36888_4127# vbn.t109 a_37178_3547# VSS.t90 nfet_03v3 ad=0.56p pd=2.56u as=0.56p ps=2.56u w=2u l=1u
X1099 a_37178_3547# vbn.t467 a_36888_4127# VSS.t90 nfet_03v3 ad=0.56p pd=2.56u as=0.56p ps=2.56u w=2u l=1u
X1100 VSS.t162 VDD_LS.t27 VSS.t162 VSS.t161 nfet_03v3 ad=13.7592p pd=49.7u as=0 ps=0 w=49.14u l=10u
X1101 a_36888_7607# vbn.t977 a_37178_8187# VSS.t83 nfet_03v3 ad=0.56p pd=2.56u as=0.56p ps=2.56u w=2u l=1u
X1102 a_36888_4127# vbn.t510 a_37178_4707# VSS.t89 nfet_03v3 ad=0.56p pd=2.56u as=0.56p ps=2.56u w=2u l=1u
X1103 a_41564_1807# vbn.t250 a_41854_2387# VSS.t93 nfet_03v3 ad=0.56p pd=2.56u as=0.56p ps=2.56u w=2u l=1u
X1104 a_41854_2387# vbn.t252 a_41564_2967# VSS.t92 nfet_03v3 ad=0.9p pd=4.9u as=0.56p ps=2.56u w=2u l=1u
X1105 a_41564_6447# vbn.t789 a_41854_7027# VSS.t85 nfet_03v3 ad=0.56p pd=2.56u as=0.56p ps=2.56u w=2u l=1u
X1106 a_36888_4127# vbn.t107 a_37178_3547# VSS.t90 nfet_03v3 ad=0.56p pd=2.56u as=0.56p ps=2.56u w=2u l=1u
X1107 a_37178_1227# vbn.t38 w_36826_300# VSS.t95 nfet_03v3 ad=0.56p pd=2.56u as=0.56p ps=2.56u w=2u l=1u
X1108 a_36888_7607# vbn.t199 a_37178_7027# VSS.t84 nfet_03v3 ad=0.56p pd=2.56u as=0.56p ps=2.56u w=2u l=1u
X1109 a_36888_5287# vbn.t524 a_37178_4707# VSS.t88 nfet_03v3 ad=0.56p pd=2.56u as=0.56p ps=2.56u w=2u l=1u
X1110 a_36888_6447# vbn.t943 a_37178_5867# VSS.t79 nfet_03v3 ad=0.56p pd=2.56u as=0.56p ps=2.56u w=2u l=1u
R0 vctrl vctrl.t0 90.2352
R1 vg.n84 vg.t43 31.0276
R2 vg.n55 vg.t48 26.4187
R3 vg.n59 vg.t47 26.4187
R4 vg.n67 vg.t46 26.4187
R5 vg.n74 vg.t45 26.4187
R6 vg.n81 vg.t44 26.4187
R7 vg.n55 vg.n54 21.9053
R8 vg.n59 vg.n47 21.9053
R9 vg.n60 vg.n59 21.9053
R10 vg.n67 vg.n44 21.9053
R11 vg.n74 vg.n73 21.9053
R12 vg.n82 vg.n81 21.9053
R13 vg.n81 vg.n40 21.9053
R14 vg.n19 vg.n18 14.5769
R15 vg.n34 vg.n32 10.4429
R16 vg.n28 vg.n26 10.4429
R17 vg.n22 vg.n20 10.4429
R18 vg.n14 vg.n12 10.4429
R19 vg.n8 vg.n6 10.4429
R20 vg.n2 vg.n0 10.4429
R21 vg vg.n86 8.16682
R22 vg.n81 vg.n80 8.0005
R23 vg.n59 vg.n50 8.0005
R24 vg.n36 vg.n35 7.6505
R25 vg.n34 vg.n33 7.6505
R26 vg.n30 vg.n29 7.6505
R27 vg.n28 vg.n27 7.6505
R28 vg.n24 vg.n23 7.6505
R29 vg.n22 vg.n21 7.6505
R30 vg.n16 vg.n15 7.6505
R31 vg.n14 vg.n13 7.6505
R32 vg.n10 vg.n9 7.6505
R33 vg.n8 vg.n7 7.6505
R34 vg.n4 vg.n3 7.6505
R35 vg.n2 vg.n1 7.6505
R36 vg.n37 vg.n36 6.02932
R37 vg.n31 vg.n30 6.02932
R38 vg.n25 vg.n24 6.02932
R39 vg.n17 vg.n16 6.02932
R40 vg.n11 vg.n10 6.02932
R41 vg.n5 vg.n4 6.02932
R42 vg.n56 vg.n55 5.8468
R43 vg.n75 vg.n74 5.8468
R44 vg.n68 vg.n67 5.8468
R45 vg.n86 vg.n85 4.7279
R46 vg.n36 vg.n34 2.79287
R47 vg.n30 vg.n28 2.79287
R48 vg.n24 vg.n22 2.79287
R49 vg.n16 vg.n14 2.79287
R50 vg.n10 vg.n8 2.79287
R51 vg.n4 vg.n2 2.79287
R52 vg.n46 vg.t20 2.71814
R53 vg.n65 vg.t41 2.71814
R54 vg.n49 vg.t42 2.71814
R55 vg.n58 vg.t12 2.71814
R56 vg.n52 vg.t19 2.71814
R57 vg.n54 vg.n53 2.4251
R58 vg.n85 vg.n84 2.28972
R59 vg.n53 vg.n51 2.2505
R60 vg.n57 vg.n48 2.2505
R61 vg.n62 vg.n61 2.2505
R62 vg.n64 vg.n63 2.2505
R63 vg.n66 vg.n45 2.2505
R64 vg.n70 vg.n69 2.2505
R65 vg.n72 vg.n71 2.2505
R66 vg.n43 vg.n42 2.2505
R67 vg.n77 vg.n76 2.2505
R68 vg.n79 vg.n78 2.2505
R69 vg.n41 vg.n39 2.2505
R70 vg.n83 vg.n38 2.2505
R71 vg.n86 vg.n37 1.83958
R72 vg.n35 vg.t25 1.4705
R73 vg.n35 vg.t15 1.4705
R74 vg.n33 vg.t23 1.4705
R75 vg.n33 vg.t22 1.4705
R76 vg.n32 vg.t24 1.4705
R77 vg.n32 vg.t5 1.4705
R78 vg.n29 vg.t21 1.4705
R79 vg.n29 vg.t30 1.4705
R80 vg.n27 vg.t11 1.4705
R81 vg.n27 vg.t31 1.4705
R82 vg.n26 vg.t2 1.4705
R83 vg.n26 vg.t34 1.4705
R84 vg.n23 vg.t35 1.4705
R85 vg.n23 vg.t8 1.4705
R86 vg.n21 vg.t16 1.4705
R87 vg.n21 vg.t1 1.4705
R88 vg.n20 vg.t36 1.4705
R89 vg.n20 vg.t39 1.4705
R90 vg.n18 vg.t18 1.4705
R91 vg.n18 vg.t9 1.4705
R92 vg.n15 vg.t0 1.4705
R93 vg.n15 vg.t37 1.4705
R94 vg.n13 vg.t7 1.4705
R95 vg.n13 vg.t13 1.4705
R96 vg.n12 vg.t3 1.4705
R97 vg.n12 vg.t26 1.4705
R98 vg.n9 vg.t27 1.4705
R99 vg.n9 vg.t4 1.4705
R100 vg.n7 vg.t28 1.4705
R101 vg.n7 vg.t10 1.4705
R102 vg.n6 vg.t29 1.4705
R103 vg.n6 vg.t17 1.4705
R104 vg.n3 vg.t6 1.4705
R105 vg.n3 vg.t32 1.4705
R106 vg.n1 vg.t40 1.4705
R107 vg.n1 vg.t33 1.4705
R108 vg.n0 vg.t14 1.4705
R109 vg.n0 vg.t38 1.4705
R110 vg.n19 vg.n17 1.30076
R111 vg.n31 vg.n25 1.13971
R112 vg.n11 vg.n5 1.13971
R113 vg.n5 vg 1.08997
R114 vg.n37 vg.n31 0.658921
R115 vg.n25 vg.n19 0.658921
R116 vg.n17 vg.n11 0.658921
R117 vg.n85 vg.n38 0.1205
R118 vg.n41 vg.n38 0.1205
R119 vg.n78 vg.n41 0.1205
R120 vg.n78 vg.n77 0.1205
R121 vg.n77 vg.n42 0.1205
R122 vg.n71 vg.n42 0.1205
R123 vg.n71 vg.n70 0.1205
R124 vg.n70 vg.n45 0.1205
R125 vg.n63 vg.n45 0.1205
R126 vg.n63 vg.n62 0.1205
R127 vg.n62 vg.n48 0.1205
R128 vg.n53 vg.n48 0.1205
R129 vg.n83 vg.n82 0.1187
R130 vg.n65 vg.n64 0.1094
R131 vg.n76 vg.n40 0.0983
R132 vg.n57 vg.n56 0.0950122
R133 vg.n76 vg.n75 0.0926122
R134 vg.n84 vg.n83 0.0830251
R135 vg.n72 vg.n44 0.0803
R136 vg.n80 vg.n39 0.0707
R137 vg.n68 vg.n66 0.0698122
R138 vg.n58 vg.n57 0.068
R139 vg.n73 vg.n43 0.0635
R140 vg.n73 vg.n72 0.0575
R141 vg.n69 vg.n68 0.0520149
R142 vg.n80 vg.n79 0.0503
R143 vg.n61 vg.n50 0.0479
R144 vg.n49 vg.n47 0.047
R145 vg.n52 vg.n51 0.0416
R146 vg.n75 vg.n43 0.0292149
R147 vg.n60 vg.n58 0.0284
R148 vg.n56 vg.n51 0.0268149
R149 vg.n50 vg.n49 0.026
R150 vg.n69 vg.n46 0.0254
R151 vg.n61 vg.n60 0.0251
R152 vg.n54 vg.n52 0.0248
R153 vg.n79 vg.n40 0.0227
R154 vg.n46 vg.n44 0.0158
R155 vg.n66 vg.n65 0.0116
R156 vg.n82 vg.n39 0.0023
R157 vg.n64 vg.n47 0.0011
R158 bit4 bit4.t0 78.8918
R159 bit3 bit3.t0 78.8918
R160 bit2 bit2.t0 78.8918
R161 bit1 bit1.t0 78.8918
R162 bit0 bit0.t0 78.8918
R163 bitb4.n0 bitb4.t1 110.341
R164 bitb4.n0 bitb4.t0 57.8015
R165 bitb4 bitb4.n0 16.0738
R166 bitb3.n0 bitb3.t1 110.341
R167 bitb3.n0 bitb3.t0 57.8015
R168 bitb3 bitb3.n0 16.0738
R169 bitb2.n0 bitb2.t1 110.341
R170 bitb2.n0 bitb2.t0 57.8015
R171 bitb2 bitb2.n0 16.0738
R172 bitb1.n0 bitb1.t1 110.341
R173 bitb1.n0 bitb1.t0 57.8015
R174 bitb1 bitb1.n0 16.0738
R175 bitb0.n0 bitb0.t1 110.341
R176 bitb0.n0 bitb0.t0 57.8015
R177 bitb0 bitb0.n0 16.0738
R178 a0.n1 a0.t3 101.793
R179 a0.n1 a0.t2 62.6858
R180 a0.n2 a0.n0 5.37563
R181 a0.n2 a0.n1 4.5005
R182 a0.n0 a0.t1 2.88512
R183 a0.n0 a0.t0 1.72163
R184 a0 a0.n2 0.692079
R185 ck ck.n0 17.56
R186 ck.n0 ck.t0 6.68892
R187 ck.n0 ck.t1 3.48853
R188 vbnf.n20 vbnf.t23 38.1796
R189 vbnf.n23 vbnf.t26 36.9444
R190 vbnf.n19 vbnf.t22 33.1076
R191 vbnf.n21 vbnf.t25 32.969
R192 vbnf.n21 vbnf.t24 32.5581
R193 vbnf.n19 vbnf.t21 31.0482
R194 vbnf.n0 vbnf.t11 23.4616
R195 vbnf.n8 vbnf.t20 22.2744
R196 vbnf.n7 vbnf.t19 22.2744
R197 vbnf.n6 vbnf.t18 22.2744
R198 vbnf.n5 vbnf.t17 22.2744
R199 vbnf.n4 vbnf.t16 22.2744
R200 vbnf.n3 vbnf.t15 22.2744
R201 vbnf.n2 vbnf.t14 22.2744
R202 vbnf.n1 vbnf.t13 22.2744
R203 vbnf.n0 vbnf.t12 22.2744
R204 vbnf vbnf.n25 10.1681
R205 vbnf.n24 vbnf.n23 8.26866
R206 vbnf.n9 vbnf.t5 7.56062
R207 vbnf vbnf.n9 6.54445
R208 vbnf.n20 vbnf.n19 6.13708
R209 vbnf.n12 vbnf.n10 6.08497
R210 vbnf.n12 vbnf.n11 5.20866
R211 vbnf.n14 vbnf.n13 5.20866
R212 vbnf.n16 vbnf.n15 5.20866
R213 vbnf.n18 vbnf.n17 5.20866
R214 vbnf.n22 vbnf.n21 4.5005
R215 vbnf.n10 vbnf.t9 3.71525
R216 vbnf.n11 vbnf.t8 3.71525
R217 vbnf.n13 vbnf.t7 3.71525
R218 vbnf.n15 vbnf.t0 3.71525
R219 vbnf.n17 vbnf.t10 3.71525
R220 vbnf.n25 vbnf 3.62182
R221 vbnf.n22 vbnf.n20 2.28129
R222 vbnf.n23 vbnf.n22 1.63708
R223 vbnf.n1 vbnf.n0 1.18772
R224 vbnf.n2 vbnf.n1 1.18772
R225 vbnf.n3 vbnf.n2 1.18772
R226 vbnf.n4 vbnf.n3 1.18772
R227 vbnf.n5 vbnf.n4 1.18772
R228 vbnf.n6 vbnf.n5 1.18772
R229 vbnf.n7 vbnf.n6 1.18772
R230 vbnf.n8 vbnf.n7 1.18772
R231 vbnf.n10 vbnf.t3 0.8915
R232 vbnf.n11 vbnf.t2 0.8915
R233 vbnf.n13 vbnf.t1 0.8915
R234 vbnf.n15 vbnf.t6 0.8915
R235 vbnf.n17 vbnf.t4 0.8915
R236 vbnf.n18 vbnf.n16 0.876816
R237 vbnf.n16 vbnf.n14 0.876816
R238 vbnf.n14 vbnf.n12 0.876816
R239 vbnf.n25 vbnf.n24 0.715763
R240 vbnf.n9 vbnf.n8 0.591977
R241 vbnf.n24 vbnf.n18 0.378263
R242 ls.n2 ls.t5 49.486
R243 ls.n1 ls.t6 44.9774
R244 ls.n5 ls.t3 31.7904
R245 ls.n1 ls.t4 31.7818
R246 ls.n3 ls.t2 16.1395
R247 ls.n4 ls.n3 6.95774
R248 ls.n0 ls.t0 6.34866
R249 ls ls.n0 5.42655
R250 ls.n2 ls.n1 4.89839
R251 ls.n3 ls 4.76339
R252 ls.n6 ls.n5 4.5005
R253 ls.n0 ls.t1 2.98002
R254 ls.n4 ls.n2 0.459974
R255 ls.n6 ls.n4 0.0455
R256 ls ls.n6 0.0241842
R257 vbn.n159 vbn.t34 49.3877
R258 vbn.n143 vbn.n142 41.4329
R259 vbn.n136 vbn.n135 41.4329
R260 vbn.n108 vbn.n107 41.4329
R261 vbn.n101 vbn.n100 41.4329
R262 vbn.n86 vbn.t33 21.6952
R263 vbn.t49 vbn.t35 21.1705
R264 vbn.t63 vbn.t49 21.1705
R265 vbn.t77 vbn.t63 21.1705
R266 vbn.t91 vbn.t77 21.1705
R267 vbn.t105 vbn.t91 21.1705
R268 vbn.t119 vbn.t105 21.1705
R269 vbn.t133 vbn.t119 21.1705
R270 vbn.t147 vbn.t133 21.1705
R271 vbn.t161 vbn.t147 21.1705
R272 vbn.t175 vbn.t161 21.1705
R273 vbn.t189 vbn.t175 21.1705
R274 vbn.t203 vbn.t189 21.1705
R275 vbn.t217 vbn.t203 21.1705
R276 vbn.t50 vbn.t36 21.1705
R277 vbn.t64 vbn.t50 21.1705
R278 vbn.t78 vbn.t64 21.1705
R279 vbn.t92 vbn.t78 21.1705
R280 vbn.t106 vbn.t92 21.1705
R281 vbn.t120 vbn.t106 21.1705
R282 vbn.t134 vbn.t120 21.1705
R283 vbn.t148 vbn.t134 21.1705
R284 vbn.t162 vbn.t148 21.1705
R285 vbn.t176 vbn.t162 21.1705
R286 vbn.t190 vbn.t176 21.1705
R287 vbn.t204 vbn.t190 21.1705
R288 vbn.t218 vbn.t204 21.1705
R289 vbn.t51 vbn.t37 21.1705
R290 vbn.t65 vbn.t51 21.1705
R291 vbn.t79 vbn.t65 21.1705
R292 vbn.t93 vbn.t79 21.1705
R293 vbn.t107 vbn.t93 21.1705
R294 vbn.t121 vbn.t107 21.1705
R295 vbn.t135 vbn.t121 21.1705
R296 vbn.t149 vbn.t135 21.1705
R297 vbn.t163 vbn.t149 21.1705
R298 vbn.t177 vbn.t163 21.1705
R299 vbn.t191 vbn.t177 21.1705
R300 vbn.t205 vbn.t191 21.1705
R301 vbn.t219 vbn.t205 21.1705
R302 vbn.t52 vbn.t38 21.1705
R303 vbn.t66 vbn.t52 21.1705
R304 vbn.t80 vbn.t66 21.1705
R305 vbn.t94 vbn.t80 21.1705
R306 vbn.t108 vbn.t94 21.1705
R307 vbn.t122 vbn.t108 21.1705
R308 vbn.t136 vbn.t122 21.1705
R309 vbn.t150 vbn.t136 21.1705
R310 vbn.t164 vbn.t150 21.1705
R311 vbn.t178 vbn.t164 21.1705
R312 vbn.t192 vbn.t178 21.1705
R313 vbn.t206 vbn.t192 21.1705
R314 vbn.t220 vbn.t206 21.1705
R315 vbn.t53 vbn.t39 21.1705
R316 vbn.t67 vbn.t53 21.1705
R317 vbn.t81 vbn.t67 21.1705
R318 vbn.t95 vbn.t81 21.1705
R319 vbn.t109 vbn.t95 21.1705
R320 vbn.t123 vbn.t109 21.1705
R321 vbn.t137 vbn.t123 21.1705
R322 vbn.t151 vbn.t137 21.1705
R323 vbn.t165 vbn.t151 21.1705
R324 vbn.t179 vbn.t165 21.1705
R325 vbn.t193 vbn.t179 21.1705
R326 vbn.t207 vbn.t193 21.1705
R327 vbn.t221 vbn.t207 21.1705
R328 vbn.t54 vbn.t40 21.1705
R329 vbn.t68 vbn.t54 21.1705
R330 vbn.t82 vbn.t68 21.1705
R331 vbn.t96 vbn.t82 21.1705
R332 vbn.t110 vbn.t96 21.1705
R333 vbn.t124 vbn.t110 21.1705
R334 vbn.t138 vbn.t124 21.1705
R335 vbn.t152 vbn.t138 21.1705
R336 vbn.t166 vbn.t152 21.1705
R337 vbn.t180 vbn.t166 21.1705
R338 vbn.t194 vbn.t180 21.1705
R339 vbn.t208 vbn.t194 21.1705
R340 vbn.t222 vbn.t208 21.1705
R341 vbn.t55 vbn.t41 21.1705
R342 vbn.t69 vbn.t55 21.1705
R343 vbn.t83 vbn.t69 21.1705
R344 vbn.t97 vbn.t83 21.1705
R345 vbn.t111 vbn.t97 21.1705
R346 vbn.t125 vbn.t111 21.1705
R347 vbn.t139 vbn.t125 21.1705
R348 vbn.t153 vbn.t139 21.1705
R349 vbn.t167 vbn.t153 21.1705
R350 vbn.t181 vbn.t167 21.1705
R351 vbn.t195 vbn.t181 21.1705
R352 vbn.t209 vbn.t195 21.1705
R353 vbn.t223 vbn.t209 21.1705
R354 vbn.t56 vbn.t42 21.1705
R355 vbn.t70 vbn.t56 21.1705
R356 vbn.t84 vbn.t70 21.1705
R357 vbn.t98 vbn.t84 21.1705
R358 vbn.t112 vbn.t98 21.1705
R359 vbn.t126 vbn.t112 21.1705
R360 vbn.t140 vbn.t126 21.1705
R361 vbn.t154 vbn.t140 21.1705
R362 vbn.t168 vbn.t154 21.1705
R363 vbn.t182 vbn.t168 21.1705
R364 vbn.t196 vbn.t182 21.1705
R365 vbn.t210 vbn.t196 21.1705
R366 vbn.t224 vbn.t210 21.1705
R367 vbn.t57 vbn.t43 21.1705
R368 vbn.t71 vbn.t57 21.1705
R369 vbn.t85 vbn.t71 21.1705
R370 vbn.t99 vbn.t85 21.1705
R371 vbn.t113 vbn.t99 21.1705
R372 vbn.t127 vbn.t113 21.1705
R373 vbn.t141 vbn.t127 21.1705
R374 vbn.t155 vbn.t141 21.1705
R375 vbn.t169 vbn.t155 21.1705
R376 vbn.t183 vbn.t169 21.1705
R377 vbn.t197 vbn.t183 21.1705
R378 vbn.t211 vbn.t197 21.1705
R379 vbn.t225 vbn.t211 21.1705
R380 vbn.t58 vbn.t44 21.1705
R381 vbn.t72 vbn.t58 21.1705
R382 vbn.t86 vbn.t72 21.1705
R383 vbn.t100 vbn.t86 21.1705
R384 vbn.t114 vbn.t100 21.1705
R385 vbn.t128 vbn.t114 21.1705
R386 vbn.t142 vbn.t128 21.1705
R387 vbn.t156 vbn.t142 21.1705
R388 vbn.t170 vbn.t156 21.1705
R389 vbn.t184 vbn.t170 21.1705
R390 vbn.t198 vbn.t184 21.1705
R391 vbn.t212 vbn.t198 21.1705
R392 vbn.t226 vbn.t212 21.1705
R393 vbn.t59 vbn.t45 21.1705
R394 vbn.t73 vbn.t59 21.1705
R395 vbn.t87 vbn.t73 21.1705
R396 vbn.t101 vbn.t87 21.1705
R397 vbn.t115 vbn.t101 21.1705
R398 vbn.t129 vbn.t115 21.1705
R399 vbn.t143 vbn.t129 21.1705
R400 vbn.t157 vbn.t143 21.1705
R401 vbn.t171 vbn.t157 21.1705
R402 vbn.t185 vbn.t171 21.1705
R403 vbn.t199 vbn.t185 21.1705
R404 vbn.t213 vbn.t199 21.1705
R405 vbn.t227 vbn.t213 21.1705
R406 vbn.t60 vbn.t46 21.1705
R407 vbn.t74 vbn.t60 21.1705
R408 vbn.t88 vbn.t74 21.1705
R409 vbn.t102 vbn.t88 21.1705
R410 vbn.t116 vbn.t102 21.1705
R411 vbn.t130 vbn.t116 21.1705
R412 vbn.t144 vbn.t130 21.1705
R413 vbn.t158 vbn.t144 21.1705
R414 vbn.t172 vbn.t158 21.1705
R415 vbn.t186 vbn.t172 21.1705
R416 vbn.t200 vbn.t186 21.1705
R417 vbn.t214 vbn.t200 21.1705
R418 vbn.t228 vbn.t214 21.1705
R419 vbn.t61 vbn.t47 21.1705
R420 vbn.t75 vbn.t61 21.1705
R421 vbn.t89 vbn.t75 21.1705
R422 vbn.t103 vbn.t89 21.1705
R423 vbn.t117 vbn.t103 21.1705
R424 vbn.t131 vbn.t117 21.1705
R425 vbn.t145 vbn.t131 21.1705
R426 vbn.t159 vbn.t145 21.1705
R427 vbn.t173 vbn.t159 21.1705
R428 vbn.t187 vbn.t173 21.1705
R429 vbn.t201 vbn.t187 21.1705
R430 vbn.t215 vbn.t201 21.1705
R431 vbn.t229 vbn.t215 21.1705
R432 vbn.t62 vbn.t48 21.1705
R433 vbn.t76 vbn.t62 21.1705
R434 vbn.t90 vbn.t76 21.1705
R435 vbn.t104 vbn.t90 21.1705
R436 vbn.t118 vbn.t104 21.1705
R437 vbn.t132 vbn.t118 21.1705
R438 vbn.t146 vbn.t132 21.1705
R439 vbn.t160 vbn.t146 21.1705
R440 vbn.t174 vbn.t160 21.1705
R441 vbn.t188 vbn.t174 21.1705
R442 vbn.t202 vbn.t188 21.1705
R443 vbn.t216 vbn.t202 21.1705
R444 vbn.t230 vbn.t216 21.1705
R445 vbn.t238 vbn.t231 21.1705
R446 vbn.t245 vbn.t238 21.1705
R447 vbn.t252 vbn.t245 21.1705
R448 vbn.t259 vbn.t252 21.1705
R449 vbn.t266 vbn.t259 21.1705
R450 vbn.t273 vbn.t266 21.1705
R451 vbn.t280 vbn.t273 21.1705
R452 vbn.t287 vbn.t280 21.1705
R453 vbn.t294 vbn.t287 21.1705
R454 vbn.t301 vbn.t294 21.1705
R455 vbn.t308 vbn.t301 21.1705
R456 vbn.t315 vbn.t308 21.1705
R457 vbn.t31 vbn.t315 21.1705
R458 vbn.t239 vbn.t232 21.1705
R459 vbn.t246 vbn.t239 21.1705
R460 vbn.t253 vbn.t246 21.1705
R461 vbn.t260 vbn.t253 21.1705
R462 vbn.t267 vbn.t260 21.1705
R463 vbn.t274 vbn.t267 21.1705
R464 vbn.t281 vbn.t274 21.1705
R465 vbn.t288 vbn.t281 21.1705
R466 vbn.t295 vbn.t288 21.1705
R467 vbn.t302 vbn.t295 21.1705
R468 vbn.t309 vbn.t302 21.1705
R469 vbn.t316 vbn.t309 21.1705
R470 vbn.t29 vbn.t316 21.1705
R471 vbn.t240 vbn.t233 21.1705
R472 vbn.t247 vbn.t240 21.1705
R473 vbn.t254 vbn.t247 21.1705
R474 vbn.t261 vbn.t254 21.1705
R475 vbn.t268 vbn.t261 21.1705
R476 vbn.t275 vbn.t268 21.1705
R477 vbn.t282 vbn.t275 21.1705
R478 vbn.t289 vbn.t282 21.1705
R479 vbn.t296 vbn.t289 21.1705
R480 vbn.t303 vbn.t296 21.1705
R481 vbn.t310 vbn.t303 21.1705
R482 vbn.t317 vbn.t310 21.1705
R483 vbn.t27 vbn.t317 21.1705
R484 vbn.t241 vbn.t234 21.1705
R485 vbn.t248 vbn.t241 21.1705
R486 vbn.t255 vbn.t248 21.1705
R487 vbn.t262 vbn.t255 21.1705
R488 vbn.t269 vbn.t262 21.1705
R489 vbn.t276 vbn.t269 21.1705
R490 vbn.t283 vbn.t276 21.1705
R491 vbn.t290 vbn.t283 21.1705
R492 vbn.t297 vbn.t290 21.1705
R493 vbn.t304 vbn.t297 21.1705
R494 vbn.t311 vbn.t304 21.1705
R495 vbn.t318 vbn.t311 21.1705
R496 vbn.t25 vbn.t318 21.1705
R497 vbn.t242 vbn.t235 21.1705
R498 vbn.t249 vbn.t242 21.1705
R499 vbn.t256 vbn.t249 21.1705
R500 vbn.t263 vbn.t256 21.1705
R501 vbn.t270 vbn.t263 21.1705
R502 vbn.t277 vbn.t270 21.1705
R503 vbn.t284 vbn.t277 21.1705
R504 vbn.t291 vbn.t284 21.1705
R505 vbn.t298 vbn.t291 21.1705
R506 vbn.t305 vbn.t298 21.1705
R507 vbn.t312 vbn.t305 21.1705
R508 vbn.t319 vbn.t312 21.1705
R509 vbn.t23 vbn.t319 21.1705
R510 vbn.t243 vbn.t236 21.1705
R511 vbn.t250 vbn.t243 21.1705
R512 vbn.t257 vbn.t250 21.1705
R513 vbn.t264 vbn.t257 21.1705
R514 vbn.t271 vbn.t264 21.1705
R515 vbn.t278 vbn.t271 21.1705
R516 vbn.t285 vbn.t278 21.1705
R517 vbn.t292 vbn.t285 21.1705
R518 vbn.t299 vbn.t292 21.1705
R519 vbn.t306 vbn.t299 21.1705
R520 vbn.t313 vbn.t306 21.1705
R521 vbn.t320 vbn.t313 21.1705
R522 vbn.t21 vbn.t320 21.1705
R523 vbn.t244 vbn.t237 21.1705
R524 vbn.t251 vbn.t244 21.1705
R525 vbn.t258 vbn.t251 21.1705
R526 vbn.t265 vbn.t258 21.1705
R527 vbn.t272 vbn.t265 21.1705
R528 vbn.t279 vbn.t272 21.1705
R529 vbn.t286 vbn.t279 21.1705
R530 vbn.t293 vbn.t286 21.1705
R531 vbn.t300 vbn.t293 21.1705
R532 vbn.t307 vbn.t300 21.1705
R533 vbn.t314 vbn.t307 21.1705
R534 vbn.t321 vbn.t314 21.1705
R535 vbn.t19 vbn.t321 21.1705
R536 vbn.t350 vbn.t322 21.1705
R537 vbn.t378 vbn.t350 21.1705
R538 vbn.t406 vbn.t378 21.1705
R539 vbn.t434 vbn.t406 21.1705
R540 vbn.t462 vbn.t434 21.1705
R541 vbn.t490 vbn.t462 21.1705
R542 vbn.t518 vbn.t490 21.1705
R543 vbn.t546 vbn.t518 21.1705
R544 vbn.t574 vbn.t546 21.1705
R545 vbn.t602 vbn.t574 21.1705
R546 vbn.t630 vbn.t602 21.1705
R547 vbn.t658 vbn.t630 21.1705
R548 vbn.t686 vbn.t658 21.1705
R549 vbn.t351 vbn.t323 21.1705
R550 vbn.t379 vbn.t351 21.1705
R551 vbn.t407 vbn.t379 21.1705
R552 vbn.t435 vbn.t407 21.1705
R553 vbn.t463 vbn.t435 21.1705
R554 vbn.t491 vbn.t463 21.1705
R555 vbn.t519 vbn.t491 21.1705
R556 vbn.t547 vbn.t519 21.1705
R557 vbn.t575 vbn.t547 21.1705
R558 vbn.t603 vbn.t575 21.1705
R559 vbn.t631 vbn.t603 21.1705
R560 vbn.t659 vbn.t631 21.1705
R561 vbn.t687 vbn.t659 21.1705
R562 vbn.t352 vbn.t324 21.1705
R563 vbn.t380 vbn.t352 21.1705
R564 vbn.t408 vbn.t380 21.1705
R565 vbn.t436 vbn.t408 21.1705
R566 vbn.t464 vbn.t436 21.1705
R567 vbn.t492 vbn.t464 21.1705
R568 vbn.t520 vbn.t492 21.1705
R569 vbn.t548 vbn.t520 21.1705
R570 vbn.t576 vbn.t548 21.1705
R571 vbn.t604 vbn.t576 21.1705
R572 vbn.t632 vbn.t604 21.1705
R573 vbn.t660 vbn.t632 21.1705
R574 vbn.t688 vbn.t660 21.1705
R575 vbn.t353 vbn.t325 21.1705
R576 vbn.t381 vbn.t353 21.1705
R577 vbn.t409 vbn.t381 21.1705
R578 vbn.t437 vbn.t409 21.1705
R579 vbn.t465 vbn.t437 21.1705
R580 vbn.t493 vbn.t465 21.1705
R581 vbn.t521 vbn.t493 21.1705
R582 vbn.t549 vbn.t521 21.1705
R583 vbn.t577 vbn.t549 21.1705
R584 vbn.t605 vbn.t577 21.1705
R585 vbn.t633 vbn.t605 21.1705
R586 vbn.t661 vbn.t633 21.1705
R587 vbn.t689 vbn.t661 21.1705
R588 vbn.t354 vbn.t326 21.1705
R589 vbn.t382 vbn.t354 21.1705
R590 vbn.t410 vbn.t382 21.1705
R591 vbn.t438 vbn.t410 21.1705
R592 vbn.t466 vbn.t438 21.1705
R593 vbn.t494 vbn.t466 21.1705
R594 vbn.t522 vbn.t494 21.1705
R595 vbn.t550 vbn.t522 21.1705
R596 vbn.t578 vbn.t550 21.1705
R597 vbn.t606 vbn.t578 21.1705
R598 vbn.t634 vbn.t606 21.1705
R599 vbn.t662 vbn.t634 21.1705
R600 vbn.t690 vbn.t662 21.1705
R601 vbn.t355 vbn.t327 21.1705
R602 vbn.t383 vbn.t355 21.1705
R603 vbn.t411 vbn.t383 21.1705
R604 vbn.t439 vbn.t411 21.1705
R605 vbn.t467 vbn.t439 21.1705
R606 vbn.t495 vbn.t467 21.1705
R607 vbn.t523 vbn.t495 21.1705
R608 vbn.t551 vbn.t523 21.1705
R609 vbn.t579 vbn.t551 21.1705
R610 vbn.t607 vbn.t579 21.1705
R611 vbn.t635 vbn.t607 21.1705
R612 vbn.t663 vbn.t635 21.1705
R613 vbn.t691 vbn.t663 21.1705
R614 vbn.t356 vbn.t328 21.1705
R615 vbn.t384 vbn.t356 21.1705
R616 vbn.t412 vbn.t384 21.1705
R617 vbn.t440 vbn.t412 21.1705
R618 vbn.t468 vbn.t440 21.1705
R619 vbn.t496 vbn.t468 21.1705
R620 vbn.t524 vbn.t496 21.1705
R621 vbn.t552 vbn.t524 21.1705
R622 vbn.t580 vbn.t552 21.1705
R623 vbn.t608 vbn.t580 21.1705
R624 vbn.t636 vbn.t608 21.1705
R625 vbn.t664 vbn.t636 21.1705
R626 vbn.t692 vbn.t664 21.1705
R627 vbn.t357 vbn.t329 21.1705
R628 vbn.t385 vbn.t357 21.1705
R629 vbn.t413 vbn.t385 21.1705
R630 vbn.t441 vbn.t413 21.1705
R631 vbn.t469 vbn.t441 21.1705
R632 vbn.t497 vbn.t469 21.1705
R633 vbn.t525 vbn.t497 21.1705
R634 vbn.t553 vbn.t525 21.1705
R635 vbn.t581 vbn.t553 21.1705
R636 vbn.t609 vbn.t581 21.1705
R637 vbn.t637 vbn.t609 21.1705
R638 vbn.t665 vbn.t637 21.1705
R639 vbn.t693 vbn.t665 21.1705
R640 vbn.t358 vbn.t330 21.1705
R641 vbn.t386 vbn.t358 21.1705
R642 vbn.t414 vbn.t386 21.1705
R643 vbn.t442 vbn.t414 21.1705
R644 vbn.t470 vbn.t442 21.1705
R645 vbn.t498 vbn.t470 21.1705
R646 vbn.t526 vbn.t498 21.1705
R647 vbn.t554 vbn.t526 21.1705
R648 vbn.t582 vbn.t554 21.1705
R649 vbn.t610 vbn.t582 21.1705
R650 vbn.t638 vbn.t610 21.1705
R651 vbn.t666 vbn.t638 21.1705
R652 vbn.t694 vbn.t666 21.1705
R653 vbn.t359 vbn.t331 21.1705
R654 vbn.t387 vbn.t359 21.1705
R655 vbn.t415 vbn.t387 21.1705
R656 vbn.t443 vbn.t415 21.1705
R657 vbn.t471 vbn.t443 21.1705
R658 vbn.t499 vbn.t471 21.1705
R659 vbn.t527 vbn.t499 21.1705
R660 vbn.t555 vbn.t527 21.1705
R661 vbn.t583 vbn.t555 21.1705
R662 vbn.t611 vbn.t583 21.1705
R663 vbn.t639 vbn.t611 21.1705
R664 vbn.t667 vbn.t639 21.1705
R665 vbn.t695 vbn.t667 21.1705
R666 vbn.t360 vbn.t332 21.1705
R667 vbn.t388 vbn.t360 21.1705
R668 vbn.t416 vbn.t388 21.1705
R669 vbn.t444 vbn.t416 21.1705
R670 vbn.t472 vbn.t444 21.1705
R671 vbn.t500 vbn.t472 21.1705
R672 vbn.t528 vbn.t500 21.1705
R673 vbn.t556 vbn.t528 21.1705
R674 vbn.t584 vbn.t556 21.1705
R675 vbn.t612 vbn.t584 21.1705
R676 vbn.t640 vbn.t612 21.1705
R677 vbn.t668 vbn.t640 21.1705
R678 vbn.t696 vbn.t668 21.1705
R679 vbn.t361 vbn.t333 21.1705
R680 vbn.t389 vbn.t361 21.1705
R681 vbn.t417 vbn.t389 21.1705
R682 vbn.t445 vbn.t417 21.1705
R683 vbn.t473 vbn.t445 21.1705
R684 vbn.t501 vbn.t473 21.1705
R685 vbn.t529 vbn.t501 21.1705
R686 vbn.t557 vbn.t529 21.1705
R687 vbn.t585 vbn.t557 21.1705
R688 vbn.t613 vbn.t585 21.1705
R689 vbn.t641 vbn.t613 21.1705
R690 vbn.t669 vbn.t641 21.1705
R691 vbn.t697 vbn.t669 21.1705
R692 vbn.t362 vbn.t334 21.1705
R693 vbn.t390 vbn.t362 21.1705
R694 vbn.t418 vbn.t390 21.1705
R695 vbn.t446 vbn.t418 21.1705
R696 vbn.t474 vbn.t446 21.1705
R697 vbn.t502 vbn.t474 21.1705
R698 vbn.t530 vbn.t502 21.1705
R699 vbn.t558 vbn.t530 21.1705
R700 vbn.t586 vbn.t558 21.1705
R701 vbn.t614 vbn.t586 21.1705
R702 vbn.t642 vbn.t614 21.1705
R703 vbn.t670 vbn.t642 21.1705
R704 vbn.t698 vbn.t670 21.1705
R705 vbn.t363 vbn.t335 21.1705
R706 vbn.t391 vbn.t363 21.1705
R707 vbn.t419 vbn.t391 21.1705
R708 vbn.t447 vbn.t419 21.1705
R709 vbn.t475 vbn.t447 21.1705
R710 vbn.t503 vbn.t475 21.1705
R711 vbn.t531 vbn.t503 21.1705
R712 vbn.t559 vbn.t531 21.1705
R713 vbn.t587 vbn.t559 21.1705
R714 vbn.t615 vbn.t587 21.1705
R715 vbn.t643 vbn.t615 21.1705
R716 vbn.t671 vbn.t643 21.1705
R717 vbn.t699 vbn.t671 21.1705
R718 vbn.t364 vbn.t336 21.1705
R719 vbn.t392 vbn.t364 21.1705
R720 vbn.t420 vbn.t392 21.1705
R721 vbn.t448 vbn.t420 21.1705
R722 vbn.t476 vbn.t448 21.1705
R723 vbn.t504 vbn.t476 21.1705
R724 vbn.t532 vbn.t504 21.1705
R725 vbn.t560 vbn.t532 21.1705
R726 vbn.t588 vbn.t560 21.1705
R727 vbn.t616 vbn.t588 21.1705
R728 vbn.t644 vbn.t616 21.1705
R729 vbn.t672 vbn.t644 21.1705
R730 vbn.t700 vbn.t672 21.1705
R731 vbn.t365 vbn.t337 21.1705
R732 vbn.t393 vbn.t365 21.1705
R733 vbn.t421 vbn.t393 21.1705
R734 vbn.t449 vbn.t421 21.1705
R735 vbn.t477 vbn.t449 21.1705
R736 vbn.t505 vbn.t477 21.1705
R737 vbn.t533 vbn.t505 21.1705
R738 vbn.t561 vbn.t533 21.1705
R739 vbn.t589 vbn.t561 21.1705
R740 vbn.t617 vbn.t589 21.1705
R741 vbn.t645 vbn.t617 21.1705
R742 vbn.t673 vbn.t645 21.1705
R743 vbn.t701 vbn.t673 21.1705
R744 vbn.t366 vbn.t338 21.1705
R745 vbn.t394 vbn.t366 21.1705
R746 vbn.t422 vbn.t394 21.1705
R747 vbn.t450 vbn.t422 21.1705
R748 vbn.t478 vbn.t450 21.1705
R749 vbn.t506 vbn.t478 21.1705
R750 vbn.t534 vbn.t506 21.1705
R751 vbn.t562 vbn.t534 21.1705
R752 vbn.t590 vbn.t562 21.1705
R753 vbn.t618 vbn.t590 21.1705
R754 vbn.t646 vbn.t618 21.1705
R755 vbn.t674 vbn.t646 21.1705
R756 vbn.t702 vbn.t674 21.1705
R757 vbn.t367 vbn.t339 21.1705
R758 vbn.t395 vbn.t367 21.1705
R759 vbn.t423 vbn.t395 21.1705
R760 vbn.t451 vbn.t423 21.1705
R761 vbn.t479 vbn.t451 21.1705
R762 vbn.t507 vbn.t479 21.1705
R763 vbn.t535 vbn.t507 21.1705
R764 vbn.t563 vbn.t535 21.1705
R765 vbn.t591 vbn.t563 21.1705
R766 vbn.t619 vbn.t591 21.1705
R767 vbn.t647 vbn.t619 21.1705
R768 vbn.t675 vbn.t647 21.1705
R769 vbn.t703 vbn.t675 21.1705
R770 vbn.t368 vbn.t340 21.1705
R771 vbn.t396 vbn.t368 21.1705
R772 vbn.t424 vbn.t396 21.1705
R773 vbn.t452 vbn.t424 21.1705
R774 vbn.t480 vbn.t452 21.1705
R775 vbn.t508 vbn.t480 21.1705
R776 vbn.t536 vbn.t508 21.1705
R777 vbn.t564 vbn.t536 21.1705
R778 vbn.t592 vbn.t564 21.1705
R779 vbn.t620 vbn.t592 21.1705
R780 vbn.t648 vbn.t620 21.1705
R781 vbn.t676 vbn.t648 21.1705
R782 vbn.t704 vbn.t676 21.1705
R783 vbn.t369 vbn.t341 21.1705
R784 vbn.t397 vbn.t369 21.1705
R785 vbn.t425 vbn.t397 21.1705
R786 vbn.t453 vbn.t425 21.1705
R787 vbn.t481 vbn.t453 21.1705
R788 vbn.t509 vbn.t481 21.1705
R789 vbn.t537 vbn.t509 21.1705
R790 vbn.t565 vbn.t537 21.1705
R791 vbn.t593 vbn.t565 21.1705
R792 vbn.t621 vbn.t593 21.1705
R793 vbn.t649 vbn.t621 21.1705
R794 vbn.t677 vbn.t649 21.1705
R795 vbn.t705 vbn.t677 21.1705
R796 vbn.t370 vbn.t342 21.1705
R797 vbn.t398 vbn.t370 21.1705
R798 vbn.t426 vbn.t398 21.1705
R799 vbn.t454 vbn.t426 21.1705
R800 vbn.t482 vbn.t454 21.1705
R801 vbn.t510 vbn.t482 21.1705
R802 vbn.t538 vbn.t510 21.1705
R803 vbn.t566 vbn.t538 21.1705
R804 vbn.t594 vbn.t566 21.1705
R805 vbn.t622 vbn.t594 21.1705
R806 vbn.t650 vbn.t622 21.1705
R807 vbn.t678 vbn.t650 21.1705
R808 vbn.t706 vbn.t678 21.1705
R809 vbn.t371 vbn.t343 21.1705
R810 vbn.t399 vbn.t371 21.1705
R811 vbn.t427 vbn.t399 21.1705
R812 vbn.t455 vbn.t427 21.1705
R813 vbn.t483 vbn.t455 21.1705
R814 vbn.t511 vbn.t483 21.1705
R815 vbn.t539 vbn.t511 21.1705
R816 vbn.t567 vbn.t539 21.1705
R817 vbn.t595 vbn.t567 21.1705
R818 vbn.t623 vbn.t595 21.1705
R819 vbn.t651 vbn.t623 21.1705
R820 vbn.t679 vbn.t651 21.1705
R821 vbn.t707 vbn.t679 21.1705
R822 vbn.t372 vbn.t344 21.1705
R823 vbn.t400 vbn.t372 21.1705
R824 vbn.t428 vbn.t400 21.1705
R825 vbn.t456 vbn.t428 21.1705
R826 vbn.t484 vbn.t456 21.1705
R827 vbn.t512 vbn.t484 21.1705
R828 vbn.t540 vbn.t512 21.1705
R829 vbn.t568 vbn.t540 21.1705
R830 vbn.t596 vbn.t568 21.1705
R831 vbn.t624 vbn.t596 21.1705
R832 vbn.t652 vbn.t624 21.1705
R833 vbn.t680 vbn.t652 21.1705
R834 vbn.t708 vbn.t680 21.1705
R835 vbn.t373 vbn.t345 21.1705
R836 vbn.t401 vbn.t373 21.1705
R837 vbn.t429 vbn.t401 21.1705
R838 vbn.t457 vbn.t429 21.1705
R839 vbn.t485 vbn.t457 21.1705
R840 vbn.t513 vbn.t485 21.1705
R841 vbn.t541 vbn.t513 21.1705
R842 vbn.t569 vbn.t541 21.1705
R843 vbn.t597 vbn.t569 21.1705
R844 vbn.t625 vbn.t597 21.1705
R845 vbn.t653 vbn.t625 21.1705
R846 vbn.t681 vbn.t653 21.1705
R847 vbn.t709 vbn.t681 21.1705
R848 vbn.t374 vbn.t346 21.1705
R849 vbn.t402 vbn.t374 21.1705
R850 vbn.t430 vbn.t402 21.1705
R851 vbn.t458 vbn.t430 21.1705
R852 vbn.t486 vbn.t458 21.1705
R853 vbn.t514 vbn.t486 21.1705
R854 vbn.t542 vbn.t514 21.1705
R855 vbn.t570 vbn.t542 21.1705
R856 vbn.t598 vbn.t570 21.1705
R857 vbn.t626 vbn.t598 21.1705
R858 vbn.t654 vbn.t626 21.1705
R859 vbn.t682 vbn.t654 21.1705
R860 vbn.t710 vbn.t682 21.1705
R861 vbn.t375 vbn.t347 21.1705
R862 vbn.t403 vbn.t375 21.1705
R863 vbn.t431 vbn.t403 21.1705
R864 vbn.t459 vbn.t431 21.1705
R865 vbn.t487 vbn.t459 21.1705
R866 vbn.t515 vbn.t487 21.1705
R867 vbn.t543 vbn.t515 21.1705
R868 vbn.t571 vbn.t543 21.1705
R869 vbn.t599 vbn.t571 21.1705
R870 vbn.t627 vbn.t599 21.1705
R871 vbn.t655 vbn.t627 21.1705
R872 vbn.t683 vbn.t655 21.1705
R873 vbn.t711 vbn.t683 21.1705
R874 vbn.t376 vbn.t348 21.1705
R875 vbn.t404 vbn.t376 21.1705
R876 vbn.t432 vbn.t404 21.1705
R877 vbn.t460 vbn.t432 21.1705
R878 vbn.t488 vbn.t460 21.1705
R879 vbn.t516 vbn.t488 21.1705
R880 vbn.t544 vbn.t516 21.1705
R881 vbn.t572 vbn.t544 21.1705
R882 vbn.t600 vbn.t572 21.1705
R883 vbn.t628 vbn.t600 21.1705
R884 vbn.t656 vbn.t628 21.1705
R885 vbn.t684 vbn.t656 21.1705
R886 vbn.t712 vbn.t684 21.1705
R887 vbn.t377 vbn.t349 21.1705
R888 vbn.t405 vbn.t377 21.1705
R889 vbn.t433 vbn.t405 21.1705
R890 vbn.t461 vbn.t433 21.1705
R891 vbn.t489 vbn.t461 21.1705
R892 vbn.t517 vbn.t489 21.1705
R893 vbn.t545 vbn.t517 21.1705
R894 vbn.t573 vbn.t545 21.1705
R895 vbn.t601 vbn.t573 21.1705
R896 vbn.t629 vbn.t601 21.1705
R897 vbn.t657 vbn.t629 21.1705
R898 vbn.t685 vbn.t657 21.1705
R899 vbn.t713 vbn.t685 21.1705
R900 vbn.t721 vbn.t714 21.1705
R901 vbn.t728 vbn.t721 21.1705
R902 vbn.t735 vbn.t728 21.1705
R903 vbn.t742 vbn.t735 21.1705
R904 vbn.t749 vbn.t742 21.1705
R905 vbn.t756 vbn.t749 21.1705
R906 vbn.t763 vbn.t756 21.1705
R907 vbn.t770 vbn.t763 21.1705
R908 vbn.t777 vbn.t770 21.1705
R909 vbn.t784 vbn.t777 21.1705
R910 vbn.t791 vbn.t784 21.1705
R911 vbn.t798 vbn.t791 21.1705
R912 vbn.t17 vbn.t798 21.1705
R913 vbn.t722 vbn.t715 21.1705
R914 vbn.t729 vbn.t722 21.1705
R915 vbn.t736 vbn.t729 21.1705
R916 vbn.t743 vbn.t736 21.1705
R917 vbn.t750 vbn.t743 21.1705
R918 vbn.t757 vbn.t750 21.1705
R919 vbn.t764 vbn.t757 21.1705
R920 vbn.t771 vbn.t764 21.1705
R921 vbn.t778 vbn.t771 21.1705
R922 vbn.t785 vbn.t778 21.1705
R923 vbn.t792 vbn.t785 21.1705
R924 vbn.t799 vbn.t792 21.1705
R925 vbn.t15 vbn.t799 21.1705
R926 vbn.t723 vbn.t716 21.1705
R927 vbn.t730 vbn.t723 21.1705
R928 vbn.t737 vbn.t730 21.1705
R929 vbn.t744 vbn.t737 21.1705
R930 vbn.t751 vbn.t744 21.1705
R931 vbn.t758 vbn.t751 21.1705
R932 vbn.t765 vbn.t758 21.1705
R933 vbn.t772 vbn.t765 21.1705
R934 vbn.t779 vbn.t772 21.1705
R935 vbn.t786 vbn.t779 21.1705
R936 vbn.t793 vbn.t786 21.1705
R937 vbn.t800 vbn.t793 21.1705
R938 vbn.t13 vbn.t800 21.1705
R939 vbn.t724 vbn.t717 21.1705
R940 vbn.t731 vbn.t724 21.1705
R941 vbn.t738 vbn.t731 21.1705
R942 vbn.t745 vbn.t738 21.1705
R943 vbn.t752 vbn.t745 21.1705
R944 vbn.t759 vbn.t752 21.1705
R945 vbn.t766 vbn.t759 21.1705
R946 vbn.t773 vbn.t766 21.1705
R947 vbn.t780 vbn.t773 21.1705
R948 vbn.t787 vbn.t780 21.1705
R949 vbn.t794 vbn.t787 21.1705
R950 vbn.t801 vbn.t794 21.1705
R951 vbn.t11 vbn.t801 21.1705
R952 vbn.t725 vbn.t718 21.1705
R953 vbn.t732 vbn.t725 21.1705
R954 vbn.t739 vbn.t732 21.1705
R955 vbn.t746 vbn.t739 21.1705
R956 vbn.t753 vbn.t746 21.1705
R957 vbn.t760 vbn.t753 21.1705
R958 vbn.t767 vbn.t760 21.1705
R959 vbn.t774 vbn.t767 21.1705
R960 vbn.t781 vbn.t774 21.1705
R961 vbn.t788 vbn.t781 21.1705
R962 vbn.t795 vbn.t788 21.1705
R963 vbn.t802 vbn.t795 21.1705
R964 vbn.t9 vbn.t802 21.1705
R965 vbn.t726 vbn.t719 21.1705
R966 vbn.t733 vbn.t726 21.1705
R967 vbn.t740 vbn.t733 21.1705
R968 vbn.t747 vbn.t740 21.1705
R969 vbn.t754 vbn.t747 21.1705
R970 vbn.t761 vbn.t754 21.1705
R971 vbn.t768 vbn.t761 21.1705
R972 vbn.t775 vbn.t768 21.1705
R973 vbn.t782 vbn.t775 21.1705
R974 vbn.t789 vbn.t782 21.1705
R975 vbn.t796 vbn.t789 21.1705
R976 vbn.t803 vbn.t796 21.1705
R977 vbn.t7 vbn.t803 21.1705
R978 vbn.t727 vbn.t720 21.1705
R979 vbn.t734 vbn.t727 21.1705
R980 vbn.t741 vbn.t734 21.1705
R981 vbn.t748 vbn.t741 21.1705
R982 vbn.t755 vbn.t748 21.1705
R983 vbn.t762 vbn.t755 21.1705
R984 vbn.t769 vbn.t762 21.1705
R985 vbn.t776 vbn.t769 21.1705
R986 vbn.t783 vbn.t776 21.1705
R987 vbn.t790 vbn.t783 21.1705
R988 vbn.t797 vbn.t790 21.1705
R989 vbn.t804 vbn.t797 21.1705
R990 vbn.t5 vbn.t804 21.1705
R991 vbn.t819 vbn.t805 21.1705
R992 vbn.t833 vbn.t819 21.1705
R993 vbn.t847 vbn.t833 21.1705
R994 vbn.t861 vbn.t847 21.1705
R995 vbn.t875 vbn.t861 21.1705
R996 vbn.t889 vbn.t875 21.1705
R997 vbn.t903 vbn.t889 21.1705
R998 vbn.t917 vbn.t903 21.1705
R999 vbn.t931 vbn.t917 21.1705
R1000 vbn.t945 vbn.t931 21.1705
R1001 vbn.t959 vbn.t945 21.1705
R1002 vbn.t973 vbn.t959 21.1705
R1003 vbn.t987 vbn.t973 21.1705
R1004 vbn.t820 vbn.t806 21.1705
R1005 vbn.t834 vbn.t820 21.1705
R1006 vbn.t848 vbn.t834 21.1705
R1007 vbn.t862 vbn.t848 21.1705
R1008 vbn.t876 vbn.t862 21.1705
R1009 vbn.t890 vbn.t876 21.1705
R1010 vbn.t904 vbn.t890 21.1705
R1011 vbn.t918 vbn.t904 21.1705
R1012 vbn.t932 vbn.t918 21.1705
R1013 vbn.t946 vbn.t932 21.1705
R1014 vbn.t960 vbn.t946 21.1705
R1015 vbn.t974 vbn.t960 21.1705
R1016 vbn.t988 vbn.t974 21.1705
R1017 vbn.t821 vbn.t807 21.1705
R1018 vbn.t835 vbn.t821 21.1705
R1019 vbn.t849 vbn.t835 21.1705
R1020 vbn.t863 vbn.t849 21.1705
R1021 vbn.t877 vbn.t863 21.1705
R1022 vbn.t891 vbn.t877 21.1705
R1023 vbn.t905 vbn.t891 21.1705
R1024 vbn.t919 vbn.t905 21.1705
R1025 vbn.t933 vbn.t919 21.1705
R1026 vbn.t947 vbn.t933 21.1705
R1027 vbn.t961 vbn.t947 21.1705
R1028 vbn.t975 vbn.t961 21.1705
R1029 vbn.t989 vbn.t975 21.1705
R1030 vbn.t822 vbn.t808 21.1705
R1031 vbn.t836 vbn.t822 21.1705
R1032 vbn.t850 vbn.t836 21.1705
R1033 vbn.t864 vbn.t850 21.1705
R1034 vbn.t878 vbn.t864 21.1705
R1035 vbn.t892 vbn.t878 21.1705
R1036 vbn.t906 vbn.t892 21.1705
R1037 vbn.t920 vbn.t906 21.1705
R1038 vbn.t934 vbn.t920 21.1705
R1039 vbn.t948 vbn.t934 21.1705
R1040 vbn.t962 vbn.t948 21.1705
R1041 vbn.t976 vbn.t962 21.1705
R1042 vbn.t990 vbn.t976 21.1705
R1043 vbn.t823 vbn.t809 21.1705
R1044 vbn.t837 vbn.t823 21.1705
R1045 vbn.t851 vbn.t837 21.1705
R1046 vbn.t865 vbn.t851 21.1705
R1047 vbn.t879 vbn.t865 21.1705
R1048 vbn.t893 vbn.t879 21.1705
R1049 vbn.t907 vbn.t893 21.1705
R1050 vbn.t921 vbn.t907 21.1705
R1051 vbn.t935 vbn.t921 21.1705
R1052 vbn.t949 vbn.t935 21.1705
R1053 vbn.t963 vbn.t949 21.1705
R1054 vbn.t977 vbn.t963 21.1705
R1055 vbn.t991 vbn.t977 21.1705
R1056 vbn.t824 vbn.t810 21.1705
R1057 vbn.t838 vbn.t824 21.1705
R1058 vbn.t852 vbn.t838 21.1705
R1059 vbn.t866 vbn.t852 21.1705
R1060 vbn.t880 vbn.t866 21.1705
R1061 vbn.t894 vbn.t880 21.1705
R1062 vbn.t908 vbn.t894 21.1705
R1063 vbn.t922 vbn.t908 21.1705
R1064 vbn.t936 vbn.t922 21.1705
R1065 vbn.t950 vbn.t936 21.1705
R1066 vbn.t964 vbn.t950 21.1705
R1067 vbn.t978 vbn.t964 21.1705
R1068 vbn.t992 vbn.t978 21.1705
R1069 vbn.t825 vbn.t811 21.1705
R1070 vbn.t839 vbn.t825 21.1705
R1071 vbn.t853 vbn.t839 21.1705
R1072 vbn.t867 vbn.t853 21.1705
R1073 vbn.t881 vbn.t867 21.1705
R1074 vbn.t895 vbn.t881 21.1705
R1075 vbn.t909 vbn.t895 21.1705
R1076 vbn.t923 vbn.t909 21.1705
R1077 vbn.t937 vbn.t923 21.1705
R1078 vbn.t951 vbn.t937 21.1705
R1079 vbn.t965 vbn.t951 21.1705
R1080 vbn.t979 vbn.t965 21.1705
R1081 vbn.t993 vbn.t979 21.1705
R1082 vbn.t826 vbn.t812 21.1705
R1083 vbn.t840 vbn.t826 21.1705
R1084 vbn.t854 vbn.t840 21.1705
R1085 vbn.t868 vbn.t854 21.1705
R1086 vbn.t882 vbn.t868 21.1705
R1087 vbn.t896 vbn.t882 21.1705
R1088 vbn.t910 vbn.t896 21.1705
R1089 vbn.t924 vbn.t910 21.1705
R1090 vbn.t938 vbn.t924 21.1705
R1091 vbn.t952 vbn.t938 21.1705
R1092 vbn.t966 vbn.t952 21.1705
R1093 vbn.t980 vbn.t966 21.1705
R1094 vbn.t994 vbn.t980 21.1705
R1095 vbn.t827 vbn.t813 21.1705
R1096 vbn.t841 vbn.t827 21.1705
R1097 vbn.t855 vbn.t841 21.1705
R1098 vbn.t869 vbn.t855 21.1705
R1099 vbn.t883 vbn.t869 21.1705
R1100 vbn.t897 vbn.t883 21.1705
R1101 vbn.t911 vbn.t897 21.1705
R1102 vbn.t925 vbn.t911 21.1705
R1103 vbn.t939 vbn.t925 21.1705
R1104 vbn.t953 vbn.t939 21.1705
R1105 vbn.t967 vbn.t953 21.1705
R1106 vbn.t981 vbn.t967 21.1705
R1107 vbn.t995 vbn.t981 21.1705
R1108 vbn.t828 vbn.t814 21.1705
R1109 vbn.t842 vbn.t828 21.1705
R1110 vbn.t856 vbn.t842 21.1705
R1111 vbn.t870 vbn.t856 21.1705
R1112 vbn.t884 vbn.t870 21.1705
R1113 vbn.t898 vbn.t884 21.1705
R1114 vbn.t912 vbn.t898 21.1705
R1115 vbn.t926 vbn.t912 21.1705
R1116 vbn.t940 vbn.t926 21.1705
R1117 vbn.t954 vbn.t940 21.1705
R1118 vbn.t968 vbn.t954 21.1705
R1119 vbn.t982 vbn.t968 21.1705
R1120 vbn.t996 vbn.t982 21.1705
R1121 vbn.t829 vbn.t815 21.1705
R1122 vbn.t843 vbn.t829 21.1705
R1123 vbn.t857 vbn.t843 21.1705
R1124 vbn.t871 vbn.t857 21.1705
R1125 vbn.t885 vbn.t871 21.1705
R1126 vbn.t899 vbn.t885 21.1705
R1127 vbn.t913 vbn.t899 21.1705
R1128 vbn.t927 vbn.t913 21.1705
R1129 vbn.t941 vbn.t927 21.1705
R1130 vbn.t955 vbn.t941 21.1705
R1131 vbn.t969 vbn.t955 21.1705
R1132 vbn.t983 vbn.t969 21.1705
R1133 vbn.t997 vbn.t983 21.1705
R1134 vbn.t830 vbn.t816 21.1705
R1135 vbn.t844 vbn.t830 21.1705
R1136 vbn.t858 vbn.t844 21.1705
R1137 vbn.t872 vbn.t858 21.1705
R1138 vbn.t886 vbn.t872 21.1705
R1139 vbn.t900 vbn.t886 21.1705
R1140 vbn.t914 vbn.t900 21.1705
R1141 vbn.t928 vbn.t914 21.1705
R1142 vbn.t942 vbn.t928 21.1705
R1143 vbn.t956 vbn.t942 21.1705
R1144 vbn.t970 vbn.t956 21.1705
R1145 vbn.t984 vbn.t970 21.1705
R1146 vbn.t998 vbn.t984 21.1705
R1147 vbn.t831 vbn.t817 21.1705
R1148 vbn.t845 vbn.t831 21.1705
R1149 vbn.t859 vbn.t845 21.1705
R1150 vbn.t873 vbn.t859 21.1705
R1151 vbn.t887 vbn.t873 21.1705
R1152 vbn.t901 vbn.t887 21.1705
R1153 vbn.t915 vbn.t901 21.1705
R1154 vbn.t929 vbn.t915 21.1705
R1155 vbn.t943 vbn.t929 21.1705
R1156 vbn.t957 vbn.t943 21.1705
R1157 vbn.t971 vbn.t957 21.1705
R1158 vbn.t985 vbn.t971 21.1705
R1159 vbn.t999 vbn.t985 21.1705
R1160 vbn.t832 vbn.t818 21.1705
R1161 vbn.t846 vbn.t832 21.1705
R1162 vbn.t860 vbn.t846 21.1705
R1163 vbn.t874 vbn.t860 21.1705
R1164 vbn.t888 vbn.t874 21.1705
R1165 vbn.t902 vbn.t888 21.1705
R1166 vbn.t916 vbn.t902 21.1705
R1167 vbn.t930 vbn.t916 21.1705
R1168 vbn.t944 vbn.t930 21.1705
R1169 vbn.t958 vbn.t944 21.1705
R1170 vbn.t972 vbn.t958 21.1705
R1171 vbn.t986 vbn.t972 21.1705
R1172 vbn.t1000 vbn.t986 21.1705
R1173 vbn.n156 vbn.t217 15.0385
R1174 vbn.n155 vbn.t218 15.0385
R1175 vbn.n154 vbn.t219 15.0385
R1176 vbn.n153 vbn.t220 15.0385
R1177 vbn.n152 vbn.t221 15.0385
R1178 vbn.n151 vbn.t222 15.0385
R1179 vbn.n150 vbn.t223 15.0385
R1180 vbn.n149 vbn.t224 15.0385
R1181 vbn.n148 vbn.t225 15.0385
R1182 vbn.n147 vbn.t226 15.0385
R1183 vbn.n146 vbn.t227 15.0385
R1184 vbn.n145 vbn.t228 15.0385
R1185 vbn.n144 vbn.t229 15.0385
R1186 vbn.n143 vbn.t230 15.0385
R1187 vbn.n142 vbn.t31 15.0385
R1188 vbn.n141 vbn.t29 15.0385
R1189 vbn.n140 vbn.t27 15.0385
R1190 vbn.n139 vbn.t25 15.0385
R1191 vbn.n138 vbn.t23 15.0385
R1192 vbn.n137 vbn.t21 15.0385
R1193 vbn.n136 vbn.t19 15.0385
R1194 vbn.n135 vbn.t686 15.0385
R1195 vbn.n134 vbn.t687 15.0385
R1196 vbn.n133 vbn.t688 15.0385
R1197 vbn.n132 vbn.t689 15.0385
R1198 vbn.n131 vbn.t690 15.0385
R1199 vbn.n130 vbn.t691 15.0385
R1200 vbn.n129 vbn.t692 15.0385
R1201 vbn.n128 vbn.t693 15.0385
R1202 vbn.n127 vbn.t694 15.0385
R1203 vbn.n126 vbn.t695 15.0385
R1204 vbn.n125 vbn.t696 15.0385
R1205 vbn.n124 vbn.t697 15.0385
R1206 vbn.n123 vbn.t698 15.0385
R1207 vbn.n122 vbn.t699 15.0385
R1208 vbn.n121 vbn.t700 15.0385
R1209 vbn.n120 vbn.t701 15.0385
R1210 vbn.n119 vbn.t702 15.0385
R1211 vbn.n118 vbn.t703 15.0385
R1212 vbn.n117 vbn.t704 15.0385
R1213 vbn.n116 vbn.t705 15.0385
R1214 vbn.n115 vbn.t706 15.0385
R1215 vbn.n114 vbn.t707 15.0385
R1216 vbn.n113 vbn.t708 15.0385
R1217 vbn.n112 vbn.t709 15.0385
R1218 vbn.n111 vbn.t710 15.0385
R1219 vbn.n110 vbn.t711 15.0385
R1220 vbn.n109 vbn.t712 15.0385
R1221 vbn.n108 vbn.t713 15.0385
R1222 vbn.n107 vbn.t17 15.0385
R1223 vbn.n106 vbn.t15 15.0385
R1224 vbn.n105 vbn.t13 15.0385
R1225 vbn.n104 vbn.t11 15.0385
R1226 vbn.n103 vbn.t9 15.0385
R1227 vbn.n102 vbn.t7 15.0385
R1228 vbn.n101 vbn.t5 15.0385
R1229 vbn.n100 vbn.t987 15.0385
R1230 vbn.n99 vbn.t988 15.0385
R1231 vbn.n98 vbn.t989 15.0385
R1232 vbn.n97 vbn.t990 15.0385
R1233 vbn.n96 vbn.t991 15.0385
R1234 vbn.n95 vbn.t992 15.0385
R1235 vbn.n94 vbn.t993 15.0385
R1236 vbn.n93 vbn.t994 15.0385
R1237 vbn.n92 vbn.t995 15.0385
R1238 vbn.n91 vbn.t996 15.0385
R1239 vbn.n90 vbn.t997 15.0385
R1240 vbn.n89 vbn.t998 15.0385
R1241 vbn.n88 vbn.t999 15.0385
R1242 vbn.n87 vbn.t1000 15.0385
R1243 vbn.n9 vbn.n8 11.1598
R1244 vbn.n77 vbn.n76 11.1598
R1245 vbn.n156 vbn.n155 11.0491
R1246 vbn.n155 vbn.n154 11.0491
R1247 vbn.n154 vbn.n153 11.0491
R1248 vbn.n153 vbn.n152 11.0491
R1249 vbn.n152 vbn.n151 11.0491
R1250 vbn.n151 vbn.n150 11.0491
R1251 vbn.n150 vbn.n149 11.0491
R1252 vbn.n149 vbn.n148 11.0491
R1253 vbn.n148 vbn.n147 11.0491
R1254 vbn.n147 vbn.n146 11.0491
R1255 vbn.n146 vbn.n145 11.0491
R1256 vbn.n145 vbn.n144 11.0491
R1257 vbn.n144 vbn.n143 11.0491
R1258 vbn.n142 vbn.n141 11.0491
R1259 vbn.n141 vbn.n140 11.0491
R1260 vbn.n140 vbn.n139 11.0491
R1261 vbn.n139 vbn.n138 11.0491
R1262 vbn.n138 vbn.n137 11.0491
R1263 vbn.n137 vbn.n136 11.0491
R1264 vbn.n135 vbn.n134 11.0491
R1265 vbn.n134 vbn.n133 11.0491
R1266 vbn.n133 vbn.n132 11.0491
R1267 vbn.n132 vbn.n131 11.0491
R1268 vbn.n131 vbn.n130 11.0491
R1269 vbn.n130 vbn.n129 11.0491
R1270 vbn.n129 vbn.n128 11.0491
R1271 vbn.n128 vbn.n127 11.0491
R1272 vbn.n127 vbn.n126 11.0491
R1273 vbn.n126 vbn.n125 11.0491
R1274 vbn.n125 vbn.n124 11.0491
R1275 vbn.n124 vbn.n123 11.0491
R1276 vbn.n123 vbn.n122 11.0491
R1277 vbn.n122 vbn.n121 11.0491
R1278 vbn.n121 vbn.n120 11.0491
R1279 vbn.n120 vbn.n119 11.0491
R1280 vbn.n119 vbn.n118 11.0491
R1281 vbn.n118 vbn.n117 11.0491
R1282 vbn.n117 vbn.n116 11.0491
R1283 vbn.n116 vbn.n115 11.0491
R1284 vbn.n115 vbn.n114 11.0491
R1285 vbn.n114 vbn.n113 11.0491
R1286 vbn.n113 vbn.n112 11.0491
R1287 vbn.n112 vbn.n111 11.0491
R1288 vbn.n111 vbn.n110 11.0491
R1289 vbn.n110 vbn.n109 11.0491
R1290 vbn.n109 vbn.n108 11.0491
R1291 vbn.n107 vbn.n106 11.0491
R1292 vbn.n106 vbn.n105 11.0491
R1293 vbn.n105 vbn.n104 11.0491
R1294 vbn.n104 vbn.n103 11.0491
R1295 vbn.n103 vbn.n102 11.0491
R1296 vbn.n102 vbn.n101 11.0491
R1297 vbn.n100 vbn.n99 11.0491
R1298 vbn.n99 vbn.n98 11.0491
R1299 vbn.n98 vbn.n97 11.0491
R1300 vbn.n97 vbn.n96 11.0491
R1301 vbn.n96 vbn.n95 11.0491
R1302 vbn.n95 vbn.n94 11.0491
R1303 vbn.n94 vbn.n93 11.0491
R1304 vbn.n93 vbn.n92 11.0491
R1305 vbn.n92 vbn.n91 11.0491
R1306 vbn.n91 vbn.n90 11.0491
R1307 vbn.n90 vbn.n89 11.0491
R1308 vbn.n89 vbn.n88 11.0491
R1309 vbn.n88 vbn.n87 11.0491
R1310 vbn.n88 vbn.n85 8.0005
R1311 vbn.n89 vbn.n84 8.0005
R1312 vbn.n90 vbn.n83 8.0005
R1313 vbn.n91 vbn.n82 8.0005
R1314 vbn.n92 vbn.n81 8.0005
R1315 vbn.n93 vbn.n80 8.0005
R1316 vbn.n94 vbn.n79 8.0005
R1317 vbn.n95 vbn.n78 8.0005
R1318 vbn.n96 vbn.n75 8.0005
R1319 vbn.n97 vbn.n74 8.0005
R1320 vbn.n98 vbn.n73 8.0005
R1321 vbn.n99 vbn.n72 8.0005
R1322 vbn.n100 vbn.n71 8.0005
R1323 vbn.n101 vbn.n69 8.0005
R1324 vbn.n102 vbn.n68 8.0005
R1325 vbn.n103 vbn.n65 8.0005
R1326 vbn.n104 vbn.n64 8.0005
R1327 vbn.n105 vbn.n61 8.0005
R1328 vbn.n106 vbn.n60 8.0005
R1329 vbn.n107 vbn.n57 8.0005
R1330 vbn.n108 vbn.n56 8.0005
R1331 vbn.n109 vbn.n55 8.0005
R1332 vbn.n110 vbn.n54 8.0005
R1333 vbn.n111 vbn.n53 8.0005
R1334 vbn.n112 vbn.n52 8.0005
R1335 vbn.n113 vbn.n51 8.0005
R1336 vbn.n114 vbn.n50 8.0005
R1337 vbn.n115 vbn.n49 8.0005
R1338 vbn.n116 vbn.n48 8.0005
R1339 vbn.n117 vbn.n47 8.0005
R1340 vbn.n118 vbn.n46 8.0005
R1341 vbn.n119 vbn.n45 8.0005
R1342 vbn.n120 vbn.n44 8.0005
R1343 vbn.n121 vbn.n43 8.0005
R1344 vbn.n122 vbn.n42 8.0005
R1345 vbn.n123 vbn.n41 8.0005
R1346 vbn.n124 vbn.n40 8.0005
R1347 vbn.n125 vbn.n39 8.0005
R1348 vbn.n126 vbn.n38 8.0005
R1349 vbn.n127 vbn.n37 8.0005
R1350 vbn.n128 vbn.n36 8.0005
R1351 vbn.n129 vbn.n35 8.0005
R1352 vbn.n130 vbn.n34 8.0005
R1353 vbn.n131 vbn.n33 8.0005
R1354 vbn.n132 vbn.n32 8.0005
R1355 vbn.n133 vbn.n31 8.0005
R1356 vbn.n134 vbn.n30 8.0005
R1357 vbn.n135 vbn.n29 8.0005
R1358 vbn.n136 vbn.n27 8.0005
R1359 vbn.n137 vbn.n26 8.0005
R1360 vbn.n138 vbn.n23 8.0005
R1361 vbn.n139 vbn.n22 8.0005
R1362 vbn.n140 vbn.n19 8.0005
R1363 vbn.n141 vbn.n18 8.0005
R1364 vbn.n142 vbn.n15 8.0005
R1365 vbn.n143 vbn.n14 8.0005
R1366 vbn.n144 vbn.n13 8.0005
R1367 vbn.n145 vbn.n12 8.0005
R1368 vbn.n146 vbn.n11 8.0005
R1369 vbn.n147 vbn.n10 8.0005
R1370 vbn.n148 vbn.n7 8.0005
R1371 vbn.n149 vbn.n6 8.0005
R1372 vbn.n150 vbn.n5 8.0005
R1373 vbn.n151 vbn.n4 8.0005
R1374 vbn.n152 vbn.n3 8.0005
R1375 vbn.n153 vbn.n2 8.0005
R1376 vbn.n154 vbn.n1 8.0005
R1377 vbn.n155 vbn.n0 8.0005
R1378 vbn.n157 vbn.n156 5.56684
R1379 vbn.n87 vbn.n86 5.56684
R1380 vbn.n158 vbn.t4 5.15158
R1381 vbn.n159 vbn.n158 4.69589
R1382 vbn.n70 vbn.t6 2.70867
R1383 vbn.n28 vbn.t20 2.70867
R1384 vbn.n67 vbn.n66 1.87392
R1385 vbn.n63 vbn.n62 1.87392
R1386 vbn.n59 vbn.n58 1.87392
R1387 vbn.n25 vbn.n24 1.87392
R1388 vbn.n21 vbn.n20 1.87392
R1389 vbn.n17 vbn.n16 1.87392
R1390 vbn.n158 vbn.n157 0.967396
R1391 vbn.n66 vbn.t10 0.8825
R1392 vbn.n66 vbn.t8 0.8825
R1393 vbn.n62 vbn.t14 0.8825
R1394 vbn.n62 vbn.t12 0.8825
R1395 vbn.n58 vbn.t18 0.8825
R1396 vbn.n58 vbn.t16 0.8825
R1397 vbn.n24 vbn.t24 0.8825
R1398 vbn.n24 vbn.t22 0.8825
R1399 vbn.n20 vbn.t28 0.8825
R1400 vbn.n20 vbn.t26 0.8825
R1401 vbn.n16 vbn.t32 0.8825
R1402 vbn.n16 vbn.t30 0.8825
R1403 vbn.n57 vbn.n56 0.73471
R1404 vbn.n15 vbn.n14 0.73471
R1405 vbn vbn.n159 0.656553
R1406 vbn.n71 vbn.n70 0.525799
R1407 vbn.n29 vbn.n28 0.525799
R1408 vbn.n86 vbn.n85 0.47793
R1409 vbn.n157 vbn.n0 0.47793
R1410 vbn.n72 vbn.n71 0.369974
R1411 vbn.n73 vbn.n72 0.369974
R1412 vbn.n74 vbn.n73 0.369974
R1413 vbn.n75 vbn.n74 0.369974
R1414 vbn.n79 vbn.n78 0.369974
R1415 vbn.n80 vbn.n79 0.369974
R1416 vbn.n81 vbn.n80 0.369974
R1417 vbn.n82 vbn.n81 0.369974
R1418 vbn.n83 vbn.n82 0.369974
R1419 vbn.n84 vbn.n83 0.369974
R1420 vbn.n85 vbn.n84 0.369974
R1421 vbn.n30 vbn.n29 0.369974
R1422 vbn.n31 vbn.n30 0.369974
R1423 vbn.n32 vbn.n31 0.369974
R1424 vbn.n33 vbn.n32 0.369974
R1425 vbn.n34 vbn.n33 0.369974
R1426 vbn.n35 vbn.n34 0.369974
R1427 vbn.n36 vbn.n35 0.369974
R1428 vbn.n37 vbn.n36 0.369974
R1429 vbn.n38 vbn.n37 0.369974
R1430 vbn.n39 vbn.n38 0.369974
R1431 vbn.n40 vbn.n39 0.369974
R1432 vbn.n41 vbn.n40 0.369974
R1433 vbn.n42 vbn.n41 0.369974
R1434 vbn.n43 vbn.n42 0.369974
R1435 vbn.n44 vbn.n43 0.369974
R1436 vbn.n45 vbn.n44 0.369974
R1437 vbn.n46 vbn.n45 0.369974
R1438 vbn.n47 vbn.n46 0.369974
R1439 vbn.n48 vbn.n47 0.369974
R1440 vbn.n49 vbn.n48 0.369974
R1441 vbn.n50 vbn.n49 0.369974
R1442 vbn.n51 vbn.n50 0.369974
R1443 vbn.n52 vbn.n51 0.369974
R1444 vbn.n53 vbn.n52 0.369974
R1445 vbn.n54 vbn.n53 0.369974
R1446 vbn.n55 vbn.n54 0.369974
R1447 vbn.n56 vbn.n55 0.369974
R1448 vbn.n1 vbn.n0 0.369974
R1449 vbn.n2 vbn.n1 0.369974
R1450 vbn.n3 vbn.n2 0.369974
R1451 vbn.n4 vbn.n3 0.369974
R1452 vbn.n5 vbn.n4 0.369974
R1453 vbn.n6 vbn.n5 0.369974
R1454 vbn.n7 vbn.n6 0.369974
R1455 vbn.n11 vbn.n10 0.369974
R1456 vbn.n12 vbn.n11 0.369974
R1457 vbn.n13 vbn.n12 0.369974
R1458 vbn.n14 vbn.n13 0.369974
R1459 vbn.n77 vbn.n75 0.194711
R1460 vbn.n10 vbn.n9 0.194711
R1461 vbn.n78 vbn.n77 0.175763
R1462 vbn.n9 vbn.n7 0.175763
R1463 vbn.n59 vbn.n57 0.15751
R1464 vbn.n17 vbn.n15 0.15751
R1465 vbn.n61 vbn.n60 0.142318
R1466 vbn.n65 vbn.n64 0.142318
R1467 vbn.n69 vbn.n68 0.142318
R1468 vbn.n19 vbn.n18 0.142318
R1469 vbn.n23 vbn.n22 0.142318
R1470 vbn.n27 vbn.n26 0.142318
R1471 vbn.n8 vbn.t1 0.1405
R1472 vbn.n8 vbn.t3 0.1405
R1473 vbn.n76 vbn.t2 0.1405
R1474 vbn.n76 vbn.t0 0.1405
R1475 vbn.n60 vbn.n59 0.0714091
R1476 vbn.n63 vbn.n61 0.0714091
R1477 vbn.n64 vbn.n63 0.0714091
R1478 vbn.n67 vbn.n65 0.0714091
R1479 vbn.n68 vbn.n67 0.0714091
R1480 vbn.n18 vbn.n17 0.0714091
R1481 vbn.n21 vbn.n19 0.0714091
R1482 vbn.n22 vbn.n21 0.0714091
R1483 vbn.n25 vbn.n23 0.0714091
R1484 vbn.n26 vbn.n25 0.0714091
R1485 vbn.n70 vbn.n69 0.0700455
R1486 vbn.n28 vbn.n27 0.0700455
R1487 VDD_LS.t20 VDD_LS.t13 754.851
R1488 VDD_LS.t4 VDD_LS.t2 691.359
R1489 VDD_LS.t13 VDD_LS.t22 604.938
R1490 VDD_LS.t23 VDD_LS.t0 578.484
R1491 VDD_LS.t11 VDD_LS.t15 559.083
R1492 VDD_LS.t15 VDD_LS.t20 446.209
R1493 VDD_LS.t19 VDD_LS.t11 410.935
R1494 VDD_LS.t17 VDD_LS.t4 410.935
R1495 VDD_LS.t2 VDD_LS.t10 410.935
R1496 VDD_LS.t8 VDD_LS.t23 410.935
R1497 VDD_LS.t6 VDD_LS.t17 148.149
R1498 VDD_LS.t10 VDD_LS.t25 148.149
R1499 VDD_LS.t25 VDD_LS.t8 148.149
R1500 VDD_LS.n19 VDD_LS.t6 112.876
R1501 VDD_LS.n19 VDD_LS.t19 35.2739
R1502 VDD_LS.n77 VDD_LS.n76 21.9053
R1503 VDD_LS.n103 VDD_LS.n102 21.9053
R1504 VDD_LS.n94 VDD_LS.n93 21.9053
R1505 VDD_LS.n114 VDD_LS.n45 21.9053
R1506 VDD_LS.n106 VDD_LS.n105 21.9053
R1507 VDD_LS.n86 VDD_LS.n64 19.7393
R1508 VDD_LS.n84 VDD_LS.n66 19.7393
R1509 VDD_LS.n129 VDD_LS.n128 19.7393
R1510 VDD_LS.n122 VDD_LS.n121 19.7393
R1511 VDD_LS.n71 VDD_LS.t31 17.9366
R1512 VDD_LS.n85 VDD_LS.t30 17.9366
R1513 VDD_LS.n60 VDD_LS.t29 17.9366
R1514 VDD_LS.n112 VDD_LS.t28 17.9366
R1515 VDD_LS.n41 VDD_LS.t27 17.9366
R1516 VDD_LS.n76 VDD_LS.n70 13.9053
R1517 VDD_LS.n71 VDD_LS.n70 13.9053
R1518 VDD_LS.n86 VDD_LS.n85 13.9053
R1519 VDD_LS.n85 VDD_LS.n84 13.9053
R1520 VDD_LS.n102 VDD_LS.n54 13.9053
R1521 VDD_LS.n60 VDD_LS.n54 13.9053
R1522 VDD_LS.n95 VDD_LS.n60 13.9053
R1523 VDD_LS.n95 VDD_LS.n94 13.9053
R1524 VDD_LS.n114 VDD_LS.n113 13.9053
R1525 VDD_LS.n113 VDD_LS.n112 13.9053
R1526 VDD_LS.n112 VDD_LS.n48 13.9053
R1527 VDD_LS.n105 VDD_LS.n48 13.9053
R1528 VDD_LS.n128 VDD_LS.n41 13.9053
R1529 VDD_LS.n121 VDD_LS.n41 13.9053
R1530 VDD_LS.n11 VDD_LS.t14 9.77177
R1531 VDD_LS.n121 VDD_LS.n44 8.0005
R1532 VDD_LS.n42 VDD_LS.n41 8.0005
R1533 VDD_LS.n128 VDD_LS.n127 8.0005
R1534 VDD_LS.n105 VDD_LS.n52 8.0005
R1535 VDD_LS.n50 VDD_LS.n48 8.0005
R1536 VDD_LS.n112 VDD_LS.n111 8.0005
R1537 VDD_LS.n113 VDD_LS.n47 8.0005
R1538 VDD_LS.n115 VDD_LS.n114 8.0005
R1539 VDD_LS.n94 VDD_LS.n59 8.0005
R1540 VDD_LS.n96 VDD_LS.n95 8.0005
R1541 VDD_LS.n60 VDD_LS.n58 8.0005
R1542 VDD_LS.n55 VDD_LS.n54 8.0005
R1543 VDD_LS.n102 VDD_LS.n101 8.0005
R1544 VDD_LS.n84 VDD_LS.n83 8.0005
R1545 VDD_LS.n85 VDD_LS.n65 8.0005
R1546 VDD_LS.n87 VDD_LS.n86 8.0005
R1547 VDD_LS.n76 VDD_LS.n75 8.0005
R1548 VDD_LS.n74 VDD_LS.n70 8.0005
R1549 VDD_LS.n73 VDD_LS.n71 5.68076
R1550 VDD_LS.n5 VDD_LS.t3 4.85686
R1551 VDD_LS.n130 VDD_LS.n129 4.67932
R1552 VDD_LS.n72 VDD_LS.n69 4.5005
R1553 VDD_LS.n78 VDD_LS.n68 4.5005
R1554 VDD_LS.n80 VDD_LS.n79 4.5005
R1555 VDD_LS.n82 VDD_LS.n81 4.5005
R1556 VDD_LS.n67 VDD_LS.n63 4.5005
R1557 VDD_LS.n89 VDD_LS.n88 4.5005
R1558 VDD_LS.n90 VDD_LS.n62 4.5005
R1559 VDD_LS.n92 VDD_LS.n91 4.5005
R1560 VDD_LS.n61 VDD_LS.n57 4.5005
R1561 VDD_LS.n98 VDD_LS.n97 4.5005
R1562 VDD_LS.n100 VDD_LS.n99 4.5005
R1563 VDD_LS.n56 VDD_LS.n53 4.5005
R1564 VDD_LS.n104 VDD_LS.n51 4.5005
R1565 VDD_LS.n108 VDD_LS.n107 4.5005
R1566 VDD_LS.n110 VDD_LS.n109 4.5005
R1567 VDD_LS.n49 VDD_LS.n46 4.5005
R1568 VDD_LS.n117 VDD_LS.n116 4.5005
R1569 VDD_LS.n119 VDD_LS.n118 4.5005
R1570 VDD_LS.n120 VDD_LS.n43 4.5005
R1571 VDD_LS.n124 VDD_LS.n123 4.5005
R1572 VDD_LS.n126 VDD_LS.n125 4.5005
R1573 VDD_LS.n40 VDD_LS.n0 4.5005
R1574 VDD_LS.n2 VDD_LS.t24 3.6455
R1575 VDD_LS.n25 VDD_LS.t5 3.6455
R1576 VDD_LS.n12 VDD_LS.t21 3.6455
R1577 VDD_LS.n32 VDD_LS.n4 3.31103
R1578 VDD_LS.n17 VDD_LS.t12 2.84379
R1579 VDD_LS VDD_LS.n130 2.61817
R1580 VDD_LS.n38 VDD_LS.t1 2.33908
R1581 VDD_LS.n10 VDD_LS.t16 1.98287
R1582 VDD_LS.n8 VDD_LS.n7 1.91629
R1583 VDD_LS.n4 VDD_LS.t26 1.63383
R1584 VDD_LS.n4 VDD_LS.t9 1.63383
R1585 VDD_LS.n73 VDD_LS.n72 1.62016
R1586 VDD_LS.n39 VDD_LS.n38 1.51494
R1587 VDD_LS.n14 VDD_LS.n13 1.5005
R1588 VDD_LS.n16 VDD_LS.n15 1.5005
R1589 VDD_LS.n18 VDD_LS.n9 1.5005
R1590 VDD_LS.n22 VDD_LS.n21 1.5005
R1591 VDD_LS.n24 VDD_LS.n23 1.5005
R1592 VDD_LS.n26 VDD_LS.n6 1.5005
R1593 VDD_LS.n28 VDD_LS.n27 1.5005
R1594 VDD_LS.n30 VDD_LS.n29 1.5005
R1595 VDD_LS.n31 VDD_LS.n3 1.5005
R1596 VDD_LS.n34 VDD_LS.n33 1.5005
R1597 VDD_LS.n36 VDD_LS.n35 1.5005
R1598 VDD_LS.n37 VDD_LS.n1 1.5005
R1599 VDD_LS.n7 VDD_LS.t7 0.9805
R1600 VDD_LS.n7 VDD_LS.t18 0.9805
R1601 VDD_LS.n130 VDD_LS.n39 0.719
R1602 VDD_LS.n14 VDD_LS.n11 0.386165
R1603 VDD_LS.n120 VDD_LS.n119 0.2255
R1604 VDD_LS.n92 VDD_LS.n62 0.2255
R1605 VDD_LS.n79 VDD_LS.n78 0.2255
R1606 VDD_LS.n125 VDD_LS.n0 0.2255
R1607 VDD_LS.n125 VDD_LS.n124 0.2255
R1608 VDD_LS.n124 VDD_LS.n43 0.2255
R1609 VDD_LS.n118 VDD_LS.n43 0.2255
R1610 VDD_LS.n118 VDD_LS.n117 0.2255
R1611 VDD_LS.n117 VDD_LS.n46 0.2255
R1612 VDD_LS.n109 VDD_LS.n46 0.2255
R1613 VDD_LS.n109 VDD_LS.n108 0.2255
R1614 VDD_LS.n108 VDD_LS.n51 0.2255
R1615 VDD_LS.n56 VDD_LS.n51 0.2255
R1616 VDD_LS.n99 VDD_LS.n56 0.2255
R1617 VDD_LS.n99 VDD_LS.n98 0.2255
R1618 VDD_LS.n98 VDD_LS.n57 0.2255
R1619 VDD_LS.n91 VDD_LS.n57 0.2255
R1620 VDD_LS.n91 VDD_LS.n90 0.2255
R1621 VDD_LS.n90 VDD_LS.n89 0.2255
R1622 VDD_LS.n89 VDD_LS.n63 0.2255
R1623 VDD_LS.n81 VDD_LS.n63 0.2255
R1624 VDD_LS.n81 VDD_LS.n80 0.2255
R1625 VDD_LS.n80 VDD_LS.n68 0.2255
R1626 VDD_LS.n72 VDD_LS.n68 0.2255
R1627 VDD_LS.n130 VDD_LS.n0 0.21875
R1628 VDD_LS.n104 VDD_LS.n103 0.206375
R1629 VDD_LS.n106 VDD_LS.n104 0.172625
R1630 VDD_LS.n20 VDD_LS.n19 0.162038
R1631 VDD_LS.n74 VDD_LS.n73 0.148883
R1632 VDD_LS.n79 VDD_LS.n66 0.145566
R1633 VDD_LS.n119 VDD_LS.n45 0.143375
R1634 VDD_LS.n64 VDD_LS.n62 0.143316
R1635 VDD_LS.n44 VDD_LS.n42 0.1355
R1636 VDD_LS.n115 VDD_LS.n47 0.1355
R1637 VDD_LS.n52 VDD_LS.n50 0.1355
R1638 VDD_LS.n58 VDD_LS.n55 0.1355
R1639 VDD_LS.n96 VDD_LS.n59 0.1355
R1640 VDD_LS.n87 VDD_LS.n65 0.1355
R1641 VDD_LS.n75 VDD_LS.n74 0.1355
R1642 VDD_LS.n83 VDD_LS.n67 0.134375
R1643 VDD_LS.n111 VDD_LS.n110 0.127625
R1644 VDD_LS.n127 VDD_LS.n40 0.125375
R1645 VDD_LS.n77 VDD_LS.n69 0.118625
R1646 VDD_LS.n123 VDD_LS.n122 0.116827
R1647 VDD_LS.n101 VDD_LS.n53 0.116375
R1648 VDD_LS.n93 VDD_LS.n61 0.116375
R1649 VDD_LS.n12 VDD_LS.n11 0.109999
R1650 VDD_LS.n101 VDD_LS.n100 0.109625
R1651 VDD_LS.n93 VDD_LS.n92 0.109625
R1652 VDD_LS.n122 VDD_LS.n120 0.109566
R1653 VDD_LS.n78 VDD_LS.n77 0.107375
R1654 VDD_LS.n127 VDD_LS.n126 0.100625
R1655 VDD_LS.n111 VDD_LS.n49 0.098375
R1656 VDD_LS.n83 VDD_LS.n82 0.091625
R1657 VDD_LS.n88 VDD_LS.n87 0.089375
R1658 VDD_LS.n88 VDD_LS.n64 0.0830773
R1659 VDD_LS.n116 VDD_LS.n45 0.082625
R1660 VDD_LS.n107 VDD_LS.n52 0.082625
R1661 VDD_LS.n82 VDD_LS.n66 0.0808273
R1662 VDD_LS.n27 VDD_LS.n26 0.0755
R1663 VDD_LS.n31 VDD_LS.n30 0.0755
R1664 VDD_LS.n37 VDD_LS.n36 0.0755
R1665 VDD_LS.n15 VDD_LS.n14 0.0755
R1666 VDD_LS.n15 VDD_LS.n9 0.0755
R1667 VDD_LS.n22 VDD_LS.n9 0.0755
R1668 VDD_LS.n23 VDD_LS.n22 0.0755
R1669 VDD_LS.n23 VDD_LS.n6 0.0755
R1670 VDD_LS.n28 VDD_LS.n6 0.0755
R1671 VDD_LS.n29 VDD_LS.n28 0.0755
R1672 VDD_LS.n29 VDD_LS.n3 0.0755
R1673 VDD_LS.n34 VDD_LS.n3 0.0755
R1674 VDD_LS.n35 VDD_LS.n34 0.0755
R1675 VDD_LS.n35 VDD_LS.n1 0.0755
R1676 VDD_LS.n39 VDD_LS.n1 0.0755
R1677 VDD_LS.n27 VDD_LS.n5 0.0753125
R1678 VDD_LS.n13 VDD_LS.n12 0.0741875
R1679 VDD_LS.n97 VDD_LS.n96 0.071375
R1680 VDD_LS.n20 VDD_LS.n18 0.07025
R1681 VDD_LS.n17 VDD_LS.n16 0.0655625
R1682 VDD_LS.n97 VDD_LS.n58 0.064625
R1683 VDD_LS.n38 VDD_LS.n37 0.0610625
R1684 VDD_LS.n33 VDD_LS.n2 0.0576875
R1685 VDD_LS.n123 VDD_LS.n44 0.055625
R1686 VDD_LS.n16 VDD_LS.n10 0.0543125
R1687 VDD_LS.n116 VDD_LS.n115 0.053375
R1688 VDD_LS.n107 VDD_LS.n106 0.053375
R1689 VDD_LS.n25 VDD_LS.n24 0.0479375
R1690 VDD_LS.n129 VDD_LS.n40 0.0470773
R1691 VDD_LS.n32 VDD_LS.n31 0.04475
R1692 VDD_LS.n24 VDD_LS.n8 0.041
R1693 VDD_LS.n49 VDD_LS.n47 0.037625
R1694 VDD_LS.n126 VDD_LS.n42 0.035375
R1695 VDD_LS.n21 VDD_LS.n8 0.035
R1696 VDD_LS.n33 VDD_LS.n32 0.03125
R1697 VDD_LS.n26 VDD_LS.n25 0.0280625
R1698 VDD_LS.n100 VDD_LS.n55 0.026375
R1699 VDD_LS.n13 VDD_LS.n10 0.0216875
R1700 VDD_LS.n103 VDD_LS.n53 0.019625
R1701 VDD_LS.n61 VDD_LS.n59 0.019625
R1702 VDD_LS.n36 VDD_LS.n2 0.0183125
R1703 VDD_LS.n75 VDD_LS.n69 0.017375
R1704 VDD_LS.n18 VDD_LS.n17 0.0104375
R1705 VDD_LS.n110 VDD_LS.n50 0.008375
R1706 VDD_LS.n21 VDD_LS.n20 0.00575
R1707 VDD_LS.n67 VDD_LS.n65 0.001625
R1708 VDD_LS.n30 VDD_LS.n5 0.0006875
R1709 VDD.t20 VDD.n285 1326.26
R1710 VDD.n283 VDD.n275 943.674
R1711 VDD.n285 VDD.t22 903.912
R1712 VDD.t14 VDD.t16 877.638
R1713 VDD.t12 VDD.t14 877.638
R1714 VDD.t10 VDD.t12 877.638
R1715 VDD.t8 VDD.t6 877.638
R1716 VDD.t6 VDD.t4 877.638
R1717 VDD.t4 VDD.t2 877.638
R1718 VDD.t16 VDD.t24 608.198
R1719 VDD.n159 VDD.t8 525.919
R1720 VDD.t42 VDD.t23 413.409
R1721 VDD.t18 VDD.t42 413.409
R1722 VDD.t19 VDD.t18 413.409
R1723 VDD.t22 VDD.t19 413.409
R1724 VDD.n281 VDD.n280 410.329
R1725 VDD.n287 VDD.n280 410.329
R1726 VDD.n159 VDD.t10 351.719
R1727 VDD.t26 VDD.t0 335.197
R1728 VDD.t0 VDD.t43 324.022
R1729 VDD.t40 VDD.t20 290.503
R1730 VDD.t43 VDD.t40 290.503
R1731 VDD.t23 VDD.n284 207.821
R1732 VDD.n286 VDD.t26 198.883
R1733 VDD.t36 VDD.t38 149.046
R1734 VDD.t34 VDD.t36 149.046
R1735 VDD.t32 VDD.t30 149.046
R1736 VDD.t30 VDD.t28 149.046
R1737 VDD.n262 VDD.t34 74.5228
R1738 VDD.n262 VDD.t32 74.5228
R1739 VDD.n309 VDD.n308 10.4634
R1740 VDD.n81 VDD.t25 9.75958
R1741 VDD.n308 VDD.n307 9.56345
R1742 VDD.n287 VDD.n286 6.3005
R1743 VDD.n284 VDD.n281 6.3005
R1744 VDD.n288 VDD.n287 5.69302
R1745 VDD.n282 VDD.n281 5.69302
R1746 VDD.n348 VDD.n329 4.5005
R1747 VDD.n348 VDD.n249 4.5005
R1748 VDD.n334 VDD.n249 4.5005
R1749 VDD.n346 VDD.n249 4.5005
R1750 VDD.n342 VDD.n249 4.5005
R1751 VDD.n348 VDD.n331 4.5005
R1752 VDD.n334 VDD.n331 4.5005
R1753 VDD.n346 VDD.n331 4.5005
R1754 VDD.n342 VDD.n331 4.5005
R1755 VDD.n348 VDD.n248 4.5005
R1756 VDD.n334 VDD.n248 4.5005
R1757 VDD.n346 VDD.n248 4.5005
R1758 VDD.n342 VDD.n248 4.5005
R1759 VDD.n348 VDD.n347 4.5005
R1760 VDD.n347 VDD.n334 4.5005
R1761 VDD.n347 VDD.n346 4.5005
R1762 VDD.n266 VDD.n258 3.70672
R1763 VDD.n261 VDD.n259 3.70672
R1764 VDD.n265 VDD.n263 3.70672
R1765 VDD.n261 VDD.n260 2.71269
R1766 VDD.n265 VDD.n264 2.71269
R1767 VDD.n343 VDD.n342 2.24729
R1768 VDD.n341 VDD.n340 2.24729
R1769 VDD.n338 VDD.n337 2.24729
R1770 VDD.n340 VDD.n339 2.24729
R1771 VDD.n338 VDD.n333 2.24729
R1772 VDD.n347 VDD.n332 2.24721
R1773 VDD.n336 VDD.n329 2.24721
R1774 VDD.n335 VDD.n329 2.24721
R1775 VDD.n344 VDD.n330 2.24721
R1776 VDD.n345 VDD.n344 2.24721
R1777 VDD VDD.n247 2.22073
R1778 VDD.n245 VDD.t3 2.10633
R1779 VDD.n85 VDD.t17 2.10633
R1780 VDD.n19 VDD.n18 1.97383
R1781 VDD.n40 VDD.n39 1.97383
R1782 VDD.n126 VDD.n60 1.97383
R1783 VDD.n290 VDD.t27 1.71571
R1784 VDD.n273 VDD.t1 1.71571
R1785 VDD.n296 VDD.t44 1.71571
R1786 VDD.n298 VDD.t41 1.71571
R1787 VDD.n272 VDD.t21 1.71571
R1788 VDD.n246 VDD.n245 1.54681
R1789 VDD.n291 VDD.n274 1.5005
R1790 VDD.n293 VDD.n292 1.5005
R1791 VDD.n295 VDD.n294 1.5005
R1792 VDD.n297 VDD.n271 1.5005
R1793 VDD.n300 VDD.n299 1.5005
R1794 VDD.n301 VDD.n270 1.5005
R1795 VDD.n303 VDD.n302 1.5005
R1796 VDD.n304 VDD.n268 1.5005
R1797 VDD.n306 VDD.n305 1.5005
R1798 VDD.n269 VDD.n267 1.5005
R1799 VDD.n278 VDD.n277 1.5005
R1800 VDD.n276 VDD.n257 1.5005
R1801 VDD.n310 VDD.n256 1.5005
R1802 VDD.n312 VDD.n311 1.5005
R1803 VDD.n313 VDD.n255 1.5005
R1804 VDD.n315 VDD.n314 1.5005
R1805 VDD.n316 VDD.n254 1.5005
R1806 VDD.n318 VDD.n317 1.5005
R1807 VDD.n319 VDD.n253 1.5005
R1808 VDD.n321 VDD.n320 1.5005
R1809 VDD.n322 VDD.n252 1.5005
R1810 VDD.n324 VDD.n323 1.5005
R1811 VDD.n325 VDD.n251 1.5005
R1812 VDD.n327 VDD.n326 1.5005
R1813 VDD.n244 VDD.n1 1.5005
R1814 VDD.n243 VDD.n242 1.5005
R1815 VDD.n3 VDD.n2 1.5005
R1816 VDD.n236 VDD.n235 1.5005
R1817 VDD.n234 VDD.n233 1.5005
R1818 VDD.n7 VDD.n6 1.5005
R1819 VDD.n228 VDD.n227 1.5005
R1820 VDD.n226 VDD.n225 1.5005
R1821 VDD.n11 VDD.n10 1.5005
R1822 VDD.n220 VDD.n219 1.5005
R1823 VDD.n218 VDD.n217 1.5005
R1824 VDD.n15 VDD.n14 1.5005
R1825 VDD.n212 VDD.n211 1.5005
R1826 VDD.n210 VDD.n209 1.5005
R1827 VDD.n202 VDD.n20 1.5005
R1828 VDD.n204 VDD.n203 1.5005
R1829 VDD.n201 VDD.n200 1.5005
R1830 VDD.n24 VDD.n23 1.5005
R1831 VDD.n195 VDD.n194 1.5005
R1832 VDD.n193 VDD.n192 1.5005
R1833 VDD.n28 VDD.n27 1.5005
R1834 VDD.n187 VDD.n186 1.5005
R1835 VDD.n185 VDD.n184 1.5005
R1836 VDD.n32 VDD.n31 1.5005
R1837 VDD.n179 VDD.n178 1.5005
R1838 VDD.n177 VDD.n176 1.5005
R1839 VDD.n36 VDD.n35 1.5005
R1840 VDD.n171 VDD.n170 1.5005
R1841 VDD.n169 VDD.n168 1.5005
R1842 VDD.n161 VDD.n41 1.5005
R1843 VDD.n163 VDD.n162 1.5005
R1844 VDD.n158 VDD.n157 1.5005
R1845 VDD.n45 VDD.n44 1.5005
R1846 VDD.n152 VDD.n151 1.5005
R1847 VDD.n150 VDD.n149 1.5005
R1848 VDD.n49 VDD.n48 1.5005
R1849 VDD.n144 VDD.n143 1.5005
R1850 VDD.n142 VDD.n141 1.5005
R1851 VDD.n53 VDD.n52 1.5005
R1852 VDD.n136 VDD.n135 1.5005
R1853 VDD.n134 VDD.n133 1.5005
R1854 VDD.n57 VDD.n56 1.5005
R1855 VDD.n128 VDD.n127 1.5005
R1856 VDD.n125 VDD.n124 1.5005
R1857 VDD.n62 VDD.n61 1.5005
R1858 VDD.n119 VDD.n118 1.5005
R1859 VDD.n117 VDD.n116 1.5005
R1860 VDD.n66 VDD.n65 1.5005
R1861 VDD.n111 VDD.n110 1.5005
R1862 VDD.n109 VDD.n108 1.5005
R1863 VDD.n70 VDD.n69 1.5005
R1864 VDD.n103 VDD.n102 1.5005
R1865 VDD.n101 VDD.n100 1.5005
R1866 VDD.n74 VDD.n73 1.5005
R1867 VDD.n95 VDD.n94 1.5005
R1868 VDD.n93 VDD.n92 1.5005
R1869 VDD.n78 VDD.n77 1.5005
R1870 VDD.n87 VDD.n86 1.5005
R1871 VDD.n84 VDD.n83 1.5005
R1872 VDD.n308 VDD.n266 1.16382
R1873 VDD.n247 VDD.n246 1.1255
R1874 VDD.n241 VDD.n0 1.1255
R1875 VDD.n240 VDD.n239 1.1255
R1876 VDD.n238 VDD.n237 1.1255
R1877 VDD.n5 VDD.n4 1.1255
R1878 VDD.n232 VDD.n231 1.1255
R1879 VDD.n230 VDD.n229 1.1255
R1880 VDD.n9 VDD.n8 1.1255
R1881 VDD.n224 VDD.n223 1.1255
R1882 VDD.n222 VDD.n221 1.1255
R1883 VDD.n13 VDD.n12 1.1255
R1884 VDD.n216 VDD.n215 1.1255
R1885 VDD.n214 VDD.n213 1.1255
R1886 VDD.n17 VDD.n16 1.1255
R1887 VDD.n208 VDD.n207 1.1255
R1888 VDD.n206 VDD.n205 1.1255
R1889 VDD.n22 VDD.n21 1.1255
R1890 VDD.n199 VDD.n198 1.1255
R1891 VDD.n197 VDD.n196 1.1255
R1892 VDD.n26 VDD.n25 1.1255
R1893 VDD.n191 VDD.n190 1.1255
R1894 VDD.n189 VDD.n188 1.1255
R1895 VDD.n30 VDD.n29 1.1255
R1896 VDD.n183 VDD.n182 1.1255
R1897 VDD.n181 VDD.n180 1.1255
R1898 VDD.n34 VDD.n33 1.1255
R1899 VDD.n175 VDD.n174 1.1255
R1900 VDD.n173 VDD.n172 1.1255
R1901 VDD.n38 VDD.n37 1.1255
R1902 VDD.n167 VDD.n166 1.1255
R1903 VDD.n165 VDD.n164 1.1255
R1904 VDD.n43 VDD.n42 1.1255
R1905 VDD.n156 VDD.n155 1.1255
R1906 VDD.n154 VDD.n153 1.1255
R1907 VDD.n47 VDD.n46 1.1255
R1908 VDD.n148 VDD.n147 1.1255
R1909 VDD.n146 VDD.n145 1.1255
R1910 VDD.n51 VDD.n50 1.1255
R1911 VDD.n140 VDD.n139 1.1255
R1912 VDD.n138 VDD.n137 1.1255
R1913 VDD.n55 VDD.n54 1.1255
R1914 VDD.n132 VDD.n131 1.1255
R1915 VDD.n130 VDD.n129 1.1255
R1916 VDD.n59 VDD.n58 1.1255
R1917 VDD.n123 VDD.n122 1.1255
R1918 VDD.n121 VDD.n120 1.1255
R1919 VDD.n64 VDD.n63 1.1255
R1920 VDD.n115 VDD.n114 1.1255
R1921 VDD.n113 VDD.n112 1.1255
R1922 VDD.n68 VDD.n67 1.1255
R1923 VDD.n107 VDD.n106 1.1255
R1924 VDD.n105 VDD.n104 1.1255
R1925 VDD.n72 VDD.n71 1.1255
R1926 VDD.n99 VDD.n98 1.1255
R1927 VDD.n97 VDD.n96 1.1255
R1928 VDD.n76 VDD.n75 1.1255
R1929 VDD.n91 VDD.n90 1.1255
R1930 VDD.n89 VDD.n88 1.1255
R1931 VDD.n80 VDD.n79 1.1255
R1932 VDD.n283 VDD.n282 0.996766
R1933 VDD.n288 VDD.n275 0.996766
R1934 VDD.n289 VDD.n274 0.841357
R1935 VDD.n82 VDD.n81 0.815776
R1936 VDD.n266 VDD.n261 0.7025
R1937 VDD.n266 VDD.n265 0.7025
R1938 VDD.n82 VDD.n79 0.611805
R1939 VDD VDD.n348 0.590155
R1940 VDD.n329 VDD.n328 0.531368
R1941 VDD.n284 VDD.n283 0.371088
R1942 VDD.n286 VDD.n275 0.371088
R1943 VDD.n328 VDD.n250 0.330685
R1944 VDD.n328 VDD.n327 0.215738
R1945 VDD.n266 VDD.n262 0.207057
R1946 VDD.n18 VDD.t7 0.1405
R1947 VDD.n18 VDD.t5 0.1405
R1948 VDD.n39 VDD.t11 0.1405
R1949 VDD.n39 VDD.t9 0.1405
R1950 VDD.n60 VDD.t15 0.1405
R1951 VDD.n60 VDD.t13 0.1405
R1952 VDD.n289 VDD.n288 0.113837
R1953 VDD.n260 VDD.t37 0.0962905
R1954 VDD.n264 VDD.t31 0.0962905
R1955 VDD.n282 VDD.n250 0.0915242
R1956 VDD.n327 VDD.n251 0.0755
R1957 VDD.n323 VDD.n251 0.0755
R1958 VDD.n323 VDD.n322 0.0755
R1959 VDD.n322 VDD.n321 0.0755
R1960 VDD.n321 VDD.n253 0.0755
R1961 VDD.n317 VDD.n253 0.0755
R1962 VDD.n317 VDD.n316 0.0755
R1963 VDD.n316 VDD.n315 0.0755
R1964 VDD.n315 VDD.n255 0.0755
R1965 VDD.n311 VDD.n255 0.0755
R1966 VDD.n311 VDD.n310 0.0755
R1967 VDD.n277 VDD.n257 0.0755
R1968 VDD.n277 VDD.n267 0.0755
R1969 VDD.n306 VDD.n268 0.0755
R1970 VDD.n302 VDD.n268 0.0755
R1971 VDD.n302 VDD.n301 0.0755
R1972 VDD.n301 VDD.n300 0.0755
R1973 VDD.n300 VDD.n271 0.0755
R1974 VDD.n294 VDD.n271 0.0755
R1975 VDD.n294 VDD.n293 0.0755
R1976 VDD.n293 VDD.n274 0.0755
R1977 VDD.n326 VDD.n325 0.0755
R1978 VDD.n325 VDD.n324 0.0755
R1979 VDD.n324 VDD.n252 0.0755
R1980 VDD.n320 VDD.n252 0.0755
R1981 VDD.n320 VDD.n319 0.0755
R1982 VDD.n319 VDD.n318 0.0755
R1983 VDD.n318 VDD.n254 0.0755
R1984 VDD.n314 VDD.n254 0.0755
R1985 VDD.n314 VDD.n313 0.0755
R1986 VDD.n313 VDD.n312 0.0755
R1987 VDD.n312 VDD.n256 0.0755
R1988 VDD.n276 VDD.n256 0.0755
R1989 VDD.n278 VDD.n269 0.0755
R1990 VDD.n305 VDD.n269 0.0755
R1991 VDD.n305 VDD.n304 0.0755
R1992 VDD.n304 VDD.n303 0.0755
R1993 VDD.n303 VDD.n270 0.0755
R1994 VDD.n292 VDD.n291 0.0755
R1995 VDD.n86 VDD.n77 0.0755
R1996 VDD.n93 VDD.n77 0.0755
R1997 VDD.n94 VDD.n93 0.0755
R1998 VDD.n94 VDD.n73 0.0755
R1999 VDD.n101 VDD.n73 0.0755
R2000 VDD.n102 VDD.n101 0.0755
R2001 VDD.n102 VDD.n69 0.0755
R2002 VDD.n109 VDD.n69 0.0755
R2003 VDD.n110 VDD.n109 0.0755
R2004 VDD.n110 VDD.n65 0.0755
R2005 VDD.n117 VDD.n65 0.0755
R2006 VDD.n118 VDD.n117 0.0755
R2007 VDD.n118 VDD.n61 0.0755
R2008 VDD.n125 VDD.n61 0.0755
R2009 VDD.n127 VDD.n56 0.0755
R2010 VDD.n134 VDD.n56 0.0755
R2011 VDD.n135 VDD.n134 0.0755
R2012 VDD.n135 VDD.n52 0.0755
R2013 VDD.n142 VDD.n52 0.0755
R2014 VDD.n143 VDD.n142 0.0755
R2015 VDD.n143 VDD.n48 0.0755
R2016 VDD.n150 VDD.n48 0.0755
R2017 VDD.n151 VDD.n150 0.0755
R2018 VDD.n151 VDD.n44 0.0755
R2019 VDD.n158 VDD.n44 0.0755
R2020 VDD.n162 VDD.n158 0.0755
R2021 VDD.n162 VDD.n161 0.0755
R2022 VDD.n170 VDD.n169 0.0755
R2023 VDD.n170 VDD.n35 0.0755
R2024 VDD.n177 VDD.n35 0.0755
R2025 VDD.n178 VDD.n177 0.0755
R2026 VDD.n178 VDD.n31 0.0755
R2027 VDD.n185 VDD.n31 0.0755
R2028 VDD.n186 VDD.n185 0.0755
R2029 VDD.n186 VDD.n27 0.0755
R2030 VDD.n193 VDD.n27 0.0755
R2031 VDD.n194 VDD.n193 0.0755
R2032 VDD.n194 VDD.n23 0.0755
R2033 VDD.n201 VDD.n23 0.0755
R2034 VDD.n203 VDD.n201 0.0755
R2035 VDD.n203 VDD.n202 0.0755
R2036 VDD.n211 VDD.n210 0.0755
R2037 VDD.n211 VDD.n14 0.0755
R2038 VDD.n218 VDD.n14 0.0755
R2039 VDD.n219 VDD.n218 0.0755
R2040 VDD.n219 VDD.n10 0.0755
R2041 VDD.n226 VDD.n10 0.0755
R2042 VDD.n227 VDD.n226 0.0755
R2043 VDD.n227 VDD.n6 0.0755
R2044 VDD.n234 VDD.n6 0.0755
R2045 VDD.n235 VDD.n234 0.0755
R2046 VDD.n235 VDD.n2 0.0755
R2047 VDD.n243 VDD.n2 0.0755
R2048 VDD.n244 VDD.n243 0.0755
R2049 VDD.n295 VDD.n273 0.0738125
R2050 VDD.n309 VDD.n257 0.07325
R2051 VDD.n307 VDD.n306 0.07325
R2052 VDD.n297 VDD.n296 0.0704375
R2053 VDD.n291 VDD.n290 0.0666875
R2054 VDD.n245 VDD.n244 0.0666875
R2055 VDD.t35 VDD.n258 0.0662277
R2056 VDD.t33 VDD.n258 0.0662277
R2057 VDD.t37 VDD.n259 0.0662277
R2058 VDD.n259 VDD.t35 0.0662277
R2059 VDD.n263 VDD.t33 0.0662277
R2060 VDD.t31 VDD.n263 0.0662277
R2061 VDD.n83 VDD.n82 0.0649974
R2062 VDD.n280 VDD.n279 0.0610769
R2063 VDD.n285 VDD.n280 0.0610769
R2064 VDD.n279 VDD.n278 0.060875
R2065 VDD.n127 VDD.n126 0.05975
R2066 VDD.n84 VDD.n81 0.057125
R2067 VDD.n160 VDD.n40 0.0546875
R2068 VDD.n210 VDD.n19 0.05075
R2069 VDD.n299 VDD.n272 0.0505625
R2070 VDD.n85 VDD.n84 0.0498125
R2071 VDD.n160 VDD.n159 0.0497188
R2072 VDD.n299 VDD.n298 0.0479375
R2073 VDD.n89 VDD.n79 0.046477
R2074 VDD.n90 VDD.n89 0.046477
R2075 VDD.n90 VDD.n75 0.046477
R2076 VDD.n97 VDD.n75 0.046477
R2077 VDD.n98 VDD.n97 0.046477
R2078 VDD.n98 VDD.n71 0.046477
R2079 VDD.n105 VDD.n71 0.046477
R2080 VDD.n106 VDD.n105 0.046477
R2081 VDD.n106 VDD.n67 0.046477
R2082 VDD.n113 VDD.n67 0.046477
R2083 VDD.n114 VDD.n113 0.046477
R2084 VDD.n114 VDD.n63 0.046477
R2085 VDD.n121 VDD.n63 0.046477
R2086 VDD.n122 VDD.n121 0.046477
R2087 VDD.n122 VDD.n58 0.046477
R2088 VDD.n130 VDD.n58 0.046477
R2089 VDD.n131 VDD.n130 0.046477
R2090 VDD.n131 VDD.n54 0.046477
R2091 VDD.n138 VDD.n54 0.046477
R2092 VDD.n139 VDD.n138 0.046477
R2093 VDD.n139 VDD.n50 0.046477
R2094 VDD.n146 VDD.n50 0.046477
R2095 VDD.n147 VDD.n146 0.046477
R2096 VDD.n147 VDD.n46 0.046477
R2097 VDD.n154 VDD.n46 0.046477
R2098 VDD.n155 VDD.n154 0.046477
R2099 VDD.n155 VDD.n42 0.046477
R2100 VDD.n165 VDD.n42 0.046477
R2101 VDD.n166 VDD.n165 0.046477
R2102 VDD.n166 VDD.n37 0.046477
R2103 VDD.n173 VDD.n37 0.046477
R2104 VDD.n174 VDD.n173 0.046477
R2105 VDD.n174 VDD.n33 0.046477
R2106 VDD.n181 VDD.n33 0.046477
R2107 VDD.n182 VDD.n181 0.046477
R2108 VDD.n182 VDD.n29 0.046477
R2109 VDD.n189 VDD.n29 0.046477
R2110 VDD.n190 VDD.n189 0.046477
R2111 VDD.n190 VDD.n25 0.046477
R2112 VDD.n197 VDD.n25 0.046477
R2113 VDD.n198 VDD.n197 0.046477
R2114 VDD.n198 VDD.n21 0.046477
R2115 VDD.n206 VDD.n21 0.046477
R2116 VDD.n207 VDD.n206 0.046477
R2117 VDD.n207 VDD.n16 0.046477
R2118 VDD.n214 VDD.n16 0.046477
R2119 VDD.n215 VDD.n214 0.046477
R2120 VDD.n215 VDD.n12 0.046477
R2121 VDD.n222 VDD.n12 0.046477
R2122 VDD.n223 VDD.n222 0.046477
R2123 VDD.n223 VDD.n8 0.046477
R2124 VDD.n230 VDD.n8 0.046477
R2125 VDD.n231 VDD.n230 0.046477
R2126 VDD.n231 VDD.n4 0.046477
R2127 VDD.n238 VDD.n4 0.046477
R2128 VDD.n239 VDD.n238 0.046477
R2129 VDD.n239 VDD.n0 0.046477
R2130 VDD.n247 VDD.n0 0.046477
R2131 VDD.n83 VDD.n80 0.038
R2132 VDD.n87 VDD.n80 0.038
R2133 VDD.n88 VDD.n87 0.038
R2134 VDD.n88 VDD.n78 0.038
R2135 VDD.n91 VDD.n78 0.038
R2136 VDD.n92 VDD.n91 0.038
R2137 VDD.n92 VDD.n76 0.038
R2138 VDD.n95 VDD.n76 0.038
R2139 VDD.n96 VDD.n95 0.038
R2140 VDD.n96 VDD.n74 0.038
R2141 VDD.n99 VDD.n74 0.038
R2142 VDD.n100 VDD.n99 0.038
R2143 VDD.n100 VDD.n72 0.038
R2144 VDD.n103 VDD.n72 0.038
R2145 VDD.n104 VDD.n103 0.038
R2146 VDD.n104 VDD.n70 0.038
R2147 VDD.n107 VDD.n70 0.038
R2148 VDD.n108 VDD.n107 0.038
R2149 VDD.n108 VDD.n68 0.038
R2150 VDD.n111 VDD.n68 0.038
R2151 VDD.n112 VDD.n111 0.038
R2152 VDD.n112 VDD.n66 0.038
R2153 VDD.n115 VDD.n66 0.038
R2154 VDD.n116 VDD.n115 0.038
R2155 VDD.n116 VDD.n64 0.038
R2156 VDD.n119 VDD.n64 0.038
R2157 VDD.n120 VDD.n119 0.038
R2158 VDD.n120 VDD.n62 0.038
R2159 VDD.n123 VDD.n62 0.038
R2160 VDD.n124 VDD.n123 0.038
R2161 VDD.n124 VDD.n59 0.038
R2162 VDD.n128 VDD.n59 0.038
R2163 VDD.n129 VDD.n128 0.038
R2164 VDD.n129 VDD.n57 0.038
R2165 VDD.n132 VDD.n57 0.038
R2166 VDD.n133 VDD.n132 0.038
R2167 VDD.n133 VDD.n55 0.038
R2168 VDD.n136 VDD.n55 0.038
R2169 VDD.n137 VDD.n136 0.038
R2170 VDD.n137 VDD.n53 0.038
R2171 VDD.n140 VDD.n53 0.038
R2172 VDD.n141 VDD.n140 0.038
R2173 VDD.n141 VDD.n51 0.038
R2174 VDD.n144 VDD.n51 0.038
R2175 VDD.n145 VDD.n144 0.038
R2176 VDD.n145 VDD.n49 0.038
R2177 VDD.n148 VDD.n49 0.038
R2178 VDD.n149 VDD.n148 0.038
R2179 VDD.n149 VDD.n47 0.038
R2180 VDD.n152 VDD.n47 0.038
R2181 VDD.n153 VDD.n152 0.038
R2182 VDD.n153 VDD.n45 0.038
R2183 VDD.n156 VDD.n45 0.038
R2184 VDD.n157 VDD.n156 0.038
R2185 VDD.n157 VDD.n43 0.038
R2186 VDD.n163 VDD.n43 0.038
R2187 VDD.n164 VDD.n163 0.038
R2188 VDD.n164 VDD.n41 0.038
R2189 VDD.n167 VDD.n41 0.038
R2190 VDD.n168 VDD.n167 0.038
R2191 VDD.n168 VDD.n38 0.038
R2192 VDD.n171 VDD.n38 0.038
R2193 VDD.n172 VDD.n171 0.038
R2194 VDD.n172 VDD.n36 0.038
R2195 VDD.n175 VDD.n36 0.038
R2196 VDD.n176 VDD.n175 0.038
R2197 VDD.n176 VDD.n34 0.038
R2198 VDD.n179 VDD.n34 0.038
R2199 VDD.n180 VDD.n179 0.038
R2200 VDD.n180 VDD.n32 0.038
R2201 VDD.n183 VDD.n32 0.038
R2202 VDD.n184 VDD.n183 0.038
R2203 VDD.n184 VDD.n30 0.038
R2204 VDD.n187 VDD.n30 0.038
R2205 VDD.n188 VDD.n187 0.038
R2206 VDD.n188 VDD.n28 0.038
R2207 VDD.n191 VDD.n28 0.038
R2208 VDD.n192 VDD.n191 0.038
R2209 VDD.n192 VDD.n26 0.038
R2210 VDD.n195 VDD.n26 0.038
R2211 VDD.n196 VDD.n195 0.038
R2212 VDD.n196 VDD.n24 0.038
R2213 VDD.n199 VDD.n24 0.038
R2214 VDD.n200 VDD.n199 0.038
R2215 VDD.n200 VDD.n22 0.038
R2216 VDD.n204 VDD.n22 0.038
R2217 VDD.n205 VDD.n204 0.038
R2218 VDD.n205 VDD.n20 0.038
R2219 VDD.n208 VDD.n20 0.038
R2220 VDD.n209 VDD.n208 0.038
R2221 VDD.n209 VDD.n17 0.038
R2222 VDD.n212 VDD.n17 0.038
R2223 VDD.n213 VDD.n212 0.038
R2224 VDD.n213 VDD.n15 0.038
R2225 VDD.n216 VDD.n15 0.038
R2226 VDD.n217 VDD.n216 0.038
R2227 VDD.n217 VDD.n13 0.038
R2228 VDD.n220 VDD.n13 0.038
R2229 VDD.n221 VDD.n220 0.038
R2230 VDD.n221 VDD.n11 0.038
R2231 VDD.n224 VDD.n11 0.038
R2232 VDD.n225 VDD.n224 0.038
R2233 VDD.n225 VDD.n9 0.038
R2234 VDD.n228 VDD.n9 0.038
R2235 VDD.n229 VDD.n228 0.038
R2236 VDD.n229 VDD.n7 0.038
R2237 VDD.n232 VDD.n7 0.038
R2238 VDD.n233 VDD.n232 0.038
R2239 VDD.n233 VDD.n5 0.038
R2240 VDD.n236 VDD.n5 0.038
R2241 VDD.n237 VDD.n236 0.038
R2242 VDD.n237 VDD.n3 0.038
R2243 VDD.n240 VDD.n3 0.038
R2244 VDD.n242 VDD.n240 0.038
R2245 VDD.n242 VDD.n241 0.038
R2246 VDD.n241 VDD.n1 0.038
R2247 VDD.n246 VDD.n1 0.038
R2248 VDD.n260 VDD.t39 0.0366406
R2249 VDD.n264 VDD.t29 0.0366406
R2250 VDD.n290 VDD.n289 0.0301696
R2251 VDD.n298 VDD.n297 0.0280625
R2252 VDD.n86 VDD.n85 0.0261875
R2253 VDD.n272 VDD.n270 0.0254375
R2254 VDD.n202 VDD.n19 0.02525
R2255 VDD.n169 VDD.n40 0.01775
R2256 VDD.n126 VDD.n125 0.01625
R2257 VDD.n279 VDD.n276 0.015125
R2258 VDD.n326 VDD.n250 0.014
R2259 VDD.n340 VDD.n332 0.00857344
R2260 VDD.n342 VDD.n332 0.00857344
R2261 VDD.n348 VDD.n330 0.00857344
R2262 VDD.n338 VDD.n336 0.00857344
R2263 VDD.n345 VDD.n338 0.00857344
R2264 VDD.n340 VDD.n335 0.00857344
R2265 VDD.n336 VDD.n334 0.00857344
R2266 VDD.n346 VDD.n335 0.00857344
R2267 VDD.n334 VDD.n330 0.00857344
R2268 VDD.n346 VDD.n345 0.00857344
R2269 VDD.n333 VDD.n248 0.00841277
R2270 VDD.n339 VDD.n331 0.00841277
R2271 VDD.n337 VDD.n249 0.00841277
R2272 VDD.n344 VDD.n341 0.00841277
R2273 VDD.n343 VDD.n329 0.00841277
R2274 VDD.n344 VDD.n343 0.00841277
R2275 VDD.n341 VDD.n249 0.00841277
R2276 VDD.n337 VDD.n331 0.00841277
R2277 VDD.n339 VDD.n248 0.00841277
R2278 VDD.n347 VDD.n333 0.00841277
R2279 VDD.n296 VDD.n295 0.0055625
R2280 VDD.n161 VDD.n160 0.0040625
R2281 VDD.n310 VDD.n309 0.00275
R2282 VDD.n307 VDD.n267 0.00275
R2283 VDD.n292 VDD.n273 0.0021875
R2284 VSS.n402 VSS.t69 185036
R2285 VSS.n403 VSS.n402 109582
R2286 VSS.n903 VSS.n902 40263.9
R2287 VSS.n902 VSS.n901 22906.2
R2288 VSS.n402 VSS.t78 17503.1
R2289 VSS.n263 VSS.n145 12361.5
R2290 VSS.n901 VSS.t77 12153.5
R2291 VSS.n902 VSS.t145 6340.8
R2292 VSS.n399 VSS.n263 2505.15
R2293 VSS.t33 VSS.t145 2329.75
R2294 VSS.t149 VSS.t33 2252.09
R2295 VSS.n904 VSS.n903 2020.56
R2296 VSS.t77 VSS.t146 2019.12
R2297 VSS.t146 VSS.t149 2019.12
R2298 VSS.t143 VSS.n403 1989.9
R2299 VSS.n903 VSS.n145 1977.7
R2300 VSS.n954 VSS.t9 1447.89
R2301 VSS.t9 VSS.n953 1243.46
R2302 VSS.n311 VSS.n147 1068.61
R2303 VSS.n311 VSS.n146 1068.61
R2304 VSS.n899 VSS.n147 1068.51
R2305 VSS.n899 VSS.n146 1068.51
R2306 VSS.n956 VSS.n111 632.212
R2307 VSS.n906 VSS.n904 540.083
R2308 VSS.t159 VSS.t161 484.781
R2309 VSS.t157 VSS.t155 484.781
R2310 VSS.t155 VSS.t153 484.781
R2311 VSS.t60 VSS.t62 484.781
R2312 VSS.t58 VSS.t60 484.781
R2313 VSS.t56 VSS.t58 484.781
R2314 VSS.t54 VSS.t56 484.781
R2315 VSS.t50 VSS.t52 484.781
R2316 VSS.t48 VSS.t50 484.781
R2317 VSS.t46 VSS.t48 484.781
R2318 VSS.t38 VSS.t46 484.781
R2319 VSS.n145 VSS.t137 461.757
R2320 VSS.t161 VSS.n954 457.236
R2321 VSS.t142 VSS.t62 386.08
R2322 VSS.t72 VSS.t135 338.938
R2323 VSS.n955 VSS.t157 332.827
R2324 VSS.t142 VSS.t52 326.63
R2325 VSS.t13 VSS.t11 270.623
R2326 VSS.t11 VSS.t19 270.623
R2327 VSS.n908 VSS.n142 268.026
R2328 VSS.n140 VSS.n111 268.026
R2329 VSS.t5 VSS.t140 243.909
R2330 VSS.t138 VSS.t1 243.909
R2331 VSS.t25 VSS.t26 228.071
R2332 VSS.n901 VSS.t131 226.506
R2333 VSS.n400 VSS.t13 207.96
R2334 VSS.t75 VSS.t7 200.353
R2335 VSS.n399 VSS.t163 179.898
R2336 VSS.n401 VSS.t142 176.744
R2337 VSS.t147 VSS.t150 176.626
R2338 VSS.t142 VSS.n400 167.102
R2339 VSS.n911 VSS.n910 154.819
R2340 VSS.n955 VSS.t159 151.953
R2341 VSS.t142 VSS.t38 151.494
R2342 VSS.t70 VSS.t5 140.96
R2343 VSS.t3 VSS.t138 140.96
R2344 VSS.n909 VSS.n908 138.159
R2345 VSS.n909 VSS.n111 138.159
R2346 VSS.t66 VSS.t15 134.514
R2347 VSS.n908 VSS.n907 129.869
R2348 VSS.t95 VSS.t143 129.654
R2349 VSS.t64 VSS.t29 127.154
R2350 VSS.t0 VSS.t147 125.928
R2351 VSS.t151 VSS.t66 125.928
R2352 VSS.t131 VSS.n900 123.067
R2353 VSS.n906 VSS.t72 117.996
R2354 VSS.t80 VSS.t81 114.37
R2355 VSS.t79 VSS.t80 114.37
R2356 VSS.t78 VSS.t79 114.37
R2357 VSS.n398 VSS.t133 110.8
R2358 VSS.n904 VSS.n144 104.532
R2359 VSS.t135 VSS.n905 101.365
R2360 VSS.n953 VSS.t137 99.1805
R2361 VSS.n905 VSS.t75 98.9893
R2362 VSS.t17 VSS.t0 98.5349
R2363 VSS.n954 VSS.t1 94.2378
R2364 VSS.t142 VSS.t54 92.0444
R2365 VSS.t83 VSS.t84 81.1211
R2366 VSS.t84 VSS.t85 81.1211
R2367 VSS.t85 VSS.t86 81.1211
R2368 VSS.t86 VSS.t87 81.1211
R2369 VSS.t87 VSS.t88 81.1211
R2370 VSS.t90 VSS.t89 81.1211
R2371 VSS.t91 VSS.t92 81.1211
R2372 VSS.t92 VSS.t93 81.1211
R2373 VSS.t93 VSS.t94 81.1211
R2374 VSS.t94 VSS.t95 81.1211
R2375 VSS.t150 VSS.t23 80.9541
R2376 VSS.t133 VSS.t17 78.0921
R2377 VSS.n902 VSS.n144 76.0239
R2378 VSS.n402 VSS.n401 68.4022
R2379 VSS.t7 VSS.t129 66.521
R2380 VSS.t129 VSS.t74 66.521
R2381 VSS.n910 VSS.t128 66.521
R2382 VSS.t128 VSS.t70 66.521
R2383 VSS.t140 VSS.t27 66.521
R2384 VSS.t26 VSS.t3 66.521
R2385 VSS.n141 VSS.t25 57.018
R2386 VSS.n404 VSS.t91 56.7849
R2387 VSS.t82 VSS.t110 53.1485
R2388 VSS.t81 VSS.n240 50.2204
R2389 VSS.t29 VSS.t151 49.4721
R2390 VSS.t23 VSS.t64 44.9747
R2391 VSS.t15 VSS.t152 42.1127
R2392 VSS.n587 VSS.t88 40.5608
R2393 VSS.t19 VSS.n399 35.2818
R2394 VSS.t89 VSS.n240 31.6096
R2395 VSS.n262 VSS.t164 31.5873
R2396 VSS.t110 VSS.t83 27.9731
R2397 VSS.n404 VSS.t90 24.3367
R2398 VSS.t163 VSS.n398 15.1282
R2399 VSS.n312 VSS.n176 13.3863
R2400 VSS.n313 VSS.n312 13.3863
R2401 VSS.t69 VSS.t82 13.1476
R2402 VSS.n128 VSS.t73 13.0008
R2403 VSS.n129 VSS.t165 11.6669
R2404 VSS.t27 VSS.n141 9.50342
R2405 VSS.n126 VSS.t136 9.43826
R2406 VSS.n919 VSS.t6 9.43826
R2407 VSS.n926 VSS.t4 9.43826
R2408 VSS.n118 VSS.t139 9.43826
R2409 VSS.n587 VSS.n240 8.95174
R2410 VSS.n911 VSS.t74 6.73174
R2411 VSS.n121 VSS.n120 6.65576
R2412 VSS.n587 VSS.n586 6.27865
R2413 VSS.n587 VSS.n239 6.27865
R2414 VSS.n587 VSS.n241 6.27865
R2415 VSS.n588 VSS.n587 6.27865
R2416 VSS.n397 VSS.t134 6.08947
R2417 VSS.n396 VSS.t148 6.08947
R2418 VSS.n395 VSS.t65 6.08947
R2419 VSS.n394 VSS.t67 6.08947
R2420 VSS.n393 VSS.t132 6.08947
R2421 VSS.n982 VSS.t162 6.05637
R2422 VSS.n64 VSS.t154 6.05637
R2423 VSS.n54 VSS.n31 6.02239
R2424 VSS.n55 VSS.n36 6.02239
R2425 VSS.n56 VSS.n45 6.02239
R2426 VSS.n78 VSS.n57 6.02239
R2427 VSS.n275 VSS.t119 5.72359
R2428 VSS.n401 VSS.n218 5.56918
R2429 VSS.n845 VSS.n176 5.17896
R2430 VSS.n347 VSS.n313 5.17896
R2431 VSS.n918 VSS.t71 5.12789
R2432 VSS.n932 VSS.t2 5.12789
R2433 VSS.n405 VSS.n262 5.0855
R2434 VSS.n406 VSS.n405 4.97703
R2435 VSS.n137 VSS.t76 4.82596
R2436 VSS.n266 VSS.t14 4.82596
R2437 VSS.n266 VSS.t114 4.82596
R2438 VSS.n281 VSS.t115 4.82596
R2439 VSS.n281 VSS.t34 4.82596
R2440 VSS.n285 VSS.t16 4.82596
R2441 VSS.n284 VSS.t30 4.82596
R2442 VSS.n275 VSS.t68 4.82596
R2443 VSS.n271 VSS.t124 4.82596
R2444 VSS.n271 VSS.t21 4.82596
R2445 VSS.n289 VSS.t22 4.82596
R2446 VSS.n289 VSS.t120 4.82596
R2447 VSS.n846 VSS.t37 4.75491
R2448 VSS.n149 VSS.t125 4.75491
R2449 VSS.n895 VSS.n894 4.5755
R2450 VSS.n384 VSS.n291 4.5755
R2451 VSS.n409 VSS.n408 4.5005
R2452 VSS.n259 VSS.n258 4.5005
R2453 VSS.n415 VSS.n414 4.5005
R2454 VSS.n417 VSS.n416 4.5005
R2455 VSS.n255 VSS.n254 4.5005
R2456 VSS.n424 VSS.n423 4.5005
R2457 VSS.n426 VSS.n425 4.5005
R2458 VSS.n251 VSS.n250 4.5005
R2459 VSS.n432 VSS.n431 4.5005
R2460 VSS.n434 VSS.n433 4.5005
R2461 VSS.n247 VSS.n246 4.5005
R2462 VSS.n441 VSS.n440 4.5005
R2463 VSS.n442 VSS.n244 4.5005
R2464 VSS.n583 VSS.n582 4.5005
R2465 VSS.n581 VSS.n580 4.5005
R2466 VSS.n444 VSS.n443 4.5005
R2467 VSS.n574 VSS.n573 4.5005
R2468 VSS.n572 VSS.n571 4.5005
R2469 VSS.n568 VSS.n452 4.5005
R2470 VSS.n456 VSS.n453 4.5005
R2471 VSS.n563 VSS.n562 4.5005
R2472 VSS.n561 VSS.n560 4.5005
R2473 VSS.n458 VSS.n457 4.5005
R2474 VSS.n555 VSS.n554 4.5005
R2475 VSS.n553 VSS.n552 4.5005
R2476 VSS.n462 VSS.n461 4.5005
R2477 VSS.n547 VSS.n546 4.5005
R2478 VSS.n545 VSS.n544 4.5005
R2479 VSS.n466 VSS.n465 4.5005
R2480 VSS.n539 VSS.n538 4.5005
R2481 VSS.n537 VSS.n536 4.5005
R2482 VSS.n470 VSS.n469 4.5005
R2483 VSS.n531 VSS.n530 4.5005
R2484 VSS.n529 VSS.n528 4.5005
R2485 VSS.n474 VSS.n473 4.5005
R2486 VSS.n523 VSS.n522 4.5005
R2487 VSS.n521 VSS.n520 4.5005
R2488 VSS.n478 VSS.n477 4.5005
R2489 VSS.n515 VSS.n514 4.5005
R2490 VSS.n513 VSS.n512 4.5005
R2491 VSS.n482 VSS.n481 4.5005
R2492 VSS.n507 VSS.n506 4.5005
R2493 VSS.n505 VSS.n504 4.5005
R2494 VSS.n485 VSS.n484 4.5005
R2495 VSS.n499 VSS.n498 4.5005
R2496 VSS.n497 VSS.n496 4.5005
R2497 VSS.n237 VSS.n236 4.5005
R2498 VSS.n592 VSS.n591 4.5005
R2499 VSS.n594 VSS.n593 4.5005
R2500 VSS.n233 VSS.n232 4.5005
R2501 VSS.n600 VSS.n599 4.5005
R2502 VSS.n602 VSS.n601 4.5005
R2503 VSS.n229 VSS.n228 4.5005
R2504 VSS.n608 VSS.n607 4.5005
R2505 VSS.n610 VSS.n609 4.5005
R2506 VSS.n225 VSS.n224 4.5005
R2507 VSS.n617 VSS.n616 4.5005
R2508 VSS.n619 VSS.n618 4.5005
R2509 VSS.n221 VSS.n220 4.5005
R2510 VSS.n626 VSS.n625 4.5005
R2511 VSS.n628 VSS.n627 4.5005
R2512 VSS.n217 VSS.n216 4.5005
R2513 VSS.n635 VSS.n634 4.5005
R2514 VSS.n636 VSS.n214 4.5005
R2515 VSS.n797 VSS.n796 4.5005
R2516 VSS.n795 VSS.n794 4.5005
R2517 VSS.n638 VSS.n637 4.5005
R2518 VSS.n789 VSS.n788 4.5005
R2519 VSS.n787 VSS.n786 4.5005
R2520 VSS.n783 VSS.n641 4.5005
R2521 VSS.n645 VSS.n642 4.5005
R2522 VSS.n778 VSS.n777 4.5005
R2523 VSS.n776 VSS.n775 4.5005
R2524 VSS.n647 VSS.n646 4.5005
R2525 VSS.n770 VSS.n769 4.5005
R2526 VSS.n768 VSS.n767 4.5005
R2527 VSS.n650 VSS.n649 4.5005
R2528 VSS.n762 VSS.n761 4.5005
R2529 VSS.n760 VSS.n759 4.5005
R2530 VSS.n756 VSS.n654 4.5005
R2531 VSS.n658 VSS.n655 4.5005
R2532 VSS.n751 VSS.n750 4.5005
R2533 VSS.n749 VSS.n748 4.5005
R2534 VSS.n660 VSS.n659 4.5005
R2535 VSS.n743 VSS.n742 4.5005
R2536 VSS.n741 VSS.n740 4.5005
R2537 VSS.n663 VSS.n662 4.5005
R2538 VSS.n735 VSS.n734 4.5005
R2539 VSS.n733 VSS.n732 4.5005
R2540 VSS.n668 VSS.n667 4.5005
R2541 VSS.n727 VSS.n726 4.5005
R2542 VSS.n725 VSS.n724 4.5005
R2543 VSS.n671 VSS.n670 4.5005
R2544 VSS.n719 VSS.n718 4.5005
R2545 VSS.n717 VSS.n716 4.5005
R2546 VSS.n713 VSS.n675 4.5005
R2547 VSS.n679 VSS.n676 4.5005
R2548 VSS.n708 VSS.n707 4.5005
R2549 VSS.n706 VSS.n705 4.5005
R2550 VSS.n681 VSS.n680 4.5005
R2551 VSS.n700 VSS.n699 4.5005
R2552 VSS.n698 VSS.n697 4.5005
R2553 VSS.n684 VSS.n683 4.5005
R2554 VSS.n692 VSS.n691 4.5005
R2555 VSS.n690 VSS.n689 4.5005
R2556 VSS.n193 VSS.n192 4.5005
R2557 VSS.n814 VSS.n813 4.5005
R2558 VSS.n816 VSS.n815 4.5005
R2559 VSS.n189 VSS.n188 4.5005
R2560 VSS.n822 VSS.n821 4.5005
R2561 VSS.n824 VSS.n823 4.5005
R2562 VSS.n184 VSS.n183 4.5005
R2563 VSS.n831 VSS.n830 4.5005
R2564 VSS.n833 VSS.n832 4.5005
R2565 VSS.n180 VSS.n179 4.5005
R2566 VSS.n840 VSS.n839 4.5005
R2567 VSS.n842 VSS.n841 4.5005
R2568 VSS.n175 VSS.n174 4.5005
R2569 VSS.n850 VSS.n849 4.5005
R2570 VSS.n852 VSS.n851 4.5005
R2571 VSS.n171 VSS.n170 4.5005
R2572 VSS.n858 VSS.n857 4.5005
R2573 VSS.n860 VSS.n859 4.5005
R2574 VSS.n166 VSS.n165 4.5005
R2575 VSS.n867 VSS.n866 4.5005
R2576 VSS.n869 VSS.n868 4.5005
R2577 VSS.n162 VSS.n161 4.5005
R2578 VSS.n875 VSS.n874 4.5005
R2579 VSS.n877 VSS.n876 4.5005
R2580 VSS.n157 VSS.n156 4.5005
R2581 VSS.n884 VSS.n883 4.5005
R2582 VSS.n886 VSS.n885 4.5005
R2583 VSS.n153 VSS.n152 4.5005
R2584 VSS.n893 VSS.n892 4.5005
R2585 VSS.n894 VSS.n150 4.5005
R2586 VSS.n988 VSS.n987 4.5005
R2587 VSS.n986 VSS.n985 4.5005
R2588 VSS.n21 VSS.n20 4.5005
R2589 VSS.n979 VSS.n978 4.5005
R2590 VSS.n977 VSS.n976 4.5005
R2591 VSS.n26 VSS.n25 4.5005
R2592 VSS.n971 VSS.n970 4.5005
R2593 VSS.n969 VSS.n968 4.5005
R2594 VSS.n30 VSS.n29 4.5005
R2595 VSS.n963 VSS.n962 4.5005
R2596 VSS.n961 VSS.n960 4.5005
R2597 VSS.n35 VSS.n34 4.5005
R2598 VSS.n108 VSS.n107 4.5005
R2599 VSS.n106 VSS.n105 4.5005
R2600 VSS.n39 VSS.n38 4.5005
R2601 VSS.n100 VSS.n99 4.5005
R2602 VSS.n98 VSS.n97 4.5005
R2603 VSS.n44 VSS.n43 4.5005
R2604 VSS.n92 VSS.n91 4.5005
R2605 VSS.n90 VSS.n89 4.5005
R2606 VSS.n48 VSS.n47 4.5005
R2607 VSS.n84 VSS.n83 4.5005
R2608 VSS.n82 VSS.n81 4.5005
R2609 VSS.n53 VSS.n52 4.5005
R2610 VSS.n75 VSS.n74 4.5005
R2611 VSS.n73 VSS.n72 4.5005
R2612 VSS.n61 VSS.n60 4.5005
R2613 VSS.n67 VSS.n66 4.5005
R2614 VSS.n17 VSS.n16 4.5005
R2615 VSS.n990 VSS.n16 4.5005
R2616 VSS.n936 VSS.n935 4.5005
R2617 VSS.n935 VSS.n934 4.5005
R2618 VSS.n385 VSS.n384 4.5005
R2619 VSS.n383 VSS.n382 4.5005
R2620 VSS.n294 VSS.n293 4.5005
R2621 VSS.n377 VSS.n376 4.5005
R2622 VSS.n375 VSS.n374 4.5005
R2623 VSS.n298 VSS.n297 4.5005
R2624 VSS.n369 VSS.n368 4.5005
R2625 VSS.n367 VSS.n366 4.5005
R2626 VSS.n302 VSS.n301 4.5005
R2627 VSS.n361 VSS.n360 4.5005
R2628 VSS.n359 VSS.n358 4.5005
R2629 VSS.n306 VSS.n305 4.5005
R2630 VSS.n353 VSS.n352 4.5005
R2631 VSS.n351 VSS.n350 4.5005
R2632 VSS.n315 VSS.n309 4.5005
R2633 VSS.n343 VSS.n342 4.5005
R2634 VSS.n341 VSS.n340 4.5005
R2635 VSS.n337 VSS.n317 4.5005
R2636 VSS.n321 VSS.n318 4.5005
R2637 VSS.n332 VSS.n331 4.5005
R2638 VSS.n330 VSS.n329 4.5005
R2639 VSS.n325 VSS.n323 4.5005
R2640 VSS.n322 VSS.n0 4.5005
R2641 VSS.n5 VSS.n1 4.5005
R2642 VSS.n1014 VSS.n1013 4.5005
R2643 VSS.n1012 VSS.n1011 4.5005
R2644 VSS.n7 VSS.n6 4.5005
R2645 VSS.n1006 VSS.n1005 4.5005
R2646 VSS.n1004 VSS.n1003 4.5005
R2647 VSS.n12 VSS.n11 4.5005
R2648 VSS.n998 VSS.n997 4.5005
R2649 VSS.n996 VSS.n995 4.5005
R2650 VSS.n937 VSS.n936 4.13203
R2651 VSS.n420 VSS.t144 3.58511
R2652 VSS.n139 VSS.n125 3.45839
R2653 VSS.n446 VSS.t103 3.44407
R2654 VSS.n488 VSS.t96 3.44407
R2655 VSS.n267 VSS.n264 3.43471
R2656 VSS.n267 VSS.n265 3.43471
R2657 VSS.n280 VSS.n278 3.43471
R2658 VSS.n280 VSS.n279 3.43471
R2659 VSS.n276 VSS.n274 3.43471
R2660 VSS.n283 VSS.n282 3.43471
R2661 VSS.n272 VSS.n269 3.43471
R2662 VSS.n272 VSS.n270 3.43471
R2663 VSS.n288 VSS.n286 3.43471
R2664 VSS.n288 VSS.n287 3.43471
R2665 VSS.n863 VSS.n167 3.36366
R2666 VSS.n880 VSS.n158 3.36366
R2667 VSS.n326 VSS.n142 3.29259
R2668 VSS.n140 VSS.n13 3.29259
R2669 VSS.n120 VSS.t141 2.9405
R2670 VSS.n120 VSS.t28 2.9405
R2671 VSS.n262 VSS.t111 2.88275
R2672 VSS.n900 VSS.t152 2.8625
R2673 VSS.n267 VSS.n266 2.78932
R2674 VSS.n281 VSS.n280 2.78932
R2675 VSS.n272 VSS.n271 2.78932
R2676 VSS.n289 VSS.n288 2.78932
R2677 VSS.n938 VSS.t10 2.64712
R2678 VSS.n951 VSS.t10 2.64712
R2679 VSS.n801 VSS.n800 2.59037
R2680 VSS.n802 VSS.n211 2.59037
R2681 VSS.n803 VSS.n209 2.59037
R2682 VSS.n804 VSS.n207 2.59037
R2683 VSS.n805 VSS.n205 2.59037
R2684 VSS.n806 VSS.n203 2.59037
R2685 VSS.n807 VSS.n201 2.59037
R2686 VSS.n808 VSS.n199 2.59037
R2687 VSS.n810 VSS.n809 2.59037
R2688 VSS.n827 VSS.n185 2.59037
R2689 VSS.n195 VSS.n177 2.59037
R2690 VSS.n449 VSS.n447 2.54182
R2691 VSS.n491 VSS.n489 2.54182
R2692 VSS.t39 VSS.n195 2.51913
R2693 VSS.n801 VSS.t63 2.51913
R2694 VSS.n802 VSS.n210 2.48516
R2695 VSS.n803 VSS.n208 2.48516
R2696 VSS.n804 VSS.n206 2.48516
R2697 VSS.n805 VSS.n204 2.48516
R2698 VSS.n806 VSS.n202 2.48516
R2699 VSS.n807 VSS.n200 2.48516
R2700 VSS.n808 VSS.n198 2.48516
R2701 VSS.n809 VSS.n197 2.48516
R2702 VSS.n196 VSS.n185 2.48516
R2703 VSS.n408 VSS.n407 2.33873
R2704 VSS.n66 VSS.n65 2.32784
R2705 VSS.n933 VSS.n116 2.25177
R2706 VSS.n449 VSS.n448 1.90242
R2707 VSS.n491 VSS.n490 1.90242
R2708 VSS.n276 VSS.n275 1.89168
R2709 VSS.n284 VSS.n283 1.89168
R2710 VSS.n446 VSS.n445 1.87392
R2711 VSS.n488 VSS.n487 1.87392
R2712 VSS.n391 VSS.n390 1.86918
R2713 VSS.n125 VSS.t8 1.7645
R2714 VSS.n125 VSS.t130 1.7645
R2715 VSS.n392 VSS.n391 1.70813
R2716 VSS.n390 VSS.n389 1.63708
R2717 VSS.n65 VSS.n64 1.56609
R2718 VSS.n268 VSS.n267 1.54826
R2719 VSS.n277 VSS.n276 1.54826
R2720 VSS.n273 VSS.n272 1.54826
R2721 VSS.n393 VSS.n392 1.54471
R2722 VSS.n407 VSS.n406 1.5257
R2723 VSS.n933 VSS.n932 1.51494
R2724 VSS.n931 VSS.n117 1.5005
R2725 VSS.n930 VSS.n929 1.5005
R2726 VSS.n928 VSS.n927 1.5005
R2727 VSS.n925 VSS.n119 1.5005
R2728 VSS.n924 VSS.n923 1.5005
R2729 VSS.n922 VSS.n921 1.5005
R2730 VSS.n920 VSS.n122 1.5005
R2731 VSS.n917 VSS.n916 1.5005
R2732 VSS.n915 VSS.n123 1.5005
R2733 VSS.n914 VSS.n913 1.5005
R2734 VSS.n138 VSS.n124 1.5005
R2735 VSS.n136 VSS.n135 1.5005
R2736 VSS.n134 VSS.n133 1.5005
R2737 VSS.n132 VSS.n127 1.5005
R2738 VSS.n131 VSS.n130 1.5005
R2739 VSS.n261 VSS.n260 1.5005
R2740 VSS.n411 VSS.n410 1.5005
R2741 VSS.n413 VSS.n412 1.5005
R2742 VSS.n257 VSS.n256 1.5005
R2743 VSS.n419 VSS.n418 1.5005
R2744 VSS.n422 VSS.n421 1.5005
R2745 VSS.n253 VSS.n252 1.5005
R2746 VSS.n428 VSS.n427 1.5005
R2747 VSS.n430 VSS.n429 1.5005
R2748 VSS.n249 VSS.n248 1.5005
R2749 VSS.n436 VSS.n435 1.5005
R2750 VSS.n438 VSS.n437 1.5005
R2751 VSS.n439 VSS.n242 1.5005
R2752 VSS.n585 VSS.n584 1.5005
R2753 VSS.n245 VSS.n243 1.5005
R2754 VSS.n579 VSS.n578 1.5005
R2755 VSS.n576 VSS.n575 1.5005
R2756 VSS.n451 VSS.n450 1.5005
R2757 VSS.n570 VSS.n569 1.5005
R2758 VSS.n567 VSS.n566 1.5005
R2759 VSS.n565 VSS.n564 1.5005
R2760 VSS.n455 VSS.n454 1.5005
R2761 VSS.n559 VSS.n558 1.5005
R2762 VSS.n557 VSS.n556 1.5005
R2763 VSS.n460 VSS.n459 1.5005
R2764 VSS.n551 VSS.n550 1.5005
R2765 VSS.n549 VSS.n548 1.5005
R2766 VSS.n464 VSS.n463 1.5005
R2767 VSS.n543 VSS.n542 1.5005
R2768 VSS.n541 VSS.n540 1.5005
R2769 VSS.n468 VSS.n467 1.5005
R2770 VSS.n535 VSS.n534 1.5005
R2771 VSS.n533 VSS.n532 1.5005
R2772 VSS.n472 VSS.n471 1.5005
R2773 VSS.n527 VSS.n526 1.5005
R2774 VSS.n525 VSS.n524 1.5005
R2775 VSS.n476 VSS.n475 1.5005
R2776 VSS.n519 VSS.n518 1.5005
R2777 VSS.n517 VSS.n516 1.5005
R2778 VSS.n480 VSS.n479 1.5005
R2779 VSS.n511 VSS.n510 1.5005
R2780 VSS.n509 VSS.n508 1.5005
R2781 VSS.n486 VSS.n483 1.5005
R2782 VSS.n503 VSS.n502 1.5005
R2783 VSS.n501 VSS.n500 1.5005
R2784 VSS.n494 VSS.n493 1.5005
R2785 VSS.n495 VSS.n238 1.5005
R2786 VSS.n590 VSS.n589 1.5005
R2787 VSS.n235 VSS.n234 1.5005
R2788 VSS.n596 VSS.n595 1.5005
R2789 VSS.n598 VSS.n597 1.5005
R2790 VSS.n231 VSS.n230 1.5005
R2791 VSS.n604 VSS.n603 1.5005
R2792 VSS.n606 VSS.n605 1.5005
R2793 VSS.n227 VSS.n226 1.5005
R2794 VSS.n612 VSS.n611 1.5005
R2795 VSS.n615 VSS.n614 1.5005
R2796 VSS.n613 VSS.n223 1.5005
R2797 VSS.n621 VSS.n620 1.5005
R2798 VSS.n624 VSS.n623 1.5005
R2799 VSS.n622 VSS.n219 1.5005
R2800 VSS.n630 VSS.n629 1.5005
R2801 VSS.n632 VSS.n631 1.5005
R2802 VSS.n633 VSS.n212 1.5005
R2803 VSS.n799 VSS.n798 1.5005
R2804 VSS.n215 VSS.n213 1.5005
R2805 VSS.n793 VSS.n792 1.5005
R2806 VSS.n791 VSS.n790 1.5005
R2807 VSS.n640 VSS.n639 1.5005
R2808 VSS.n785 VSS.n784 1.5005
R2809 VSS.n782 VSS.n781 1.5005
R2810 VSS.n780 VSS.n779 1.5005
R2811 VSS.n644 VSS.n643 1.5005
R2812 VSS.n774 VSS.n773 1.5005
R2813 VSS.n772 VSS.n771 1.5005
R2814 VSS.n651 VSS.n648 1.5005
R2815 VSS.n766 VSS.n765 1.5005
R2816 VSS.n764 VSS.n763 1.5005
R2817 VSS.n653 VSS.n652 1.5005
R2818 VSS.n758 VSS.n757 1.5005
R2819 VSS.n755 VSS.n754 1.5005
R2820 VSS.n753 VSS.n752 1.5005
R2821 VSS.n657 VSS.n656 1.5005
R2822 VSS.n747 VSS.n746 1.5005
R2823 VSS.n745 VSS.n744 1.5005
R2824 VSS.n664 VSS.n661 1.5005
R2825 VSS.n739 VSS.n738 1.5005
R2826 VSS.n737 VSS.n736 1.5005
R2827 VSS.n666 VSS.n665 1.5005
R2828 VSS.n731 VSS.n730 1.5005
R2829 VSS.n729 VSS.n728 1.5005
R2830 VSS.n672 VSS.n669 1.5005
R2831 VSS.n723 VSS.n722 1.5005
R2832 VSS.n721 VSS.n720 1.5005
R2833 VSS.n674 VSS.n673 1.5005
R2834 VSS.n715 VSS.n714 1.5005
R2835 VSS.n712 VSS.n711 1.5005
R2836 VSS.n710 VSS.n709 1.5005
R2837 VSS.n678 VSS.n677 1.5005
R2838 VSS.n704 VSS.n703 1.5005
R2839 VSS.n702 VSS.n701 1.5005
R2840 VSS.n685 VSS.n682 1.5005
R2841 VSS.n696 VSS.n695 1.5005
R2842 VSS.n694 VSS.n693 1.5005
R2843 VSS.n687 VSS.n686 1.5005
R2844 VSS.n688 VSS.n194 1.5005
R2845 VSS.n812 VSS.n811 1.5005
R2846 VSS.n191 VSS.n190 1.5005
R2847 VSS.n818 VSS.n817 1.5005
R2848 VSS.n820 VSS.n819 1.5005
R2849 VSS.n187 VSS.n186 1.5005
R2850 VSS.n826 VSS.n825 1.5005
R2851 VSS.n829 VSS.n828 1.5005
R2852 VSS.n182 VSS.n181 1.5005
R2853 VSS.n835 VSS.n834 1.5005
R2854 VSS.n838 VSS.n837 1.5005
R2855 VSS.n836 VSS.n178 1.5005
R2856 VSS.n844 VSS.n843 1.5005
R2857 VSS.n848 VSS.n847 1.5005
R2858 VSS.n173 VSS.n172 1.5005
R2859 VSS.n854 VSS.n853 1.5005
R2860 VSS.n856 VSS.n855 1.5005
R2861 VSS.n169 VSS.n168 1.5005
R2862 VSS.n862 VSS.n861 1.5005
R2863 VSS.n865 VSS.n864 1.5005
R2864 VSS.n164 VSS.n163 1.5005
R2865 VSS.n871 VSS.n870 1.5005
R2866 VSS.n873 VSS.n872 1.5005
R2867 VSS.n160 VSS.n159 1.5005
R2868 VSS.n879 VSS.n878 1.5005
R2869 VSS.n882 VSS.n881 1.5005
R2870 VSS.n155 VSS.n154 1.5005
R2871 VSS.n888 VSS.n887 1.5005
R2872 VSS.n890 VSS.n889 1.5005
R2873 VSS.n891 VSS.n148 1.5005
R2874 VSS.n897 VSS.n896 1.5005
R2875 VSS.n388 VSS.n151 1.5005
R2876 VSS.n387 VSS.n386 1.5005
R2877 VSS.n292 VSS.n290 1.5005
R2878 VSS.n381 VSS.n380 1.5005
R2879 VSS.n379 VSS.n378 1.5005
R2880 VSS.n296 VSS.n295 1.5005
R2881 VSS.n373 VSS.n372 1.5005
R2882 VSS.n371 VSS.n370 1.5005
R2883 VSS.n300 VSS.n299 1.5005
R2884 VSS.n365 VSS.n364 1.5005
R2885 VSS.n363 VSS.n362 1.5005
R2886 VSS.n304 VSS.n303 1.5005
R2887 VSS.n357 VSS.n356 1.5005
R2888 VSS.n355 VSS.n354 1.5005
R2889 VSS.n308 VSS.n307 1.5005
R2890 VSS.n349 VSS.n348 1.5005
R2891 VSS.n346 VSS.n310 1.5005
R2892 VSS.n345 VSS.n344 1.5005
R2893 VSS.n316 VSS.n314 1.5005
R2894 VSS.n339 VSS.n338 1.5005
R2895 VSS.n336 VSS.n335 1.5005
R2896 VSS.n334 VSS.n333 1.5005
R2897 VSS.n320 VSS.n319 1.5005
R2898 VSS.n328 VSS.n327 1.5005
R2899 VSS.n324 VSS.n2 1.5005
R2900 VSS.n1018 VSS.n1017 1.5005
R2901 VSS.n1016 VSS.n1015 1.5005
R2902 VSS.n8 VSS.n4 1.5005
R2903 VSS.n1010 VSS.n1009 1.5005
R2904 VSS.n1008 VSS.n1007 1.5005
R2905 VSS.n10 VSS.n9 1.5005
R2906 VSS.n1002 VSS.n1001 1.5005
R2907 VSS.n1000 VSS.n999 1.5005
R2908 VSS.n15 VSS.n14 1.5005
R2909 VSS.n994 VSS.n993 1.5005
R2910 VSS.n992 VSS.n991 1.5005
R2911 VSS.n989 VSS.n18 1.5005
R2912 VSS.n22 VSS.n19 1.5005
R2913 VSS.n984 VSS.n983 1.5005
R2914 VSS.n981 VSS.n980 1.5005
R2915 VSS.n24 VSS.n23 1.5005
R2916 VSS.n975 VSS.n974 1.5005
R2917 VSS.n973 VSS.n972 1.5005
R2918 VSS.n28 VSS.n27 1.5005
R2919 VSS.n967 VSS.n966 1.5005
R2920 VSS.n965 VSS.n964 1.5005
R2921 VSS.n33 VSS.n32 1.5005
R2922 VSS.n959 VSS.n958 1.5005
R2923 VSS.n110 VSS.n109 1.5005
R2924 VSS.n40 VSS.n37 1.5005
R2925 VSS.n104 VSS.n103 1.5005
R2926 VSS.n102 VSS.n101 1.5005
R2927 VSS.n42 VSS.n41 1.5005
R2928 VSS.n96 VSS.n95 1.5005
R2929 VSS.n94 VSS.n93 1.5005
R2930 VSS.n49 VSS.n46 1.5005
R2931 VSS.n88 VSS.n87 1.5005
R2932 VSS.n86 VSS.n85 1.5005
R2933 VSS.n51 VSS.n50 1.5005
R2934 VSS.n80 VSS.n79 1.5005
R2935 VSS.n77 VSS.n76 1.5005
R2936 VSS.n59 VSS.n58 1.5005
R2937 VSS.n71 VSS.n70 1.5005
R2938 VSS.n69 VSS.n68 1.5005
R2939 VSS.n63 VSS.n62 1.5005
R2940 VSS.n940 VSS.n939 1.5005
R2941 VSS.n941 VSS.n115 1.5005
R2942 VSS.n943 VSS.n942 1.5005
R2943 VSS.n944 VSS.n114 1.5005
R2944 VSS.n946 VSS.n945 1.5005
R2945 VSS.n947 VSS.n113 1.5005
R2946 VSS.n949 VSS.n948 1.5005
R2947 VSS.n950 VSS.n112 1.5005
R2948 VSS.n167 VSS.t127 1.4705
R2949 VSS.n167 VSS.t45 1.4705
R2950 VSS.n158 VSS.t126 1.4705
R2951 VSS.n158 VSS.t24 1.4705
R2952 VSS.n265 VSS.t117 1.4705
R2953 VSS.n265 VSS.t31 1.4705
R2954 VSS.n264 VSS.t12 1.4705
R2955 VSS.n264 VSS.t113 1.4705
R2956 VSS.n279 VSS.t116 1.4705
R2957 VSS.n279 VSS.t41 1.4705
R2958 VSS.n278 VSS.t40 1.4705
R2959 VSS.n278 VSS.t112 1.4705
R2960 VSS.n274 VSS.t42 1.4705
R2961 VSS.n274 VSS.t35 1.4705
R2962 VSS.n282 VSS.t18 1.4705
R2963 VSS.n282 VSS.t118 1.4705
R2964 VSS.n270 VSS.t44 1.4705
R2965 VSS.n270 VSS.t123 1.4705
R2966 VSS.n269 VSS.t121 1.4705
R2967 VSS.n269 VSS.t20 1.4705
R2968 VSS.n287 VSS.t32 1.4705
R2969 VSS.n287 VSS.t122 1.4705
R2970 VSS.n286 VSS.t36 1.4705
R2971 VSS.n286 VSS.t43 1.4705
R2972 VSS.n280 VSS.n268 1.24511
R2973 VSS.n283 VSS.n277 1.24511
R2974 VSS.n288 VSS.n273 1.24511
R2975 VSS.n285 VSS.n284 0.898132
R2976 VSS.n447 VSS.t109 0.8825
R2977 VSS.n447 VSS.t108 0.8825
R2978 VSS.n445 VSS.t105 0.8825
R2979 VSS.n445 VSS.t104 0.8825
R2980 VSS.n448 VSS.t107 0.8825
R2981 VSS.n448 VSS.t106 0.8825
R2982 VSS.n489 VSS.t102 0.8825
R2983 VSS.n489 VSS.t101 0.8825
R2984 VSS.n487 VSS.t98 0.8825
R2985 VSS.n487 VSS.t97 0.8825
R2986 VSS.n490 VSS.t100 0.8825
R2987 VSS.n490 VSS.t99 0.8825
R2988 VSS.n397 VSS.n396 0.876816
R2989 VSS.n396 VSS.n395 0.876816
R2990 VSS.n395 VSS.n394 0.876816
R2991 VSS.n394 VSS.n393 0.876816
R2992 VSS.n577 VSS.n449 0.85325
R2993 VSS.n492 VSS.n491 0.85325
R2994 VSS.n938 VSS.n937 0.757202
R2995 VSS.n934 VSS.n16 0.694737
R2996 VSS.n449 VSS.n446 0.668395
R2997 VSS.n491 VSS.n488 0.668395
R2998 VSS.n398 VSS.n397 0.550675
R2999 VSS.n130 VSS.n129 0.513873
R3000 VSS.n952 VSS.n112 0.501672
R3001 VSS.n392 VSS.n281 0.302474
R3002 VSS.n391 VSS.n285 0.302474
R3003 VSS.n390 VSS.n289 0.302474
R3004 VSS.n803 VSS.n802 0.2381
R3005 VSS.n804 VSS.n803 0.2381
R3006 VSS.n805 VSS.n804 0.2381
R3007 VSS.n806 VSS.n805 0.2381
R3008 VSS.n807 VSS.n806 0.2381
R3009 VSS.n808 VSS.n807 0.2381
R3010 VSS.n809 VSS.n808 0.2381
R3011 VSS.n809 VSS.n185 0.2381
R3012 VSS.n802 VSS.n801 0.237763
R3013 VSS.n195 VSS.n185 0.237763
R3014 VSS.n909 VSS.n3 0.173833
R3015 VSS.n910 VSS.n909 0.173833
R3016 VSS.n907 VSS.n143 0.168242
R3017 VSS.n907 VSS.n906 0.168242
R3018 VSS.n398 VSS.n273 0.133833
R3019 VSS.n398 VSS.n277 0.133833
R3020 VSS.n398 VSS.n268 0.133833
R3021 VSS.n912 VSS.n911 0.122853
R3022 VSS.n953 VSS.n952 0.122853
R3023 VSS.n405 VSS.n404 0.12143
R3024 VSS.n940 VSS.n937 0.108353
R3025 VSS.n129 VSS.n128 0.0872074
R3026 VSS.n141 VSS.n140 0.0857459
R3027 VSS.n905 VSS.n142 0.0857459
R3028 VSS.n130 VSS.n127 0.0755
R3029 VSS.n134 VSS.n127 0.0755
R3030 VSS.n135 VSS.n134 0.0755
R3031 VSS.n135 VSS.n124 0.0755
R3032 VSS.n914 VSS.n124 0.0755
R3033 VSS.n915 VSS.n914 0.0755
R3034 VSS.n916 VSS.n915 0.0755
R3035 VSS.n916 VSS.n122 0.0755
R3036 VSS.n922 VSS.n122 0.0755
R3037 VSS.n923 VSS.n922 0.0755
R3038 VSS.n923 VSS.n119 0.0755
R3039 VSS.n928 VSS.n119 0.0755
R3040 VSS.n929 VSS.n928 0.0755
R3041 VSS.n929 VSS.n117 0.0755
R3042 VSS.n132 VSS.n131 0.0755
R3043 VSS.n133 VSS.n132 0.0755
R3044 VSS.n917 VSS.n123 0.0755
R3045 VSS.n921 VSS.n920 0.0755
R3046 VSS.n925 VSS.n924 0.0755
R3047 VSS.n927 VSS.n925 0.0755
R3048 VSS.n931 VSS.n930 0.0755
R3049 VSS.n987 VSS.n986 0.0755
R3050 VSS.n986 VSS.n20 0.0755
R3051 VSS.n978 VSS.n20 0.0755
R3052 VSS.n978 VSS.n977 0.0755
R3053 VSS.n977 VSS.n25 0.0755
R3054 VSS.n970 VSS.n25 0.0755
R3055 VSS.n970 VSS.n969 0.0755
R3056 VSS.n969 VSS.n29 0.0755
R3057 VSS.n962 VSS.n29 0.0755
R3058 VSS.n962 VSS.n961 0.0755
R3059 VSS.n961 VSS.n34 0.0755
R3060 VSS.n107 VSS.n34 0.0755
R3061 VSS.n107 VSS.n106 0.0755
R3062 VSS.n106 VSS.n38 0.0755
R3063 VSS.n99 VSS.n38 0.0755
R3064 VSS.n99 VSS.n98 0.0755
R3065 VSS.n98 VSS.n43 0.0755
R3066 VSS.n91 VSS.n43 0.0755
R3067 VSS.n91 VSS.n90 0.0755
R3068 VSS.n90 VSS.n47 0.0755
R3069 VSS.n83 VSS.n47 0.0755
R3070 VSS.n83 VSS.n82 0.0755
R3071 VSS.n82 VSS.n52 0.0755
R3072 VSS.n74 VSS.n52 0.0755
R3073 VSS.n74 VSS.n73 0.0755
R3074 VSS.n73 VSS.n60 0.0755
R3075 VSS.n66 VSS.n60 0.0755
R3076 VSS.n408 VSS.n258 0.0755
R3077 VSS.n415 VSS.n258 0.0755
R3078 VSS.n416 VSS.n415 0.0755
R3079 VSS.n416 VSS.n254 0.0755
R3080 VSS.n424 VSS.n254 0.0755
R3081 VSS.n425 VSS.n424 0.0755
R3082 VSS.n425 VSS.n250 0.0755
R3083 VSS.n432 VSS.n250 0.0755
R3084 VSS.n433 VSS.n432 0.0755
R3085 VSS.n433 VSS.n246 0.0755
R3086 VSS.n441 VSS.n246 0.0755
R3087 VSS.n442 VSS.n441 0.0755
R3088 VSS.n582 VSS.n442 0.0755
R3089 VSS.n582 VSS.n581 0.0755
R3090 VSS.n581 VSS.n443 0.0755
R3091 VSS.n573 VSS.n443 0.0755
R3092 VSS.n573 VSS.n572 0.0755
R3093 VSS.n572 VSS.n452 0.0755
R3094 VSS.n456 VSS.n452 0.0755
R3095 VSS.n562 VSS.n456 0.0755
R3096 VSS.n562 VSS.n561 0.0755
R3097 VSS.n561 VSS.n457 0.0755
R3098 VSS.n554 VSS.n457 0.0755
R3099 VSS.n554 VSS.n553 0.0755
R3100 VSS.n553 VSS.n461 0.0755
R3101 VSS.n546 VSS.n461 0.0755
R3102 VSS.n546 VSS.n545 0.0755
R3103 VSS.n545 VSS.n465 0.0755
R3104 VSS.n538 VSS.n465 0.0755
R3105 VSS.n538 VSS.n537 0.0755
R3106 VSS.n537 VSS.n469 0.0755
R3107 VSS.n530 VSS.n469 0.0755
R3108 VSS.n530 VSS.n529 0.0755
R3109 VSS.n529 VSS.n473 0.0755
R3110 VSS.n522 VSS.n473 0.0755
R3111 VSS.n522 VSS.n521 0.0755
R3112 VSS.n521 VSS.n477 0.0755
R3113 VSS.n514 VSS.n477 0.0755
R3114 VSS.n514 VSS.n513 0.0755
R3115 VSS.n513 VSS.n481 0.0755
R3116 VSS.n506 VSS.n481 0.0755
R3117 VSS.n506 VSS.n505 0.0755
R3118 VSS.n505 VSS.n484 0.0755
R3119 VSS.n498 VSS.n484 0.0755
R3120 VSS.n498 VSS.n497 0.0755
R3121 VSS.n497 VSS.n236 0.0755
R3122 VSS.n592 VSS.n236 0.0755
R3123 VSS.n593 VSS.n592 0.0755
R3124 VSS.n593 VSS.n232 0.0755
R3125 VSS.n600 VSS.n232 0.0755
R3126 VSS.n601 VSS.n600 0.0755
R3127 VSS.n601 VSS.n228 0.0755
R3128 VSS.n608 VSS.n228 0.0755
R3129 VSS.n609 VSS.n608 0.0755
R3130 VSS.n609 VSS.n224 0.0755
R3131 VSS.n617 VSS.n224 0.0755
R3132 VSS.n618 VSS.n617 0.0755
R3133 VSS.n618 VSS.n220 0.0755
R3134 VSS.n626 VSS.n220 0.0755
R3135 VSS.n627 VSS.n626 0.0755
R3136 VSS.n627 VSS.n216 0.0755
R3137 VSS.n635 VSS.n216 0.0755
R3138 VSS.n636 VSS.n635 0.0755
R3139 VSS.n796 VSS.n636 0.0755
R3140 VSS.n796 VSS.n795 0.0755
R3141 VSS.n795 VSS.n637 0.0755
R3142 VSS.n788 VSS.n637 0.0755
R3143 VSS.n788 VSS.n787 0.0755
R3144 VSS.n787 VSS.n641 0.0755
R3145 VSS.n645 VSS.n641 0.0755
R3146 VSS.n777 VSS.n645 0.0755
R3147 VSS.n777 VSS.n776 0.0755
R3148 VSS.n776 VSS.n646 0.0755
R3149 VSS.n769 VSS.n646 0.0755
R3150 VSS.n769 VSS.n768 0.0755
R3151 VSS.n768 VSS.n649 0.0755
R3152 VSS.n761 VSS.n649 0.0755
R3153 VSS.n761 VSS.n760 0.0755
R3154 VSS.n760 VSS.n654 0.0755
R3155 VSS.n658 VSS.n654 0.0755
R3156 VSS.n750 VSS.n658 0.0755
R3157 VSS.n750 VSS.n749 0.0755
R3158 VSS.n749 VSS.n659 0.0755
R3159 VSS.n742 VSS.n659 0.0755
R3160 VSS.n742 VSS.n741 0.0755
R3161 VSS.n741 VSS.n662 0.0755
R3162 VSS.n734 VSS.n662 0.0755
R3163 VSS.n734 VSS.n733 0.0755
R3164 VSS.n733 VSS.n667 0.0755
R3165 VSS.n726 VSS.n667 0.0755
R3166 VSS.n726 VSS.n725 0.0755
R3167 VSS.n725 VSS.n670 0.0755
R3168 VSS.n718 VSS.n670 0.0755
R3169 VSS.n718 VSS.n717 0.0755
R3170 VSS.n717 VSS.n675 0.0755
R3171 VSS.n679 VSS.n675 0.0755
R3172 VSS.n707 VSS.n679 0.0755
R3173 VSS.n707 VSS.n706 0.0755
R3174 VSS.n706 VSS.n680 0.0755
R3175 VSS.n699 VSS.n680 0.0755
R3176 VSS.n699 VSS.n698 0.0755
R3177 VSS.n698 VSS.n683 0.0755
R3178 VSS.n691 VSS.n683 0.0755
R3179 VSS.n691 VSS.n690 0.0755
R3180 VSS.n690 VSS.n192 0.0755
R3181 VSS.n814 VSS.n192 0.0755
R3182 VSS.n815 VSS.n814 0.0755
R3183 VSS.n815 VSS.n188 0.0755
R3184 VSS.n822 VSS.n188 0.0755
R3185 VSS.n823 VSS.n822 0.0755
R3186 VSS.n823 VSS.n183 0.0755
R3187 VSS.n831 VSS.n183 0.0755
R3188 VSS.n832 VSS.n831 0.0755
R3189 VSS.n832 VSS.n179 0.0755
R3190 VSS.n840 VSS.n179 0.0755
R3191 VSS.n841 VSS.n840 0.0755
R3192 VSS.n841 VSS.n174 0.0755
R3193 VSS.n850 VSS.n174 0.0755
R3194 VSS.n851 VSS.n850 0.0755
R3195 VSS.n851 VSS.n170 0.0755
R3196 VSS.n858 VSS.n170 0.0755
R3197 VSS.n859 VSS.n858 0.0755
R3198 VSS.n859 VSS.n165 0.0755
R3199 VSS.n867 VSS.n165 0.0755
R3200 VSS.n868 VSS.n867 0.0755
R3201 VSS.n868 VSS.n161 0.0755
R3202 VSS.n875 VSS.n161 0.0755
R3203 VSS.n876 VSS.n875 0.0755
R3204 VSS.n876 VSS.n156 0.0755
R3205 VSS.n884 VSS.n156 0.0755
R3206 VSS.n885 VSS.n884 0.0755
R3207 VSS.n885 VSS.n152 0.0755
R3208 VSS.n893 VSS.n152 0.0755
R3209 VSS.n894 VSS.n893 0.0755
R3210 VSS.n406 VSS.n260 0.0755
R3211 VSS.n411 VSS.n260 0.0755
R3212 VSS.n412 VSS.n411 0.0755
R3213 VSS.n412 VSS.n256 0.0755
R3214 VSS.n419 VSS.n256 0.0755
R3215 VSS.n421 VSS.n252 0.0755
R3216 VSS.n428 VSS.n252 0.0755
R3217 VSS.n429 VSS.n428 0.0755
R3218 VSS.n429 VSS.n248 0.0755
R3219 VSS.n436 VSS.n248 0.0755
R3220 VSS.n437 VSS.n436 0.0755
R3221 VSS.n437 VSS.n242 0.0755
R3222 VSS.n585 VSS.n243 0.0755
R3223 VSS.n578 VSS.n243 0.0755
R3224 VSS.n576 VSS.n450 0.0755
R3225 VSS.n569 VSS.n450 0.0755
R3226 VSS.n566 VSS.n565 0.0755
R3227 VSS.n565 VSS.n454 0.0755
R3228 VSS.n558 VSS.n454 0.0755
R3229 VSS.n558 VSS.n557 0.0755
R3230 VSS.n557 VSS.n459 0.0755
R3231 VSS.n550 VSS.n459 0.0755
R3232 VSS.n550 VSS.n549 0.0755
R3233 VSS.n549 VSS.n463 0.0755
R3234 VSS.n542 VSS.n463 0.0755
R3235 VSS.n542 VSS.n541 0.0755
R3236 VSS.n541 VSS.n467 0.0755
R3237 VSS.n534 VSS.n467 0.0755
R3238 VSS.n534 VSS.n533 0.0755
R3239 VSS.n533 VSS.n471 0.0755
R3240 VSS.n526 VSS.n471 0.0755
R3241 VSS.n526 VSS.n525 0.0755
R3242 VSS.n525 VSS.n475 0.0755
R3243 VSS.n518 VSS.n475 0.0755
R3244 VSS.n518 VSS.n517 0.0755
R3245 VSS.n517 VSS.n479 0.0755
R3246 VSS.n510 VSS.n479 0.0755
R3247 VSS.n510 VSS.n509 0.0755
R3248 VSS.n502 VSS.n486 0.0755
R3249 VSS.n502 VSS.n501 0.0755
R3250 VSS.n493 VSS.n238 0.0755
R3251 VSS.n589 VSS.n238 0.0755
R3252 VSS.n596 VSS.n234 0.0755
R3253 VSS.n597 VSS.n596 0.0755
R3254 VSS.n597 VSS.n230 0.0755
R3255 VSS.n604 VSS.n230 0.0755
R3256 VSS.n605 VSS.n604 0.0755
R3257 VSS.n605 VSS.n226 0.0755
R3258 VSS.n612 VSS.n226 0.0755
R3259 VSS.n614 VSS.n612 0.0755
R3260 VSS.n614 VSS.n613 0.0755
R3261 VSS.n623 VSS.n621 0.0755
R3262 VSS.n623 VSS.n622 0.0755
R3263 VSS.n631 VSS.n630 0.0755
R3264 VSS.n631 VSS.n212 0.0755
R3265 VSS.n799 VSS.n213 0.0755
R3266 VSS.n792 VSS.n213 0.0755
R3267 VSS.n792 VSS.n791 0.0755
R3268 VSS.n791 VSS.n639 0.0755
R3269 VSS.n784 VSS.n639 0.0755
R3270 VSS.n781 VSS.n780 0.0755
R3271 VSS.n780 VSS.n643 0.0755
R3272 VSS.n773 VSS.n643 0.0755
R3273 VSS.n773 VSS.n772 0.0755
R3274 VSS.n765 VSS.n651 0.0755
R3275 VSS.n765 VSS.n764 0.0755
R3276 VSS.n764 VSS.n652 0.0755
R3277 VSS.n757 VSS.n652 0.0755
R3278 VSS.n754 VSS.n753 0.0755
R3279 VSS.n753 VSS.n656 0.0755
R3280 VSS.n746 VSS.n656 0.0755
R3281 VSS.n746 VSS.n745 0.0755
R3282 VSS.n738 VSS.n664 0.0755
R3283 VSS.n738 VSS.n737 0.0755
R3284 VSS.n737 VSS.n665 0.0755
R3285 VSS.n730 VSS.n665 0.0755
R3286 VSS.n730 VSS.n729 0.0755
R3287 VSS.n722 VSS.n672 0.0755
R3288 VSS.n722 VSS.n721 0.0755
R3289 VSS.n721 VSS.n673 0.0755
R3290 VSS.n714 VSS.n673 0.0755
R3291 VSS.n711 VSS.n710 0.0755
R3292 VSS.n710 VSS.n677 0.0755
R3293 VSS.n703 VSS.n677 0.0755
R3294 VSS.n703 VSS.n702 0.0755
R3295 VSS.n695 VSS.n685 0.0755
R3296 VSS.n695 VSS.n694 0.0755
R3297 VSS.n694 VSS.n686 0.0755
R3298 VSS.n686 VSS.n194 0.0755
R3299 VSS.n811 VSS.n194 0.0755
R3300 VSS.n818 VSS.n190 0.0755
R3301 VSS.n819 VSS.n818 0.0755
R3302 VSS.n819 VSS.n186 0.0755
R3303 VSS.n826 VSS.n186 0.0755
R3304 VSS.n828 VSS.n181 0.0755
R3305 VSS.n835 VSS.n181 0.0755
R3306 VSS.n837 VSS.n835 0.0755
R3307 VSS.n837 VSS.n836 0.0755
R3308 VSS.n847 VSS.n172 0.0755
R3309 VSS.n854 VSS.n172 0.0755
R3310 VSS.n855 VSS.n854 0.0755
R3311 VSS.n855 VSS.n168 0.0755
R3312 VSS.n862 VSS.n168 0.0755
R3313 VSS.n864 VSS.n163 0.0755
R3314 VSS.n871 VSS.n163 0.0755
R3315 VSS.n872 VSS.n871 0.0755
R3316 VSS.n872 VSS.n159 0.0755
R3317 VSS.n879 VSS.n159 0.0755
R3318 VSS.n881 VSS.n154 0.0755
R3319 VSS.n888 VSS.n154 0.0755
R3320 VSS.n889 VSS.n888 0.0755
R3321 VSS.n889 VSS.n148 0.0755
R3322 VSS.n388 VSS.n387 0.0755
R3323 VSS.n387 VSS.n290 0.0755
R3324 VSS.n380 VSS.n290 0.0755
R3325 VSS.n380 VSS.n379 0.0755
R3326 VSS.n379 VSS.n295 0.0755
R3327 VSS.n372 VSS.n295 0.0755
R3328 VSS.n372 VSS.n371 0.0755
R3329 VSS.n371 VSS.n299 0.0755
R3330 VSS.n364 VSS.n299 0.0755
R3331 VSS.n364 VSS.n363 0.0755
R3332 VSS.n363 VSS.n303 0.0755
R3333 VSS.n356 VSS.n303 0.0755
R3334 VSS.n356 VSS.n355 0.0755
R3335 VSS.n355 VSS.n307 0.0755
R3336 VSS.n348 VSS.n307 0.0755
R3337 VSS.n346 VSS.n345 0.0755
R3338 VSS.n345 VSS.n314 0.0755
R3339 VSS.n338 VSS.n314 0.0755
R3340 VSS.n335 VSS.n334 0.0755
R3341 VSS.n334 VSS.n319 0.0755
R3342 VSS.n327 VSS.n319 0.0755
R3343 VSS.n1017 VSS.n2 0.0755
R3344 VSS.n1017 VSS.n1016 0.0755
R3345 VSS.n1009 VSS.n8 0.0755
R3346 VSS.n1009 VSS.n1008 0.0755
R3347 VSS.n1008 VSS.n9 0.0755
R3348 VSS.n1001 VSS.n1000 0.0755
R3349 VSS.n1000 VSS.n14 0.0755
R3350 VSS.n993 VSS.n14 0.0755
R3351 VSS.n993 VSS.n992 0.0755
R3352 VSS.n992 VSS.n18 0.0755
R3353 VSS.n22 VSS.n18 0.0755
R3354 VSS.n983 VSS.n22 0.0755
R3355 VSS.n981 VSS.n23 0.0755
R3356 VSS.n974 VSS.n23 0.0755
R3357 VSS.n974 VSS.n973 0.0755
R3358 VSS.n973 VSS.n27 0.0755
R3359 VSS.n966 VSS.n965 0.0755
R3360 VSS.n965 VSS.n32 0.0755
R3361 VSS.n958 VSS.n32 0.0755
R3362 VSS.n103 VSS.n40 0.0755
R3363 VSS.n103 VSS.n102 0.0755
R3364 VSS.n102 VSS.n41 0.0755
R3365 VSS.n95 VSS.n41 0.0755
R3366 VSS.n95 VSS.n94 0.0755
R3367 VSS.n87 VSS.n49 0.0755
R3368 VSS.n87 VSS.n86 0.0755
R3369 VSS.n86 VSS.n50 0.0755
R3370 VSS.n79 VSS.n50 0.0755
R3371 VSS.n77 VSS.n58 0.0755
R3372 VSS.n70 VSS.n58 0.0755
R3373 VSS.n70 VSS.n69 0.0755
R3374 VSS.n69 VSS.n62 0.0755
R3375 VSS.n950 VSS.n949 0.0755
R3376 VSS.n949 VSS.n113 0.0755
R3377 VSS.n945 VSS.n113 0.0755
R3378 VSS.n945 VSS.n944 0.0755
R3379 VSS.n944 VSS.n943 0.0755
R3380 VSS.n943 VSS.n115 0.0755
R3381 VSS.n939 VSS.n115 0.0755
R3382 VSS.n948 VSS.n112 0.0755
R3383 VSS.n948 VSS.n947 0.0755
R3384 VSS.n947 VSS.n946 0.0755
R3385 VSS.n946 VSS.n114 0.0755
R3386 VSS.n942 VSS.n114 0.0755
R3387 VSS.n942 VSS.n941 0.0755
R3388 VSS.n941 VSS.n940 0.0755
R3389 VSS.n384 VSS.n383 0.0755
R3390 VSS.n383 VSS.n293 0.0755
R3391 VSS.n376 VSS.n293 0.0755
R3392 VSS.n376 VSS.n375 0.0755
R3393 VSS.n375 VSS.n297 0.0755
R3394 VSS.n368 VSS.n297 0.0755
R3395 VSS.n368 VSS.n367 0.0755
R3396 VSS.n367 VSS.n301 0.0755
R3397 VSS.n360 VSS.n301 0.0755
R3398 VSS.n360 VSS.n359 0.0755
R3399 VSS.n359 VSS.n305 0.0755
R3400 VSS.n352 VSS.n305 0.0755
R3401 VSS.n352 VSS.n351 0.0755
R3402 VSS.n351 VSS.n309 0.0755
R3403 VSS.n342 VSS.n309 0.0755
R3404 VSS.n342 VSS.n341 0.0755
R3405 VSS.n341 VSS.n317 0.0755
R3406 VSS.n321 VSS.n317 0.0755
R3407 VSS.n331 VSS.n321 0.0755
R3408 VSS.n331 VSS.n330 0.0755
R3409 VSS.n330 VSS.n323 0.0755
R3410 VSS.n323 VSS.n322 0.0755
R3411 VSS.n322 VSS.n5 0.0755
R3412 VSS.n1013 VSS.n5 0.0755
R3413 VSS.n1013 VSS.n1012 0.0755
R3414 VSS.n1012 VSS.n6 0.0755
R3415 VSS.n1005 VSS.n6 0.0755
R3416 VSS.n1004 VSS.n11 0.0755
R3417 VSS.n997 VSS.n11 0.0755
R3418 VSS.n997 VSS.n996 0.0755
R3419 VSS.n136 VSS.n126 0.0741875
R3420 VSS.n939 VSS.n938 0.072875
R3421 VSS.n291 VSS.n151 0.0725
R3422 VSS.n386 VSS.n385 0.0725
R3423 VSS.n382 VSS.n292 0.0725
R3424 VSS.n381 VSS.n294 0.0725
R3425 VSS.n378 VSS.n377 0.0725
R3426 VSS.n374 VSS.n296 0.0725
R3427 VSS.n373 VSS.n298 0.0725
R3428 VSS.n370 VSS.n369 0.0725
R3429 VSS.n366 VSS.n300 0.0725
R3430 VSS.n365 VSS.n302 0.0725
R3431 VSS.n362 VSS.n361 0.0725
R3432 VSS.n358 VSS.n304 0.0725
R3433 VSS.n357 VSS.n306 0.0725
R3434 VSS.n354 VSS.n353 0.0725
R3435 VSS.n350 VSS.n308 0.0725
R3436 VSS.n344 VSS.n315 0.07175
R3437 VSS.n343 VSS.n316 0.07175
R3438 VSS.n340 VSS.n339 0.07175
R3439 VSS.n337 VSS.n336 0.07175
R3440 VSS.n333 VSS.n318 0.07175
R3441 VSS.n332 VSS.n320 0.07175
R3442 VSS.n329 VSS.n328 0.07175
R3443 VSS.n325 VSS.n324 0.07175
R3444 VSS.n1015 VSS.n1 0.07175
R3445 VSS.n1014 VSS.n4 0.07175
R3446 VSS.n1011 VSS.n1010 0.07175
R3447 VSS.n1007 VSS.n7 0.07175
R3448 VSS.n1006 VSS.n10 0.07175
R3449 VSS.n1003 VSS.n1002 0.07175
R3450 VSS.n999 VSS.n12 0.07175
R3451 VSS.n998 VSS.n15 0.07175
R3452 VSS.n995 VSS.n994 0.07175
R3453 VSS.n991 VSS.n17 0.07175
R3454 VSS.n990 VSS.n989 0.07175
R3455 VSS.n988 VSS.n19 0.07175
R3456 VSS.n985 VSS.n984 0.07175
R3457 VSS.n980 VSS.n21 0.07175
R3458 VSS.n979 VSS.n24 0.07175
R3459 VSS.n976 VSS.n975 0.07175
R3460 VSS.n972 VSS.n26 0.07175
R3461 VSS.n971 VSS.n28 0.07175
R3462 VSS.n968 VSS.n967 0.07175
R3463 VSS.n964 VSS.n30 0.07175
R3464 VSS.n963 VSS.n33 0.07175
R3465 VSS.n960 VSS.n959 0.07175
R3466 VSS.n109 VSS.n35 0.07175
R3467 VSS.n108 VSS.n37 0.07175
R3468 VSS.n105 VSS.n104 0.07175
R3469 VSS.n101 VSS.n39 0.07175
R3470 VSS.n100 VSS.n42 0.07175
R3471 VSS.n97 VSS.n96 0.07175
R3472 VSS.n93 VSS.n44 0.07175
R3473 VSS.n92 VSS.n46 0.07175
R3474 VSS.n89 VSS.n88 0.07175
R3475 VSS.n85 VSS.n48 0.07175
R3476 VSS.n84 VSS.n51 0.07175
R3477 VSS.n81 VSS.n80 0.07175
R3478 VSS.n76 VSS.n53 0.07175
R3479 VSS.n75 VSS.n59 0.07175
R3480 VSS.n72 VSS.n71 0.07175
R3481 VSS.n68 VSS.n61 0.07175
R3482 VSS.n67 VSS.n63 0.07175
R3483 VSS.n810 VSS.n190 0.071375
R3484 VSS.n49 VSS.n45 0.071375
R3485 VSS.n745 VSS.n205 0.070625
R3486 VSS.n349 VSS.n310 0.06875
R3487 VSS.n781 VSS.n211 0.068375
R3488 VSS.n848 VSS.n175 0.068
R3489 VSS.n849 VSS.n173 0.068
R3490 VSS.n853 VSS.n852 0.068
R3491 VSS.n856 VSS.n171 0.068
R3492 VSS.n857 VSS.n169 0.068
R3493 VSS.n861 VSS.n860 0.068
R3494 VSS.n865 VSS.n166 0.068
R3495 VSS.n866 VSS.n164 0.068
R3496 VSS.n870 VSS.n869 0.068
R3497 VSS.n873 VSS.n162 0.068
R3498 VSS.n874 VSS.n160 0.068
R3499 VSS.n878 VSS.n877 0.068
R3500 VSS.n882 VSS.n157 0.068
R3501 VSS.n883 VSS.n155 0.068
R3502 VSS.n887 VSS.n886 0.068
R3503 VSS.n890 VSS.n153 0.068
R3504 VSS.n892 VSS.n891 0.068
R3505 VSS.n896 VSS.n150 0.068
R3506 VSS.n895 VSS.n151 0.068
R3507 VSS.n1016 VSS.n3 0.0665
R3508 VSS.n421 VSS.n420 0.0659375
R3509 VSS.n326 VSS.n2 0.06575
R3510 VSS.n569 VSS.n239 0.063875
R3511 VSS.n898 VSS.n897 0.0629375
R3512 VSS.n996 VSS.n16 0.062375
R3513 VSS.n800 VSS.n212 0.0621875
R3514 VSS.n493 VSS.n492 0.062
R3515 VSS.n932 VSS.n931 0.0610625
R3516 VSS.n935 VSS.n117 0.0605
R3517 VSS.n846 VSS.n845 0.0603125
R3518 VSS.n958 VSS.n957 0.05975
R3519 VSS.n672 VSS.n203 0.059375
R3520 VSS VSS.n0 0.059
R3521 VSS.n1005 VSS 0.059
R3522 VSS.n982 VSS.n981 0.0588125
R3523 VSS.n702 VSS.n199 0.058625
R3524 VSS.n110 VSS.n36 0.058625
R3525 VSS.n912 VSS.n123 0.0584375
R3526 VSS.n138 VSS.n137 0.0543125
R3527 VSS.n176 VSS.n146 0.0530253
R3528 VSS.n400 VSS.n146 0.0530253
R3529 VSS.n313 VSS.n147 0.0530253
R3530 VSS.n147 VSS.n144 0.0530253
R3531 VSS.n921 VSS.n121 0.051875
R3532 VSS.n589 VSS.n588 0.051875
R3533 VSS.n630 VSS.n218 0.051125
R3534 VSS.n407 VSS.n261 0.0510348
R3535 VSS.n828 VSS.n827 0.050375
R3536 VSS.n78 VSS.n77 0.050375
R3537 VSS.n577 VSS.n576 0.05
R3538 VSS.n409 VSS.n261 0.049625
R3539 VSS.n410 VSS.n259 0.049625
R3540 VSS.n414 VSS.n413 0.049625
R3541 VSS.n417 VSS.n257 0.049625
R3542 VSS.n418 VSS.n255 0.049625
R3543 VSS.n423 VSS.n422 0.049625
R3544 VSS.n426 VSS.n253 0.049625
R3545 VSS.n427 VSS.n251 0.049625
R3546 VSS.n431 VSS.n430 0.049625
R3547 VSS.n434 VSS.n249 0.049625
R3548 VSS.n435 VSS.n247 0.049625
R3549 VSS.n440 VSS.n438 0.049625
R3550 VSS.n439 VSS.n244 0.049625
R3551 VSS.n584 VSS.n583 0.049625
R3552 VSS.n580 VSS.n245 0.049625
R3553 VSS.n579 VSS.n444 0.049625
R3554 VSS.n575 VSS.n574 0.049625
R3555 VSS.n571 VSS.n451 0.049625
R3556 VSS.n570 VSS.n568 0.049625
R3557 VSS.n567 VSS.n453 0.049625
R3558 VSS.n564 VSS.n563 0.049625
R3559 VSS.n560 VSS.n455 0.049625
R3560 VSS.n559 VSS.n458 0.049625
R3561 VSS.n556 VSS.n555 0.049625
R3562 VSS.n552 VSS.n460 0.049625
R3563 VSS.n551 VSS.n462 0.049625
R3564 VSS.n548 VSS.n547 0.049625
R3565 VSS.n544 VSS.n464 0.049625
R3566 VSS.n543 VSS.n466 0.049625
R3567 VSS.n540 VSS.n539 0.049625
R3568 VSS.n536 VSS.n468 0.049625
R3569 VSS.n535 VSS.n470 0.049625
R3570 VSS.n532 VSS.n531 0.049625
R3571 VSS.n528 VSS.n472 0.049625
R3572 VSS.n527 VSS.n474 0.049625
R3573 VSS.n524 VSS.n523 0.049625
R3574 VSS.n520 VSS.n476 0.049625
R3575 VSS.n519 VSS.n478 0.049625
R3576 VSS.n516 VSS.n515 0.049625
R3577 VSS.n512 VSS.n480 0.049625
R3578 VSS.n511 VSS.n482 0.049625
R3579 VSS.n508 VSS.n507 0.049625
R3580 VSS.n504 VSS.n483 0.049625
R3581 VSS.n503 VSS.n485 0.049625
R3582 VSS.n500 VSS.n499 0.049625
R3583 VSS.n496 VSS.n494 0.049625
R3584 VSS.n495 VSS.n237 0.049625
R3585 VSS.n591 VSS.n590 0.049625
R3586 VSS.n594 VSS.n235 0.049625
R3587 VSS.n595 VSS.n233 0.049625
R3588 VSS.n599 VSS.n598 0.049625
R3589 VSS.n602 VSS.n231 0.049625
R3590 VSS.n603 VSS.n229 0.049625
R3591 VSS.n607 VSS.n606 0.049625
R3592 VSS.n610 VSS.n227 0.049625
R3593 VSS.n611 VSS.n225 0.049625
R3594 VSS.n616 VSS.n615 0.049625
R3595 VSS.n619 VSS.n223 0.049625
R3596 VSS.n620 VSS.n221 0.049625
R3597 VSS.n625 VSS.n624 0.049625
R3598 VSS.n628 VSS.n219 0.049625
R3599 VSS.n629 VSS.n217 0.049625
R3600 VSS.n634 VSS.n632 0.049625
R3601 VSS.n633 VSS.n214 0.049625
R3602 VSS.n798 VSS.n797 0.049625
R3603 VSS.n794 VSS.n215 0.049625
R3604 VSS.n793 VSS.n638 0.049625
R3605 VSS.n790 VSS.n789 0.049625
R3606 VSS.n786 VSS.n640 0.049625
R3607 VSS.n785 VSS.n783 0.049625
R3608 VSS.n782 VSS.n642 0.049625
R3609 VSS.n779 VSS.n778 0.049625
R3610 VSS.n775 VSS.n644 0.049625
R3611 VSS.n774 VSS.n647 0.049625
R3612 VSS.n771 VSS.n770 0.049625
R3613 VSS.n767 VSS.n648 0.049625
R3614 VSS.n766 VSS.n650 0.049625
R3615 VSS.n763 VSS.n762 0.049625
R3616 VSS.n759 VSS.n653 0.049625
R3617 VSS.n758 VSS.n756 0.049625
R3618 VSS.n755 VSS.n655 0.049625
R3619 VSS.n752 VSS.n751 0.049625
R3620 VSS.n748 VSS.n657 0.049625
R3621 VSS.n747 VSS.n660 0.049625
R3622 VSS.n744 VSS.n743 0.049625
R3623 VSS.n740 VSS.n661 0.049625
R3624 VSS.n739 VSS.n663 0.049625
R3625 VSS.n736 VSS.n735 0.049625
R3626 VSS.n732 VSS.n666 0.049625
R3627 VSS.n731 VSS.n668 0.049625
R3628 VSS.n728 VSS.n727 0.049625
R3629 VSS.n724 VSS.n669 0.049625
R3630 VSS.n723 VSS.n671 0.049625
R3631 VSS.n720 VSS.n719 0.049625
R3632 VSS.n716 VSS.n674 0.049625
R3633 VSS.n715 VSS.n713 0.049625
R3634 VSS.n712 VSS.n676 0.049625
R3635 VSS.n709 VSS.n708 0.049625
R3636 VSS.n705 VSS.n678 0.049625
R3637 VSS.n704 VSS.n681 0.049625
R3638 VSS.n701 VSS.n700 0.049625
R3639 VSS.n697 VSS.n682 0.049625
R3640 VSS.n696 VSS.n684 0.049625
R3641 VSS.n693 VSS.n692 0.049625
R3642 VSS.n689 VSS.n687 0.049625
R3643 VSS.n688 VSS.n193 0.049625
R3644 VSS.n813 VSS.n812 0.049625
R3645 VSS.n816 VSS.n191 0.049625
R3646 VSS.n817 VSS.n189 0.049625
R3647 VSS.n821 VSS.n820 0.049625
R3648 VSS.n824 VSS.n187 0.049625
R3649 VSS.n825 VSS.n184 0.049625
R3650 VSS.n830 VSS.n829 0.049625
R3651 VSS.n833 VSS.n182 0.049625
R3652 VSS.n834 VSS.n180 0.049625
R3653 VSS.n839 VSS.n838 0.049625
R3654 VSS.n842 VSS.n178 0.049625
R3655 VSS.n843 VSS.n175 0.049625
R3656 VSS.n757 VSS.n207 0.049625
R3657 VSS.n389 VSS.n149 0.0483125
R3658 VSS.n13 VSS.n9 0.04775
R3659 VSS.n651 VSS.n209 0.047375
R3660 VSS.n586 VSS.n242 0.046625
R3661 VSS.n836 VSS.n177 0.0460625
R3662 VSS.n64 VSS.n62 0.0460625
R3663 VSS.n338 VSS.n143 0.045875
R3664 VSS.n863 VSS.n862 0.043625
R3665 VSS.n139 VSS.n138 0.042125
R3666 VSS.n131 VSS.n128 0.041375
R3667 VSS.n486 VSS.n241 0.041375
R3668 VSS.n881 VSS.n880 0.04025
R3669 VSS.n65 VSS.n63 0.039791
R3670 VSS.n613 VSS.n222 0.0389375
R3671 VSS.n711 VSS.n201 0.038375
R3672 VSS.n966 VSS.n31 0.038375
R3673 VSS.n714 VSS.n201 0.037625
R3674 VSS.n31 VSS.n27 0.037625
R3675 VSS.n621 VSS.n222 0.0370625
R3676 VSS.n919 VSS.n918 0.036875
R3677 VSS.n926 VSS.n118 0.036875
R3678 VSS.t63 VSS.n210 0.0363974
R3679 VSS.n210 VSS.t61 0.0363974
R3680 VSS.t61 VSS.n208 0.0363974
R3681 VSS.n208 VSS.t59 0.0363974
R3682 VSS.t59 VSS.n206 0.0363974
R3683 VSS.n206 VSS.t57 0.0363974
R3684 VSS.t57 VSS.n204 0.0363974
R3685 VSS.n204 VSS.t55 0.0363974
R3686 VSS.t55 VSS.n202 0.0363974
R3687 VSS.n202 VSS.t53 0.0363974
R3688 VSS.t53 VSS.n200 0.0363974
R3689 VSS.n200 VSS.t51 0.0363974
R3690 VSS.t51 VSS.n198 0.0363974
R3691 VSS.n198 VSS.t49 0.0363974
R3692 VSS.t49 VSS.n197 0.0363974
R3693 VSS.n197 VSS.t47 0.0363974
R3694 VSS.t47 VSS.n196 0.0363974
R3695 VSS.n196 VSS.t39 0.0363974
R3696 VSS.n54 VSS.t162 0.0363974
R3697 VSS.t160 VSS.n54 0.0363974
R3698 VSS.n55 VSS.t160 0.0363974
R3699 VSS.t158 VSS.n55 0.0363974
R3700 VSS.n56 VSS.t158 0.0363974
R3701 VSS.t156 VSS.n56 0.0363974
R3702 VSS.n57 VSS.t156 0.0363974
R3703 VSS.t154 VSS.n57 0.0363974
R3704 VSS.n952 VSS.n951 0.0363125
R3705 VSS.n957 VSS.n956 0.0358741
R3706 VSS.n956 VSS.n955 0.0358741
R3707 VSS.n880 VSS.n879 0.03575
R3708 VSS.n312 VSS.n311 0.0356351
R3709 VSS.n311 VSS.n263 0.0356351
R3710 VSS.n899 VSS.n898 0.0356351
R3711 VSS.n900 VSS.n899 0.0356351
R3712 VSS.n347 VSS.n346 0.035375
R3713 VSS.n509 VSS.n241 0.034625
R3714 VSS.n913 VSS.n139 0.033875
R3715 VSS.n845 VSS.n844 0.033875
R3716 VSS.n348 VSS.n347 0.033875
R3717 VSS.n864 VSS.n863 0.032375
R3718 VSS.n335 VSS.n143 0.030125
R3719 VSS.n844 VSS.n177 0.0299375
R3720 VSS.n586 VSS.n585 0.029375
R3721 VSS.n927 VSS.n926 0.0288125
R3722 VSS.n772 VSS.n209 0.028625
R3723 VSS.n1001 VSS.n13 0.02825
R3724 VSS.n897 VSS.n149 0.0273125
R3725 VSS.n410 VSS.n409 0.026375
R3726 VSS.n413 VSS.n259 0.026375
R3727 VSS.n414 VSS.n257 0.026375
R3728 VSS.n418 VSS.n417 0.026375
R3729 VSS.n422 VSS.n255 0.026375
R3730 VSS.n423 VSS.n253 0.026375
R3731 VSS.n427 VSS.n426 0.026375
R3732 VSS.n430 VSS.n251 0.026375
R3733 VSS.n431 VSS.n249 0.026375
R3734 VSS.n435 VSS.n434 0.026375
R3735 VSS.n438 VSS.n247 0.026375
R3736 VSS.n440 VSS.n439 0.026375
R3737 VSS.n584 VSS.n244 0.026375
R3738 VSS.n583 VSS.n245 0.026375
R3739 VSS.n580 VSS.n579 0.026375
R3740 VSS.n575 VSS.n444 0.026375
R3741 VSS.n574 VSS.n451 0.026375
R3742 VSS.n571 VSS.n570 0.026375
R3743 VSS.n568 VSS.n567 0.026375
R3744 VSS.n564 VSS.n453 0.026375
R3745 VSS.n563 VSS.n455 0.026375
R3746 VSS.n560 VSS.n559 0.026375
R3747 VSS.n556 VSS.n458 0.026375
R3748 VSS.n555 VSS.n460 0.026375
R3749 VSS.n552 VSS.n551 0.026375
R3750 VSS.n548 VSS.n462 0.026375
R3751 VSS.n547 VSS.n464 0.026375
R3752 VSS.n544 VSS.n543 0.026375
R3753 VSS.n540 VSS.n466 0.026375
R3754 VSS.n539 VSS.n468 0.026375
R3755 VSS.n536 VSS.n535 0.026375
R3756 VSS.n532 VSS.n470 0.026375
R3757 VSS.n531 VSS.n472 0.026375
R3758 VSS.n528 VSS.n527 0.026375
R3759 VSS.n524 VSS.n474 0.026375
R3760 VSS.n523 VSS.n476 0.026375
R3761 VSS.n520 VSS.n519 0.026375
R3762 VSS.n516 VSS.n478 0.026375
R3763 VSS.n515 VSS.n480 0.026375
R3764 VSS.n512 VSS.n511 0.026375
R3765 VSS.n508 VSS.n482 0.026375
R3766 VSS.n507 VSS.n483 0.026375
R3767 VSS.n504 VSS.n503 0.026375
R3768 VSS.n500 VSS.n485 0.026375
R3769 VSS.n499 VSS.n494 0.026375
R3770 VSS.n496 VSS.n495 0.026375
R3771 VSS.n590 VSS.n237 0.026375
R3772 VSS.n591 VSS.n235 0.026375
R3773 VSS.n595 VSS.n594 0.026375
R3774 VSS.n598 VSS.n233 0.026375
R3775 VSS.n599 VSS.n231 0.026375
R3776 VSS.n603 VSS.n602 0.026375
R3777 VSS.n606 VSS.n229 0.026375
R3778 VSS.n607 VSS.n227 0.026375
R3779 VSS.n611 VSS.n610 0.026375
R3780 VSS.n615 VSS.n225 0.026375
R3781 VSS.n616 VSS.n223 0.026375
R3782 VSS.n620 VSS.n619 0.026375
R3783 VSS.n624 VSS.n221 0.026375
R3784 VSS.n625 VSS.n219 0.026375
R3785 VSS.n629 VSS.n628 0.026375
R3786 VSS.n632 VSS.n217 0.026375
R3787 VSS.n634 VSS.n633 0.026375
R3788 VSS.n798 VSS.n214 0.026375
R3789 VSS.n797 VSS.n215 0.026375
R3790 VSS.n794 VSS.n793 0.026375
R3791 VSS.n790 VSS.n638 0.026375
R3792 VSS.n789 VSS.n640 0.026375
R3793 VSS.n786 VSS.n785 0.026375
R3794 VSS.n783 VSS.n782 0.026375
R3795 VSS.n779 VSS.n642 0.026375
R3796 VSS.n778 VSS.n644 0.026375
R3797 VSS.n775 VSS.n774 0.026375
R3798 VSS.n771 VSS.n647 0.026375
R3799 VSS.n770 VSS.n648 0.026375
R3800 VSS.n767 VSS.n766 0.026375
R3801 VSS.n763 VSS.n650 0.026375
R3802 VSS.n762 VSS.n653 0.026375
R3803 VSS.n759 VSS.n758 0.026375
R3804 VSS.n756 VSS.n755 0.026375
R3805 VSS.n752 VSS.n655 0.026375
R3806 VSS.n751 VSS.n657 0.026375
R3807 VSS.n748 VSS.n747 0.026375
R3808 VSS.n744 VSS.n660 0.026375
R3809 VSS.n743 VSS.n661 0.026375
R3810 VSS.n740 VSS.n739 0.026375
R3811 VSS.n736 VSS.n663 0.026375
R3812 VSS.n735 VSS.n666 0.026375
R3813 VSS.n732 VSS.n731 0.026375
R3814 VSS.n728 VSS.n668 0.026375
R3815 VSS.n727 VSS.n669 0.026375
R3816 VSS.n724 VSS.n723 0.026375
R3817 VSS.n720 VSS.n671 0.026375
R3818 VSS.n719 VSS.n674 0.026375
R3819 VSS.n716 VSS.n715 0.026375
R3820 VSS.n713 VSS.n712 0.026375
R3821 VSS.n709 VSS.n676 0.026375
R3822 VSS.n708 VSS.n678 0.026375
R3823 VSS.n705 VSS.n704 0.026375
R3824 VSS.n701 VSS.n681 0.026375
R3825 VSS.n700 VSS.n682 0.026375
R3826 VSS.n697 VSS.n696 0.026375
R3827 VSS.n693 VSS.n684 0.026375
R3828 VSS.n692 VSS.n687 0.026375
R3829 VSS.n689 VSS.n688 0.026375
R3830 VSS.n812 VSS.n193 0.026375
R3831 VSS.n813 VSS.n191 0.026375
R3832 VSS.n817 VSS.n816 0.026375
R3833 VSS.n820 VSS.n189 0.026375
R3834 VSS.n821 VSS.n187 0.026375
R3835 VSS.n825 VSS.n824 0.026375
R3836 VSS.n829 VSS.n184 0.026375
R3837 VSS.n830 VSS.n182 0.026375
R3838 VSS.n834 VSS.n833 0.026375
R3839 VSS.n838 VSS.n180 0.026375
R3840 VSS.n839 VSS.n178 0.026375
R3841 VSS.n843 VSS.n842 0.026375
R3842 VSS.n754 VSS.n207 0.026375
R3843 VSS.n578 VSS.n577 0.026
R3844 VSS.n827 VSS.n826 0.025625
R3845 VSS.n79 VSS.n78 0.025625
R3846 VSS.n622 VSS.n218 0.024875
R3847 VSS.n924 VSS.n121 0.024125
R3848 VSS.n588 VSS.n234 0.024125
R3849 VSS.n847 VSS.n846 0.0239375
R3850 VSS.n951 VSS.n950 0.022625
R3851 VSS.n137 VSS.n136 0.0216875
R3852 VSS.n403 VSS.n222 0.0210534
R3853 VSS.n920 VSS.n919 0.0205625
R3854 VSS.n918 VSS.n917 0.0190625
R3855 VSS.n913 VSS.n912 0.0175625
R3856 VSS.n685 VSS.n199 0.017375
R3857 VSS.n40 VSS.n36 0.017375
R3858 VSS.n983 VSS.n982 0.0171875
R3859 VSS VSS.n1004 0.017
R3860 VSS.n729 VSS.n203 0.016625
R3861 VSS.n957 VSS.n110 0.01625
R3862 VSS.n935 VSS.n933 0.0155
R3863 VSS.n934 VSS.n116 0.0144596
R3864 VSS.n936 VSS.n116 0.0144596
R3865 VSS.n501 VSS.n492 0.014
R3866 VSS.n800 VSS.n799 0.0138125
R3867 VSS.n987 VSS.n16 0.013625
R3868 VSS VSS.n1018 0.01325
R3869 VSS.n898 VSS.n148 0.0130625
R3870 VSS.n566 VSS.n239 0.012125
R3871 VSS.n930 VSS.n118 0.0108125
R3872 VSS.n327 VSS.n326 0.01025
R3873 VSS.n420 VSS.n419 0.0100625
R3874 VSS.n8 VSS.n3 0.0095
R3875 VSS.n849 VSS.n848 0.008
R3876 VSS.n852 VSS.n173 0.008
R3877 VSS.n853 VSS.n171 0.008
R3878 VSS.n857 VSS.n856 0.008
R3879 VSS.n860 VSS.n169 0.008
R3880 VSS.n861 VSS.n166 0.008
R3881 VSS.n866 VSS.n865 0.008
R3882 VSS.n869 VSS.n164 0.008
R3883 VSS.n870 VSS.n162 0.008
R3884 VSS.n874 VSS.n873 0.008
R3885 VSS.n877 VSS.n160 0.008
R3886 VSS.n878 VSS.n157 0.008
R3887 VSS.n883 VSS.n882 0.008
R3888 VSS.n886 VSS.n155 0.008
R3889 VSS.n887 VSS.n153 0.008
R3890 VSS.n892 VSS.n890 0.008
R3891 VSS.n891 VSS.n150 0.008
R3892 VSS.n896 VSS.n895 0.008
R3893 VSS.n784 VSS.n211 0.007625
R3894 VSS.n664 VSS.n205 0.005375
R3895 VSS.n811 VSS.n810 0.004625
R3896 VSS.n94 VSS.n45 0.004625
R3897 VSS.n315 VSS.n310 0.00425
R3898 VSS.n344 VSS.n343 0.00425
R3899 VSS.n340 VSS.n316 0.00425
R3900 VSS.n339 VSS.n337 0.00425
R3901 VSS.n336 VSS.n318 0.00425
R3902 VSS.n333 VSS.n332 0.00425
R3903 VSS.n329 VSS.n320 0.00425
R3904 VSS.n328 VSS.n325 0.00425
R3905 VSS.n324 VSS.n0 0.00425
R3906 VSS.n1018 VSS.n1 0.00425
R3907 VSS.n1015 VSS.n1014 0.00425
R3908 VSS.n1011 VSS.n4 0.00425
R3909 VSS.n1010 VSS.n7 0.00425
R3910 VSS.n1007 VSS.n1006 0.00425
R3911 VSS.n1003 VSS.n10 0.00425
R3912 VSS.n1002 VSS.n12 0.00425
R3913 VSS.n999 VSS.n998 0.00425
R3914 VSS.n995 VSS.n15 0.00425
R3915 VSS.n994 VSS.n17 0.00425
R3916 VSS.n991 VSS.n990 0.00425
R3917 VSS.n989 VSS.n988 0.00425
R3918 VSS.n985 VSS.n19 0.00425
R3919 VSS.n984 VSS.n21 0.00425
R3920 VSS.n980 VSS.n979 0.00425
R3921 VSS.n976 VSS.n24 0.00425
R3922 VSS.n975 VSS.n26 0.00425
R3923 VSS.n972 VSS.n971 0.00425
R3924 VSS.n968 VSS.n28 0.00425
R3925 VSS.n967 VSS.n30 0.00425
R3926 VSS.n964 VSS.n963 0.00425
R3927 VSS.n960 VSS.n33 0.00425
R3928 VSS.n959 VSS.n35 0.00425
R3929 VSS.n109 VSS.n108 0.00425
R3930 VSS.n105 VSS.n37 0.00425
R3931 VSS.n104 VSS.n39 0.00425
R3932 VSS.n101 VSS.n100 0.00425
R3933 VSS.n97 VSS.n42 0.00425
R3934 VSS.n96 VSS.n44 0.00425
R3935 VSS.n93 VSS.n92 0.00425
R3936 VSS.n89 VSS.n46 0.00425
R3937 VSS.n88 VSS.n48 0.00425
R3938 VSS.n85 VSS.n84 0.00425
R3939 VSS.n81 VSS.n51 0.00425
R3940 VSS.n80 VSS.n53 0.00425
R3941 VSS.n76 VSS.n75 0.00425
R3942 VSS.n72 VSS.n59 0.00425
R3943 VSS.n71 VSS.n61 0.00425
R3944 VSS.n68 VSS.n67 0.00425
R3945 VSS.n386 VSS.n291 0.0035
R3946 VSS.n385 VSS.n292 0.0035
R3947 VSS.n382 VSS.n381 0.0035
R3948 VSS.n378 VSS.n294 0.0035
R3949 VSS.n377 VSS.n296 0.0035
R3950 VSS.n374 VSS.n373 0.0035
R3951 VSS.n370 VSS.n298 0.0035
R3952 VSS.n369 VSS.n300 0.0035
R3953 VSS.n366 VSS.n365 0.0035
R3954 VSS.n362 VSS.n302 0.0035
R3955 VSS.n361 VSS.n304 0.0035
R3956 VSS.n358 VSS.n357 0.0035
R3957 VSS.n354 VSS.n306 0.0035
R3958 VSS.n353 VSS.n308 0.0035
R3959 VSS.n350 VSS.n349 0.0035
R3960 VSS.n133 VSS.n126 0.0018125
R3961 VSS.n389 VSS.n388 0.000875
C0 a_41854_3547# a_41854_2387# 0.05596f
C1 vbn vbnf 0.01083f
C2 a_n4642_7514# a_n5234_7514# 0.88042f
C3 a_37178_3547# a_36888_1807# 0
C4 vbn a_36888_5287# 13.2616f
C5 a_n5128_6451# a_n5234_7514# 0.01134f
C6 a_n6436_6531# a_n7601_6703# 0.00463f
C7 a_n7180_6531# q1 0.00689f
C8 vctrl a_41854_2387# 0.3277f
C9 vg a_6356_6633# 1.06397f
C10 a_36888_6447# a_41564_6447# 4.1149f
C11 a_41854_1227# a_37178_1227# 4.04491f
C12 bitb0 a_6356_6633# 0.21396f
C13 a_37178_7027# a_41854_5867# 0.00115f
C14 a_n6694_7514# ck 0
C15 a_41854_3547# a_41564_2967# 2.37452f
C16 ck a_n8217_6703# 1.12832f
C17 vbn a_37178_5867# 12.4223f
C18 a_n7180_6531# a_n7601_6703# 0.04749f
C19 vctrl a_41564_2967# 0
C20 vg a_1632_6633# 0.4138f
C21 bitb4 bit4 0.79928f
C22 a_36888_6447# a_41854_7027# 0.03482f
C23 a_37178_7027# a_41564_6447# 2.88648f
C24 a_41854_1227# a_36888_1807# 2.91652f
C25 vbnf bit1 0.19681f
C26 a_41564_4127# a_41564_2967# 0.05596f
C27 VDD bit2 0.39961f
C28 bitb2 a_6206_4704# 0.21396f
C29 a_6206_896# bit4 0.00331f
C30 a_41854_1227# w_36826_300# 0.05949f
C31 VDD a_37178_8187# 0.00193f
C32 vg a_1867_7085# 0.52997f
C33 a_37178_7027# a_41854_7027# 4.03621f
C34 a_36888_7607# a_41564_6447# 0.00177f
C35 a_n7286_7514# ck 0
C36 vbn a_36888_6447# 13.2616f
C37 a_41564_4127# a_41854_3547# 2.37431f
C38 bitb2 a_7096_6633# 0.00121f
C39 a_6206_14# vbnf 9.72296f
C40 a_7096_6633# a_6206_4704# 3.99805f
C41 VDD a_60550_8387# 0.05007f
C42 bit0 bit1 0.02757f
C43 a_36888_7607# a_41854_7027# 2.91652f
C44 a_37178_7027# a_41564_7607# 0.03322f
C45 vbn a_37178_7027# 12.4252f
C46 a_41854_4707# a_41854_3547# 0.05596f
C47 ck a_n7872_8894# 0
C48 a_n3101_6703# a_n5234_7514# 0
C49 a_6356_6633# a_6206_4704# 0.20544f
C50 vbn a_36888_7607# 13.2849f
C51 a_36888_7607# a_41564_7607# 4.1149f
C52 a_37178_8187# a_41854_7027# 0.00115f
C53 a_41854_4707# a_41564_4127# 2.37452f
C54 vbnf bit3 0.19848f
C55 VDD a0 1.58817f
C56 VDD bit4 0.45851f
C57 VDD_LS ck 0.92368f
C58 a_6206_14# bit0 0
C59 a_6356_6633# a_7096_6633# 0.51329f
C60 a_6206_896# bitb1 0
C61 a_36888_7607# a_41854_8187# 0.03482f
C62 vbn a_37178_8187# 12.6636f
C63 a_37178_8187# a_41564_7607# 2.88648f
C64 a_41564_5287# a_41564_4127# 0.05596f
C65 a_996_6587# a_1632_6633# 0.37969f
C66 a_37178_8187# a_41854_8187# 4.07037f
C67 vbn a_60550_8387# 0.27863f
C68 a_41564_5287# a_41854_4707# 2.37431f
C69 bit1 bit2 0.02757f
C70 a_996_6587# a_1867_7085# 0.34397f
C71 vctrl a_6206_896# 0.30122f
C72 bitb3 bitb4 0.01415f
C73 vbnf vg 1.37475f
C74 vbnf bitb0 0.0727f
C75 VDD bitb1 0.69643f
C76 a_6206_14# bit2 0
C77 a_6206_896# bitb3 0.21489f
C78 a_1867_7085# a_1632_6633# 0.37174f
C79 bit2 bit3 0.02757f
C80 bit0 vg 0.02208f
C81 bitb0 bit0 0.79928f
C82 vbn a_41564_1807# 3.27202f
C83 VDD vctrl 0.0024f
C84 a_n4810_7514# a_n5549_6703# 0.01794f
C85 vbn a_41854_2387# 3.49251f
C86 vbnf bitb2 0.1755f
C87 VDD bitb3 0.69649f
C88 a_6206_14# bit4 0.05001f
C89 vbnf a_6206_4704# 11.0435f
C90 a_n6694_7514# a_n5549_6703# 0.00175f
C91 a_6206_896# bitb4 0.00214f
C92 a_41564_1807# a_37178_1227# 0.03322f
C93 vbn a_41564_2967# 3.48625f
C94 a_41854_4707# a_41854_5867# 0.05596f
C95 VDD a_452_6633# 1.2f
C96 VDD_LS a_996_6587# 0
C97 vbnf a_7096_6633# 4.66746f
C98 a_n6694_7514# a_n8217_6703# 0
C99 a_n3607_6703# a_n5549_6703# 0.02485f
C100 a_36888_2967# a_37178_2387# 10.9859f
C101 a_41564_1807# a_36888_1807# 4.00658f
C102 a_41564_5287# a_41854_5867# 2.37452f
C103 vbn a_41854_3547# 3.49251f
C104 bit3 bit4 0.02757f
C105 bitb1 bit1 0.79928f
C106 bit0 a_6206_4704# 0
C107 vbnf a_6356_6633# 1.13433f
C108 vbn vctrl 1.86478f
C109 a_n6862_7514# a_n6694_7514# 0.08507f
C110 a_n7286_7514# a_n4810_7514# 0
C111 a_n7286_7514# a_n5549_6703# 0.00223f
C112 a_37178_3547# a_37178_2387# 0.01838f
C113 a_41854_2387# a_36888_1807# 0.0269f
C114 vbn a_41564_4127# 3.48625f
C115 a_41564_5287# a_41564_6447# 0.05596f
C116 a_n7601_6703# q1 1.57175f
C117 bit0 a_7096_6633# 0.00884f
C118 a_n7286_7514# a_n6694_7514# 0.87554f
C119 VDD bitb4 0.69669f
C120 a_n7286_7514# a_n8217_6703# 0.00738f
C121 a_n4810_7514# a_n7872_8894# 0
C122 a_6206_14# bitb1 0
C123 a_n7872_8894# a_n5549_6703# 0.00156f
C124 a_37178_3547# a_36888_2967# 11.0476f
C125 a_36888_4127# a_37178_2387# 0
C126 vbn a_41854_4707# 3.49251f
C127 VDD a_6206_896# 0.21312f
C128 a_n5234_7514# q1 0.00721f
C129 a_41854_1227# a_37178_2387# 0
C130 bit0 a_6356_6633# 0.04998f
C131 vctrl a_37178_1227# 0.06613f
C132 a_n7286_7514# a_n6862_7514# 0.00388f
C133 a_n6694_7514# a_n7872_8894# 0
C134 a_n7872_8894# a_n8217_6703# 0
C135 a_36888_4127# a_36888_2967# 0.18664f
C136 VDD_LS a_n4810_7514# 0.23085f
C137 vbn a_41564_5287# 3.48625f
C138 VDD_LS a_n5549_6703# 0.58961f
C139 a_n5234_7514# a_n7601_6703# 0
C140 a0 vg 0.40525f
C141 bitb2 bit2 0.79928f
C142 vctrl a_36888_1807# 2.4556f
C143 a_n6862_7514# a_n7872_8894# 0
C144 bit2 a_6206_4704# 0.04998f
C145 a_n7872_8894# a_n3607_6703# 0
C146 a_36888_4127# a_37178_3547# 10.9862f
C147 a_37178_4707# a_36888_2967# 0
C148 vctrl a_6206_14# 0.19159f
C149 VDD_LS a_n6694_7514# 0.21816f
C150 VDD_LS a_n8217_6703# 0.37512f
C151 vctrl w_36826_300# 0.07808f
C152 a_n7286_7514# a_n7872_8894# 0
C153 a_37178_4707# a_37178_3547# 0.01838f
C154 VDD_LS a_n6862_7514# 0.14459f
C155 a_6206_14# bitb3 0
C156 VDD_LS a_n3607_6703# 0.39275f
C157 a_36888_5287# a_37178_3547# 0
C158 a_37178_4707# a_36888_4127# 11.0476f
C159 VDD_LS a_n7286_7514# 0.40251f
C160 a_n4384_6451# a_n5549_6703# 0.0061f
C161 ls a_n4810_7514# 0.02307f
C162 ls a_n5549_6703# 1.56506f
C163 a_n4642_7514# a_n4810_7514# 0.14135f
C164 a_41564_6447# a_41854_5867# 2.37431f
C165 bitb1 vg 0.00141f
C166 a_n4642_7514# a_n5549_6703# 0.70987f
C167 bitb3 bit3 0.79928f
C168 a_36888_5287# a_36888_4127# 0.18664f
C169 bitb0 bitb1 0.01415f
C170 bit4 a_6206_4704# 0
C171 VDD_LS a_n7872_8894# 2.59119f
C172 a_n5128_6451# a_n5549_6703# 0.07726f
C173 ls a_n6694_7514# 0
C174 a_6206_896# bit1 0.00331f
C175 a_n4642_7514# a_n6694_7514# 0.00248f
C176 a_41854_7027# a_41854_5867# 0.05596f
C177 a0 a_996_6587# 0.1634f
C178 a_37178_5867# a_36888_4127# 0
C179 a_36888_5287# a_37178_4707# 10.9862f
C180 a_6206_14# bitb4 0.21399f
C181 VDD vbn 0.61636f
C182 ls a_n3607_6703# 0.96168f
C183 a_41854_7027# a_41564_6447# 2.37452f
C184 a_n4642_7514# a_n3607_6703# 0.08987f
C185 vbn a_41854_5867# 3.49251f
C186 a_37178_5867# a_37178_4707# 0.01838f
C187 a_6206_896# a_6206_14# 8.81578f
C188 vctrl vg 1.00629f
C189 a_n6436_6531# a_n6694_7514# 0.00564f
C190 VDD a_41854_8187# 0.00481f
C191 vbn a_41564_6447# 3.48625f
C192 a_41564_7607# a_41564_6447# 0.05596f
C193 a_37178_5867# a_36888_5287# 11.0476f
C194 bitb4 bit3 1.85602f
C195 bitb1 bitb2 0.01415f
C196 a0 a_1632_6633# 0.00356f
C197 vbnf bit0 0.19018f
C198 VDD bit1 0.39958f
C199 a_37178_4707# a_36888_6447# 0
C200 ls a_n7872_8894# 0.33461f
C201 bitb1 a_6206_4704# 0
C202 a_6206_896# bit3 0.05328f
C203 vbn a_41854_7027# 3.49334f
C204 a_41564_7607# a_41854_7027# 2.37431f
C205 a_36888_7607# a_36866_9481# 0.17366f
C206 a_n6436_6531# a_n7286_7514# 0.04322f
C207 vg a_452_6633# 0.52714f
C208 a_n3101_6703# a_n5549_6703# 0
C209 q1 ck 0
C210 a_36888_5287# a_36888_6447# 0.18664f
C211 bitb1 a_7096_6633# 0.21396f
C212 VDD_LS a_n4384_6451# 0.00409f
C213 a_41854_8187# a_41854_7027# 0.05596f
C214 VDD_LS ls 1.22951f
C215 vbn a_41564_7607# 3.54873f
C216 a_37178_8187# a_36866_9481# 9.66738f
C217 VDD a_6206_14# 0.2224f
C218 a_n7180_6531# a_n7286_7514# 0.00757f
C219 a_n2245_6719# a_n3607_6703# 0.00588f
C220 VDD_LS a_n4642_7514# 0.26831f
C221 a_n7601_6703# ck 0.00938f
C222 a_36888_5287# a_37178_7027# 0
C223 a_37178_5867# a_36888_6447# 10.9862f
C224 VDD_LS a_n5128_6451# 0.00198f
C225 bitb1 a_6356_6633# 0.00121f
C226 vctrl a_6206_4704# 0.17004f
C227 a_41854_8187# a_41564_7607# 2.37452f
C228 vbn a_41854_8187# 6.27374f
C229 a_60550_8387# a_36866_9481# 0.14595f
C230 a_n3101_6703# a_n3607_6703# 1.04229f
C231 a_37178_5867# a_37178_7027# 0.01838f
C232 vbnf bit2 0.19681f
C233 VDD_LS a_n6436_6531# 0.00406f
C234 bitb2 bitb3 0.01415f
C235 vbn w_37991_300# 0.00346f
C236 VDD bit3 0.39972f
C237 vctrl a_7096_6633# 0.04912f
C238 bitb3 a_6206_4704# 0.00123f
C239 vbn a_37178_1227# 12.5272f
C240 a_6206_896# vg 3.03622f
C241 a_6206_896# bitb0 0
C242 a_n2245_6719# a_n7872_8894# 0.22692f
C243 a_37178_2387# a_41564_1807# 0.72603f
C244 a_37178_5867# a_36888_7607# 0
C245 VDD_LS a_n7180_6531# 0.00222f
C246 vctrl a_6356_6633# 3.22782f
C247 ls a_n4384_6451# 0.01106f
C248 vbn a_36888_1807# 13.1706f
C249 a_37178_7027# a_36888_6447# 11.0476f
C250 a_n3101_6703# a_n7872_8894# 0.00642f
C251 a_n4642_7514# a_n4384_6451# 0.00911f
C252 a_36888_2967# a_41564_1807# 0.00177f
C253 a_37178_2387# a_41854_2387# 3.97376f
C254 vbn w_36826_300# 6.10627f
C255 a_996_6587# a_452_6633# 0.39821f
C256 VDD_LS a_n2245_6719# 0.33992f
C257 ls a_n4642_7514# 0.63671f
C258 a0 a_n7872_8894# 0.00459f
C259 ls a_n5128_6451# 0.01045f
C260 a_36888_7607# a_36888_6447# 0.18664f
C261 a_36888_2967# a_41854_2387# 2.91652f
C262 a_37178_2387# a_41564_2967# 0.03322f
C263 VDD_LS a_n3101_6703# 0.28227f
C264 vbnf bit4 1.13336f
C265 a_36888_1807# a_37178_1227# 10.9861f
C266 a_36888_7607# a_37178_7027# 10.9862f
C267 a_37178_8187# a_36888_6447# 0
C268 VDD bitb0 0.78238f
C269 VDD_LS a0 0.0349f
C270 VDD vg 24.0577f
C271 a_6206_14# bit1 0
C272 bitb4 a_6206_4704# 0
C273 w_36826_300# w_37991_300# 0.09601f
C274 a_37178_3547# a_41854_2387# 0.00115f
C275 a_36888_2967# a_41564_2967# 4.1149f
C276 a_6206_896# bitb2 0.00104f
C277 w_36826_300# a_37178_1227# 12.307f
C278 a_6206_896# a_6206_4704# 4.47742f
C279 a_41854_1227# a_41564_1807# 2.37431f
C280 a_37178_2387# vctrl 8.43974f
C281 a_452_6633# a_1632_6633# 0.1528f
C282 a_37178_8187# a_37178_7027# 0.01838f
C283 a_36888_2967# a_41854_3547# 0.03482f
C284 a_37178_3547# a_41564_2967# 2.88648f
C285 w_36826_300# a_36888_1807# 0.1968f
C286 a_6206_896# a_7096_6633# 0.6087f
C287 a_41854_1227# a_41854_2387# 0.05596f
C288 a_36888_2967# vctrl 0.07604f
C289 a_452_6633# a_1867_7085# 0.02066f
C290 ls a_n2245_6719# 0
C291 a_37178_8187# a_36888_7607# 11.0477f
C292 a_36888_4127# a_41564_2967# 0.00177f
C293 a_37178_3547# a_41854_3547# 4.03621f
C294 a_n3101_6703# a_n4384_6451# 0
C295 a_6206_896# a_6356_6633# 3.25671f
C296 a_37178_3547# vctrl 0.01256f
C297 ls a_n3101_6703# 0.12117f
C298 a_60550_8387# a_36888_7607# 0.01558f
C299 vbnf bitb1 0.1755f
C300 a_n4642_7514# a_n3101_6703# 0
C301 a_37178_3547# a_41564_4127# 0.03322f
C302 a_36888_4127# a_41854_3547# 2.91652f
C303 VDD bitb2 0.69643f
C304 a_6206_14# bit3 0.00887f
C305 VDD a_6206_4704# 0.20804f
C306 a_36888_4127# vctrl 0.00108f
C307 a_60550_8387# a_37178_8187# 0.0117f
C308 a_37178_4707# a_41854_3547# 0.00115f
C309 a_36888_4127# a_41564_4127# 4.1149f
C310 a_41854_1227# vctrl 0.00174f
C311 VDD a_996_6587# 1.38472f
C312 VDD a_7096_6633# 0.19817f
C313 bit1 vg 0
C314 bitb1 bit0 1.85602f
C315 a_36888_4127# a_41854_4707# 0.03482f
C316 a_37178_4707# a_41564_4127# 2.88648f
C317 vctrl vbnf 3.18603f
C318 VDD a_6356_6633# 0.26171f
C319 q1 a_n5549_6703# 0.74328f
C320 a_37178_4707# a_41854_4707# 4.03621f
C321 a_36888_5287# a_41564_4127# 0.00177f
C322 vbnf bitb3 0.17647f
C323 a_n3101_6703# a_n2245_6719# 0.20859f
C324 q1 a_n6694_7514# 0.67113f
C325 VDD a_1632_6633# 1.51639f
C326 q1 a_n8217_6703# 0.00656f
C327 a_6206_14# vg 5.82132f
C328 a_n7601_6703# a_n5549_6703# 0.0098f
C329 a_6206_14# bitb0 0
C330 a_n2245_6719# a0 1.9857f
C331 a_36888_5287# a_41854_4707# 2.91652f
C332 a_37178_4707# a_41564_5287# 0.03322f
C333 a_n5234_7514# a_n4810_7514# 0.00509f
C334 a_n7601_6703# a_n6694_7514# 0.70254f
C335 q1 a_n6862_7514# 0.01095f
C336 VDD a_1867_7085# 1.30999f
C337 VDD_LS a_452_6633# 0
C338 a_n7601_6703# a_n8217_6703# 0.7483f
C339 a_n5234_7514# a_n5549_6703# 0.74379f
C340 a_37178_5867# a_41854_4707# 0.00115f
C341 a_36888_5287# a_41564_5287# 4.1149f
C342 bitb2 bit1 1.85602f
C343 a_n5234_7514# a_n6694_7514# 0
C344 a_n7601_6703# a_n6862_7514# 0.01101f
C345 q1 a_n7286_7514# 1.29375f
C346 bit1 a_6206_4704# 0.00886f
C347 a_37178_5867# a_41564_5287# 2.88648f
C348 a_n7601_6703# a_n7286_7514# 0.71835f
C349 q1 a_n7872_8894# 0.00168f
C350 a_n5234_7514# a_n3607_6703# 0.003f
C351 bit1 a_7096_6633# 0.04998f
C352 vbnf bitb4 0.17851f
C353 a_6206_14# bitb2 0
C354 a_6206_14# a_6206_4704# 7.70065f
C355 a_6206_896# vbnf 8.01765f
C356 a_n5234_7514# a_n7286_7514# 0.00334f
C357 a_n7601_6703# a_n7872_8894# 0.00167f
C358 a_41564_5287# a_36888_6447# 0.00177f
C359 VDD_LS q1 0.47949f
C360 VDD a_36866_9481# 28.8396f
C361 a_6206_14# a_7096_6633# 1.30715f
C362 a_n5234_7514# a_n7872_8894# 0
C363 bitb0 vg 1.37238f
C364 bitb3 bit2 1.85602f
C365 vbn a_37178_2387# 11.9387f
C366 VDD_LS a_n7601_6703# 0.45003f
C367 bit3 a_6206_4704# 0
C368 VDD a_n7872_8894# 0.02233f
C369 a_6206_14# a_6356_6633# 0.21414f
C370 a_6206_896# bit0 0.00331f
C371 vbn a_36888_2967# 13.2571f
C372 VDD_LS a_n5234_7514# 0.51666f
C373 VDD vbnf 5.68903f
C374 VDD VDD_LS 0.03331f
C375 a_41854_2387# a_41564_1807# 2.34764f
C376 a_36888_5287# a_41854_5867# 0.03482f
C377 a_37178_2387# a_37178_1227# 0
C378 vbn a_37178_3547# 12.4223f
C379 ls q1 0.00995f
C380 vbn a_36866_9481# 53.2906f
C381 a_41564_7607# a_36866_9481# 0
C382 a_41564_2967# a_41564_1807# 0.05596f
C383 a_n4642_7514# q1 0
C384 a_37178_2387# a_36888_1807# 10.222f
C385 a_37178_5867# a_41854_5867# 4.03621f
C386 vbn a_36888_4127# 13.2616f
C387 VDD bit0 0.40332f
C388 vg a_6206_4704# 2.53191f
C389 a_41854_8187# a_36866_9481# 1.20914f
C390 bitb0 a_6206_4704# 0
C391 a_41854_1227# vbn 3.47973f
C392 a_41564_2967# a_41854_2387# 2.37431f
C393 a_37178_2387# w_36826_300# 0.00101f
C394 a_6206_896# bit2 0.01215f
C395 a_36888_2967# a_36888_1807# 0.17041f
C396 vbn a_37178_4707# 12.4223f
C397 a_37178_5867# a_41564_6447# 0.03322f
C398 a_n4384_6451# a_n5234_7514# 0.07136f
C399 a_n6436_6531# q1 0.00604f
C400 vg a_996_6587# 0.4584f
C401 vctrl a_41564_1807# 4.74781f
C402 a0 a_452_6633# 0.60056f
C403 ls a_n5234_7514# 1.35416f
C404 vg a_7096_6633# 3.92909f
C405 bitb0 a_7096_6633# 0
C406 a_36888_6447# a_41854_5867# 2.91652f
C407 vctrl VSS 31.3915f
C408 vg VSS 14.71012f
C409 bit4 VSS 3.03991f
C410 bit3 VSS 3.61766f
C411 bit2 VSS 3.61644f
C412 bit1 VSS 3.61744f
C413 bit0 VSS 3.61508f
C414 bitb4 VSS 2.90376f
C415 bitb3 VSS 2.89511f
C416 bitb2 VSS 2.8943f
C417 bitb1 VSS 2.89514f
C418 bitb0 VSS 2.65122f
C419 a0 VSS 1.55052f
C420 ck VSS 3.68251f
C421 vbnf VSS 0.11644p
C422 ls VSS 4.21743f
C423 vbn VSS 0.18989p
C424 VDD_LS VSS 72.7929f
C425 VDD VSS 0.44834p
C426 a_41854_1227# VSS 3.93442f
C427 a_41564_1807# VSS 1.69719f
C428 a_41854_2387# VSS 1.65655f
C429 a_41564_2967# VSS 1.65198f
C430 a_41854_3547# VSS 1.65655f
C431 a_41564_4127# VSS 1.65198f
C432 a_41854_4707# VSS 1.65655f
C433 a_41564_5287# VSS 1.65198f
C434 a_41854_5867# VSS 1.65655f
C435 a_41564_6447# VSS 1.65198f
C436 a_41854_7027# VSS 1.65655f
C437 a_41564_7607# VSS 1.65198f
C438 a_41854_8187# VSS 2.25067f
C439 a_37178_1227# VSS 1.91496f
C440 a_36888_1807# VSS 3.9691f
C441 a_37178_2387# VSS 1.31364f
C442 a_36888_2967# VSS 3.9634f
C443 a_37178_3547# VSS 1.34623f
C444 a_36888_4127# VSS 3.96359f
C445 a_37178_4707# VSS 1.34623f
C446 a_36888_5287# VSS 3.96359f
C447 a_37178_5867# VSS 1.34623f
C448 a_36888_6447# VSS 3.96359f
C449 a_37178_7027# VSS 1.34623f
C450 a_36888_7607# VSS 3.95929f
C451 a_37178_8187# VSS 1.67149f
C452 a_60550_8387# VSS 0.65251f
C453 a_6206_14# VSS 24.4677f
C454 a_6206_896# VSS 15.2494f
C455 a_6206_4704# VSS 7.9423f
C456 a_7096_6633# VSS 3.80578f
C457 a_6356_6633# VSS 2.52234f
C458 a_1632_6633# VSS 0.27347f
C459 a_1867_7085# VSS 0.42661f
C460 a_452_6633# VSS 0.36118f
C461 a_996_6587# VSS 0.28496f
C462 a_n4384_6451# VSS 0.14599f
C463 a_n5128_6451# VSS 0.14869f
C464 a_n6436_6531# VSS 0.09609f
C465 a_n7180_6531# VSS 0.09795f
C466 a_n2245_6719# VSS 1.45122f
C467 a_n3101_6703# VSS 0.65272f
C468 a_n4642_7514# VSS 0.56414f
C469 a_n4810_7514# VSS 0.01195f
C470 a_n6694_7514# VSS 0.47458f
C471 a_n6862_7514# VSS 0.01275f
C472 a_n7286_7514# VSS 0.51067f
C473 q1 VSS 0.88857f
C474 a_n7601_6703# VSS 1.00618f
C475 a_n5234_7514# VSS 0.52691f
C476 a_n5549_6703# VSS 1.00806f
C477 a_n8217_6703# VSS 0.82236f
C478 a_n3607_6703# VSS 0.69051f
C479 a_36866_9481# VSS 12.6032f
C480 a_n7872_8894# VSS 7.24156f
C481 w_37991_300# VSS 0.66986f
C482 w_36826_300# VSS 11.6672f
C483 VDD.n0 VSS 0.09949f
C484 VDD.n1 VSS 0.03049f
C485 VDD.t3 VSS 0.12109f
C486 VDD.n2 VSS 0.06099f
C487 VDD.n3 VSS 0.03049f
C488 VDD.n4 VSS 0.09949f
C489 VDD.n5 VSS 0.03049f
C490 VDD.n6 VSS 0.06099f
C491 VDD.n7 VSS 0.03049f
C492 VDD.n8 VSS 0.09949f
C493 VDD.n9 VSS 0.03049f
C494 VDD.n10 VSS 0.06099f
C495 VDD.n11 VSS 0.03049f
C496 VDD.n12 VSS 0.09949f
C497 VDD.n13 VSS 0.03049f
C498 VDD.n14 VSS 0.06099f
C499 VDD.n15 VSS 0.03049f
C500 VDD.n16 VSS 0.09949f
C501 VDD.n17 VSS 0.03049f
C502 VDD.t7 VSS 0.0249f
C503 VDD.t5 VSS 0.0249f
C504 VDD.n18 VSS 0.0974f
C505 VDD.n19 VSS 0.05343f
C506 VDD.n20 VSS 0.03049f
C507 VDD.n21 VSS 0.09949f
C508 VDD.n22 VSS 0.03049f
C509 VDD.n23 VSS 0.06099f
C510 VDD.n24 VSS 0.03049f
C511 VDD.n25 VSS 0.09949f
C512 VDD.n26 VSS 0.03049f
C513 VDD.n27 VSS 0.06099f
C514 VDD.n28 VSS 0.03049f
C515 VDD.n29 VSS 0.09949f
C516 VDD.n30 VSS 0.03049f
C517 VDD.n31 VSS 0.06099f
C518 VDD.n32 VSS 0.03049f
C519 VDD.n33 VSS 0.09949f
C520 VDD.n34 VSS 0.03049f
C521 VDD.n35 VSS 0.06099f
C522 VDD.n36 VSS 0.03049f
C523 VDD.n37 VSS 0.09949f
C524 VDD.n38 VSS 0.03049f
C525 VDD.t11 VSS 0.0249f
C526 VDD.t9 VSS 0.0249f
C527 VDD.n39 VSS 0.0974f
C528 VDD.n40 VSS 0.05198f
C529 VDD.n41 VSS 0.03049f
C530 VDD.n42 VSS 0.09949f
C531 VDD.n43 VSS 0.03049f
C532 VDD.n44 VSS 0.06099f
C533 VDD.n45 VSS 0.03049f
C534 VDD.n46 VSS 0.09949f
C535 VDD.n47 VSS 0.03049f
C536 VDD.n48 VSS 0.06099f
C537 VDD.n49 VSS 0.03049f
C538 VDD.n50 VSS 0.09949f
C539 VDD.n51 VSS 0.03049f
C540 VDD.n52 VSS 0.06099f
C541 VDD.n53 VSS 0.03049f
C542 VDD.n54 VSS 0.09949f
C543 VDD.n55 VSS 0.03049f
C544 VDD.n56 VSS 0.06099f
C545 VDD.n57 VSS 0.03049f
C546 VDD.n58 VSS 0.09949f
C547 VDD.n59 VSS 0.03049f
C548 VDD.t15 VSS 0.0249f
C549 VDD.t13 VSS 0.0249f
C550 VDD.n60 VSS 0.0974f
C551 VDD.n61 VSS 0.06099f
C552 VDD.n62 VSS 0.03049f
C553 VDD.n63 VSS 0.09949f
C554 VDD.n64 VSS 0.03049f
C555 VDD.n65 VSS 0.06099f
C556 VDD.n66 VSS 0.03049f
C557 VDD.n67 VSS 0.09949f
C558 VDD.n68 VSS 0.03049f
C559 VDD.n69 VSS 0.06099f
C560 VDD.n70 VSS 0.03049f
C561 VDD.n71 VSS 0.09949f
C562 VDD.n72 VSS 0.03049f
C563 VDD.n73 VSS 0.06099f
C564 VDD.n74 VSS 0.03049f
C565 VDD.n75 VSS 0.09949f
C566 VDD.n76 VSS 0.03049f
C567 VDD.n77 VSS 0.06099f
C568 VDD.n78 VSS 0.03049f
C569 VDD.n79 VSS 0.33029f
C570 VDD.n80 VSS 0.03049f
C571 VDD.t17 VSS 0.12109f
C572 VDD.t25 VSS 0.00292f
C573 VDD.n81 VSS 0.15058f
C574 VDD.n82 VSS 0.1474f
C575 VDD.n83 VSS 0.04745f
C576 VDD.n84 VSS 0.04307f
C577 VDD.n85 VSS 0.05997f
C578 VDD.n86 VSS 0.04094f
C579 VDD.n87 VSS 0.03049f
C580 VDD.n88 VSS 0.03049f
C581 VDD.n89 VSS 0.09949f
C582 VDD.n90 VSS 0.09949f
C583 VDD.n91 VSS 0.03049f
C584 VDD.n92 VSS 0.03049f
C585 VDD.n93 VSS 0.06099f
C586 VDD.n94 VSS 0.06099f
C587 VDD.n95 VSS 0.03049f
C588 VDD.n96 VSS 0.03049f
C589 VDD.n97 VSS 0.09949f
C590 VDD.n98 VSS 0.09949f
C591 VDD.n99 VSS 0.03049f
C592 VDD.n100 VSS 0.03049f
C593 VDD.n101 VSS 0.06099f
C594 VDD.n102 VSS 0.06099f
C595 VDD.n103 VSS 0.03049f
C596 VDD.n104 VSS 0.03049f
C597 VDD.n105 VSS 0.09949f
C598 VDD.n106 VSS 0.09949f
C599 VDD.n107 VSS 0.03049f
C600 VDD.n108 VSS 0.03049f
C601 VDD.n109 VSS 0.06099f
C602 VDD.n110 VSS 0.06099f
C603 VDD.n111 VSS 0.03049f
C604 VDD.n112 VSS 0.03049f
C605 VDD.n113 VSS 0.09949f
C606 VDD.n114 VSS 0.09949f
C607 VDD.n115 VSS 0.03049f
C608 VDD.n116 VSS 0.03049f
C609 VDD.n117 VSS 0.06099f
C610 VDD.n118 VSS 0.06099f
C611 VDD.n119 VSS 0.03049f
C612 VDD.n120 VSS 0.03049f
C613 VDD.n121 VSS 0.09949f
C614 VDD.n122 VSS 0.09949f
C615 VDD.n123 VSS 0.03049f
C616 VDD.n124 VSS 0.03049f
C617 VDD.n125 VSS 0.0369f
C618 VDD.n126 VSS 0.05343f
C619 VDD.n127 VSS 0.05459f
C620 VDD.n128 VSS 0.03049f
C621 VDD.n129 VSS 0.03049f
C622 VDD.n130 VSS 0.09949f
C623 VDD.n131 VSS 0.09949f
C624 VDD.n132 VSS 0.03049f
C625 VDD.n133 VSS 0.03049f
C626 VDD.n134 VSS 0.06099f
C627 VDD.n135 VSS 0.06099f
C628 VDD.n136 VSS 0.03049f
C629 VDD.n137 VSS 0.03049f
C630 VDD.n138 VSS 0.09949f
C631 VDD.n139 VSS 0.09949f
C632 VDD.n140 VSS 0.03049f
C633 VDD.n141 VSS 0.03049f
C634 VDD.n142 VSS 0.06099f
C635 VDD.n143 VSS 0.06099f
C636 VDD.n144 VSS 0.03049f
C637 VDD.n145 VSS 0.03049f
C638 VDD.n146 VSS 0.09949f
C639 VDD.n147 VSS 0.09949f
C640 VDD.n148 VSS 0.03049f
C641 VDD.n149 VSS 0.03049f
C642 VDD.n150 VSS 0.06099f
C643 VDD.n151 VSS 0.06099f
C644 VDD.n152 VSS 0.03049f
C645 VDD.n153 VSS 0.03049f
C646 VDD.n154 VSS 0.09949f
C647 VDD.n155 VSS 0.09949f
C648 VDD.n156 VSS 0.03049f
C649 VDD.n157 VSS 0.03049f
C650 VDD.n158 VSS 0.06099f
C651 VDD.t24 VSS 1.21103f
C652 VDD.t16 VSS 2.59807f
C653 VDD.t14 VSS 3.0692f
C654 VDD.t12 VSS 3.0692f
C655 VDD.t10 VSS 2.1496f
C656 VDD.t2 VSS 3.19989f
C657 VDD.t4 VSS 3.0692f
C658 VDD.t6 VSS 3.0692f
C659 VDD.t8 VSS 2.4542f
C660 VDD.n159 VSS 1.24415f
C661 VDD.n160 VSS -0.26697f
C662 VDD.n161 VSS 0.03194f
C663 VDD.n162 VSS 0.06099f
C664 VDD.n163 VSS 0.03049f
C665 VDD.n164 VSS 0.03049f
C666 VDD.n165 VSS 0.09949f
C667 VDD.n166 VSS 0.09949f
C668 VDD.n167 VSS 0.03049f
C669 VDD.n168 VSS 0.03049f
C670 VDD.n169 VSS 0.03751f
C671 VDD.n170 VSS 0.06099f
C672 VDD.n171 VSS 0.03049f
C673 VDD.n172 VSS 0.03049f
C674 VDD.n173 VSS 0.09949f
C675 VDD.n174 VSS 0.09949f
C676 VDD.n175 VSS 0.03049f
C677 VDD.n176 VSS 0.03049f
C678 VDD.n177 VSS 0.06099f
C679 VDD.n178 VSS 0.06099f
C680 VDD.n179 VSS 0.03049f
C681 VDD.n180 VSS 0.03049f
C682 VDD.n181 VSS 0.09949f
C683 VDD.n182 VSS 0.09949f
C684 VDD.n183 VSS 0.03049f
C685 VDD.n184 VSS 0.03049f
C686 VDD.n185 VSS 0.06099f
C687 VDD.n186 VSS 0.06099f
C688 VDD.n187 VSS 0.03049f
C689 VDD.n188 VSS 0.03049f
C690 VDD.n189 VSS 0.09949f
C691 VDD.n190 VSS 0.09949f
C692 VDD.n191 VSS 0.03049f
C693 VDD.n192 VSS 0.03049f
C694 VDD.n193 VSS 0.06099f
C695 VDD.n194 VSS 0.06099f
C696 VDD.n195 VSS 0.03049f
C697 VDD.n196 VSS 0.03049f
C698 VDD.n197 VSS 0.09949f
C699 VDD.n198 VSS 0.09949f
C700 VDD.n199 VSS 0.03049f
C701 VDD.n200 VSS 0.03049f
C702 VDD.n201 VSS 0.06099f
C703 VDD.n202 VSS 0.04056f
C704 VDD.n203 VSS 0.06099f
C705 VDD.n204 VSS 0.03049f
C706 VDD.n205 VSS 0.03049f
C707 VDD.n206 VSS 0.09949f
C708 VDD.n207 VSS 0.09949f
C709 VDD.n208 VSS 0.03049f
C710 VDD.n209 VSS 0.03049f
C711 VDD.n210 VSS 0.05093f
C712 VDD.n211 VSS 0.06099f
C713 VDD.n212 VSS 0.03049f
C714 VDD.n213 VSS 0.03049f
C715 VDD.n214 VSS 0.09949f
C716 VDD.n215 VSS 0.09949f
C717 VDD.n216 VSS 0.03049f
C718 VDD.n217 VSS 0.03049f
C719 VDD.n218 VSS 0.06099f
C720 VDD.n219 VSS 0.06099f
C721 VDD.n220 VSS 0.03049f
C722 VDD.n221 VSS 0.03049f
C723 VDD.n222 VSS 0.09949f
C724 VDD.n223 VSS 0.09949f
C725 VDD.n224 VSS 0.03049f
C726 VDD.n225 VSS 0.03049f
C727 VDD.n226 VSS 0.06099f
C728 VDD.n227 VSS 0.06099f
C729 VDD.n228 VSS 0.03049f
C730 VDD.n229 VSS 0.03049f
C731 VDD.n230 VSS 0.09949f
C732 VDD.n231 VSS 0.09949f
C733 VDD.n232 VSS 0.03049f
C734 VDD.n233 VSS 0.03049f
C735 VDD.n234 VSS 0.06099f
C736 VDD.n235 VSS 0.06099f
C737 VDD.n236 VSS 0.03049f
C738 VDD.n237 VSS 0.03049f
C739 VDD.n238 VSS 0.09949f
C740 VDD.n239 VSS 0.09949f
C741 VDD.n240 VSS 0.03049f
C742 VDD.n241 VSS 0.03049f
C743 VDD.n242 VSS 0.03049f
C744 VDD.n243 VSS 0.06099f
C745 VDD.n244 VSS 0.05741f
C746 VDD.n245 VSS 0.07633f
C747 VDD.n246 VSS 0.05736f
C748 VDD.n247 VSS 2.45193f
C749 VDD.n248 VSS 0.03354f
C750 VDD.n249 VSS 0.03354f
C751 VDD.n250 VSS 0.27903f
C752 VDD.n251 VSS 0.06099f
C753 VDD.n252 VSS 0.06099f
C754 VDD.n253 VSS 0.06099f
C755 VDD.n254 VSS 0.06099f
C756 VDD.n255 VSS 0.06099f
C757 VDD.n256 VSS 0.06099f
C758 VDD.n257 VSS 0.06008f
C759 VDD.n258 VSS 0.21262f
C760 VDD.t35 VSS 0.10609f
C761 VDD.n259 VSS 0.21262f
C762 VDD.t37 VSS 0.17282f
C763 VDD.t39 VSS 0.33645f
C764 VDD.n260 VSS 0.17941f
C765 VDD.n261 VSS 0.17102f
C766 VDD.t38 VSS 2.11457f
C767 VDD.t36 VSS 1.86721f
C768 VDD.t34 VSS 1.40041f
C769 VDD.t28 VSS 2.11457f
C770 VDD.t30 VSS 1.86721f
C771 VDD.t32 VSS 1.40041f
C772 VDD.n262 VSS 0.86354f
C773 VDD.t33 VSS 0.10609f
C774 VDD.n263 VSS 0.21262f
C775 VDD.t29 VSS 0.33645f
C776 VDD.t31 VSS 0.17282f
C777 VDD.n264 VSS 0.17941f
C778 VDD.n265 VSS 0.17102f
C779 VDD.n266 VSS 0.13341f
C780 VDD.n267 VSS 0.03141f
C781 VDD.n268 VSS 0.06099f
C782 VDD.n269 VSS 0.06099f
C783 VDD.n270 VSS 0.04063f
C784 VDD.n271 VSS 0.06099f
C785 VDD.t21 VSS 0.03408f
C786 VDD.n272 VSS 0.05391f
C787 VDD.t41 VSS 0.03408f
C788 VDD.t44 VSS 0.03408f
C789 VDD.t1 VSS 0.03408f
C790 VDD.n273 VSS 0.05391f
C791 VDD.n274 VSS 0.15407f
C792 VDD.t27 VSS 0.03408f
C793 VDD.n275 VSS 0.16711f
C794 VDD.n276 VSS 0.03644f
C795 VDD.n277 VSS 0.06099f
C796 VDD.n278 VSS 0.05504f
C797 VDD.n279 VSS 0.03049f
C798 VDD.n280 VSS 0.1195f
C799 VDD.n281 VSS 0.07076f
C800 VDD.n283 VSS 0.16711f
C801 VDD.n284 VSS 0.14443f
C802 VDD.t23 VSS 0.31614f
C803 VDD.t42 VSS 0.42077f
C804 VDD.t18 VSS 0.42077f
C805 VDD.t19 VSS 0.42077f
C806 VDD.t22 VSS 0.67038f
C807 VDD.n285 VSS 1.13493f
C808 VDD.t20 VSS 0.82277f
C809 VDD.t40 VSS 0.29567f
C810 VDD.t43 VSS 0.31273f
C811 VDD.t0 VSS 0.33548f
C812 VDD.t26 VSS 0.27179f
C813 VDD.n286 VSS 0.13988f
C814 VDD.n287 VSS 0.07076f
C815 VDD.n288 VSS 0.01469f
C816 VDD.n289 VSS 0.07526f
C817 VDD.n290 VSS 0.06864f
C818 VDD.n291 VSS 0.05741f
C819 VDD.n292 VSS 0.03118f
C820 VDD.n293 VSS 0.06099f
C821 VDD.n294 VSS 0.06099f
C822 VDD.n295 VSS 0.03187f
C823 VDD.n296 VSS 0.05391f
C824 VDD.n297 VSS 0.03964f
C825 VDD.n298 VSS 0.05391f
C826 VDD.n299 VSS 0.03964f
C827 VDD.n300 VSS 0.06099f
C828 VDD.n301 VSS 0.06099f
C829 VDD.n302 VSS 0.06099f
C830 VDD.n303 VSS 0.06099f
C831 VDD.n304 VSS 0.06099f
C832 VDD.n305 VSS 0.06099f
C833 VDD.n306 VSS 0.06008f
C834 VDD.n307 VSS 0.42183f
C835 VDD.n308 VSS 0.44164f
C836 VDD.n309 VSS 0.44045f
C837 VDD.n310 VSS 0.03141f
C838 VDD.n311 VSS 0.06099f
C839 VDD.n312 VSS 0.06099f
C840 VDD.n313 VSS 0.06099f
C841 VDD.n314 VSS 0.06099f
C842 VDD.n315 VSS 0.06099f
C843 VDD.n316 VSS 0.06099f
C844 VDD.n317 VSS 0.06099f
C845 VDD.n318 VSS 0.06099f
C846 VDD.n319 VSS 0.06099f
C847 VDD.n320 VSS 0.06099f
C848 VDD.n321 VSS 0.06099f
C849 VDD.n322 VSS 0.06099f
C850 VDD.n323 VSS 0.06099f
C851 VDD.n324 VSS 0.06099f
C852 VDD.n325 VSS 0.06099f
C853 VDD.n326 VSS 0.03598f
C854 VDD.n327 VSS 0.14185f
C855 VDD.n328 VSS 0.93573f
C856 VDD.n329 VSS 0.67963f
C857 VDD.n331 VSS 0.03354f
C858 VDD.n334 VSS 0.03283f
C859 VDD.n338 VSS 0.03283f
C860 VDD.n340 VSS 0.03283f
C861 VDD.n342 VSS 0.10596f
C862 VDD.n344 VSS 0.03354f
C863 VDD.n346 VSS 0.03283f
C864 VDD.n347 VSS 0.03278f
C865 VDD.n348 VSS 0.65439f
C866 VDD_LS.n0 VSS 0.00497f
C867 VDD_LS.n1 VSS 0.01515f
C868 VDD_LS.t1 VSS 0.00345f
C869 VDD_LS.t24 VSS 0.0021f
C870 VDD_LS.n2 VSS 0.01192f
C871 VDD_LS.n3 VSS 0.01515f
C872 VDD_LS.t26 VSS 0
C873 VDD_LS.t9 VSS 0
C874 VDD_LS.n4 VSS 0.0016f
C875 VDD_LS.t3 VSS 0.00169f
C876 VDD_LS.n5 VSS 0.01191f
C877 VDD_LS.n6 VSS 0.01515f
C878 VDD_LS.t5 VSS 0.0021f
C879 VDD_LS.t7 VSS 0
C880 VDD_LS.t18 VSS 0
C881 VDD_LS.n7 VSS 0.00266f
C882 VDD_LS.n8 VSS 0.01101f
C883 VDD_LS.n9 VSS 0.01515f
C884 VDD_LS.t12 VSS 0.00279f
C885 VDD_LS.t16 VSS 0.00409f
C886 VDD_LS.n10 VSS 0.01207f
C887 VDD_LS.t14 VSS 0.00143f
C888 VDD_LS.n11 VSS 0.13444f
C889 VDD_LS.t21 VSS 0.0021f
C890 VDD_LS.n12 VSS 0.02854f
C891 VDD_LS.n13 VSS 0.00958f
C892 VDD_LS.n14 VSS 0.07974f
C893 VDD_LS.n15 VSS 0.01515f
C894 VDD_LS.n16 VSS 0.012f
C895 VDD_LS.n17 VSS 0.01195f
C896 VDD_LS.n18 VSS 0.00805f
C897 VDD_LS.t22 VSS 0.07721f
C898 VDD_LS.t13 VSS 0.06898f
C899 VDD_LS.t20 VSS 0.06092f
C900 VDD_LS.t15 VSS 0.05099f
C901 VDD_LS.t11 VSS 0.04921f
C902 VDD_LS.t19 VSS 0.02263f
C903 VDD_LS.t0 VSS 0.05064f
C904 VDD_LS.t23 VSS 0.05019f
C905 VDD_LS.t8 VSS 0.02836f
C906 VDD_LS.t25 VSS 0.01503f
C907 VDD_LS.t10 VSS 0.02836f
C908 VDD_LS.t2 VSS 0.05591f
C909 VDD_LS.t4 VSS 0.05591f
C910 VDD_LS.t17 VSS 0.02836f
C911 VDD_LS.t6 VSS 0.01324f
C912 VDD_LS.n19 VSS -0.01454f
C913 VDD_LS.n20 VSS -0.01448f
C914 VDD_LS.n21 VSS 0.00401f
C915 VDD_LS.n22 VSS 0.01515f
C916 VDD_LS.n23 VSS 0.01515f
C917 VDD_LS.n24 VSS 0.00888f
C918 VDD_LS.n25 VSS 0.01192f
C919 VDD_LS.n26 VSS 0.01036f
C920 VDD_LS.n27 VSS 0.01513f
C921 VDD_LS.n28 VSS 0.01515f
C922 VDD_LS.n29 VSS 0.01515f
C923 VDD_LS.n30 VSS 0.00759f
C924 VDD_LS.n31 VSS 0.01204f
C925 VDD_LS.n32 VSS 0.01135f
C926 VDD_LS.n33 VSS 0.00888f
C927 VDD_LS.n34 VSS 0.01515f
C928 VDD_LS.n35 VSS 0.01515f
C929 VDD_LS.n36 VSS 0.00937f
C930 VDD_LS.n37 VSS 0.01369f
C931 VDD_LS.n38 VSS 0.01644f
C932 VDD_LS.n39 VSS 0.05579f
C933 VDD_LS.n40 VSS 0.00279f
C934 VDD_LS.t27 VSS 1.15577f
C935 VDD_LS.n41 VSS 0.39006f
C936 VDD_LS.n42 VSS 0.00191f
C937 VDD_LS.n43 VSS 0.00505f
C938 VDD_LS.n44 VSS 0.00213f
C939 VDD_LS.n45 VSS 0.00505f
C940 VDD_LS.n46 VSS 0.00505f
C941 VDD_LS.n47 VSS 0.00193f
C942 VDD_LS.t28 VSS 1.15577f
C943 VDD_LS.n48 VSS 0.00239f
C944 VDD_LS.n49 VSS 0.00151f
C945 VDD_LS.n50 VSS 0.0016f
C946 VDD_LS.n51 VSS 0.00505f
C947 VDD_LS.n52 VSS 0.00244f
C948 VDD_LS.n53 VSS 0.00151f
C949 VDD_LS.n54 VSS 0.00239f
C950 VDD_LS.n55 VSS 0.00181f
C951 VDD_LS.n56 VSS 0.00505f
C952 VDD_LS.n57 VSS 0.00505f
C953 VDD_LS.n58 VSS 0.00223f
C954 VDD_LS.n59 VSS 0.00173f
C955 VDD_LS.t29 VSS 1.15577f
C956 VDD_LS.n60 VSS 0.39006f
C957 VDD_LS.n61 VSS 0.00151f
C958 VDD_LS.n62 VSS 0.00616f
C959 VDD_LS.n63 VSS 0.00505f
C960 VDD_LS.n64 VSS 0.00523f
C961 VDD_LS.n65 VSS 0.00153f
C962 VDD_LS.t30 VSS 1.15577f
C963 VDD_LS.n66 VSS 0.00525f
C964 VDD_LS.n67 VSS 0.00151f
C965 VDD_LS.n68 VSS 0.00505f
C966 VDD_LS.n69 VSS 0.00151f
C967 VDD_LS.n70 VSS 0.00239f
C968 VDD_LS.t31 VSS 1.15577f
C969 VDD_LS.n71 VSS 0.39123f
C970 VDD_LS.n72 VSS 0.02111f
C971 VDD_LS.n73 VSS 0.02576f
C972 VDD_LS.n74 VSS 0.00375f
C973 VDD_LS.n75 VSS 0.0017f
C974 VDD_LS.n76 VSS 0.00384f
C975 VDD_LS.n77 VSS 0.00505f
C976 VDD_LS.n78 VSS 0.00372f
C977 VDD_LS.n79 VSS 0.00615f
C978 VDD_LS.n80 VSS 0.00505f
C979 VDD_LS.n81 VSS 0.00505f
C980 VDD_LS.n82 VSS 0.00243f
C981 VDD_LS.n83 VSS 0.00252f
C982 VDD_LS.n84 VSS 0.00352f
C983 VDD_LS.n85 VSS 0.39006f
C984 VDD_LS.n86 VSS 0.00352f
C985 VDD_LS.n87 VSS 0.00251f
C986 VDD_LS.n88 VSS 0.00241f
C987 VDD_LS.n89 VSS 0.00505f
C988 VDD_LS.n90 VSS 0.00505f
C989 VDD_LS.n91 VSS 0.00505f
C990 VDD_LS.n92 VSS 0.00375f
C991 VDD_LS.n93 VSS 0.00505f
C992 VDD_LS.n94 VSS 0.00384f
C993 VDD_LS.n95 VSS 0.00239f
C994 VDD_LS.n96 VSS 0.00231f
C995 VDD_LS.n97 VSS 0.00151f
C996 VDD_LS.n98 VSS 0.00505f
C997 VDD_LS.n99 VSS 0.00505f
C998 VDD_LS.n100 VSS 0.00151f
C999 VDD_LS.n101 VSS 0.00252f
C1000 VDD_LS.n102 VSS 0.00384f
C1001 VDD_LS.n103 VSS 0.00505f
C1002 VDD_LS.n104 VSS 0.00424f
C1003 VDD_LS.n105 VSS 0.00384f
C1004 VDD_LS.n106 VSS 0.00505f
C1005 VDD_LS.n107 VSS 0.00151f
C1006 VDD_LS.n108 VSS 0.00505f
C1007 VDD_LS.n109 VSS 0.00505f
C1008 VDD_LS.n110 VSS 0.00151f
C1009 VDD_LS.n111 VSS 0.00252f
C1010 VDD_LS.n112 VSS 0.39006f
C1011 VDD_LS.n113 VSS 0.00239f
C1012 VDD_LS.n114 VSS 0.00384f
C1013 VDD_LS.n115 VSS 0.00211f
C1014 VDD_LS.n116 VSS 0.00151f
C1015 VDD_LS.n117 VSS 0.00505f
C1016 VDD_LS.n118 VSS 0.00505f
C1017 VDD_LS.n119 VSS 0.00413f
C1018 VDD_LS.n120 VSS 0.00641f
C1019 VDD_LS.n121 VSS 0.00352f
C1020 VDD_LS.n122 VSS 0.00474f
C1021 VDD_LS.n123 VSS 0.00227f
C1022 VDD_LS.n124 VSS 0.00505f
C1023 VDD_LS.n125 VSS 0.00505f
C1024 VDD_LS.n126 VSS 0.00151f
C1025 VDD_LS.n127 VSS 0.00252f
C1026 VDD_LS.n128 VSS 0.00352f
C1027 VDD_LS.n129 VSS 0.01152f
C1028 VDD_LS.n130 VSS 0.07434f
C1029 vbn.t4 VSS 0.03398f
C1030 vbn.n0 VSS 0.06559f
C1031 vbn.t35 VSS 0.20032f
C1032 vbn.t49 VSS 0.26168f
C1033 vbn.t63 VSS 0.26168f
C1034 vbn.t77 VSS 0.26168f
C1035 vbn.t91 VSS 0.26168f
C1036 vbn.t105 VSS 0.26168f
C1037 vbn.t119 VSS 0.26168f
C1038 vbn.t133 VSS 0.26168f
C1039 vbn.t147 VSS 0.26168f
C1040 vbn.t161 VSS 0.26168f
C1041 vbn.t175 VSS 0.26168f
C1042 vbn.t189 VSS 0.26168f
C1043 vbn.t203 VSS 0.26168f
C1044 vbn.t217 VSS 0.22378f
C1045 vbn.t36 VSS 0.20032f
C1046 vbn.t50 VSS 0.26168f
C1047 vbn.t64 VSS 0.26168f
C1048 vbn.t78 VSS 0.26168f
C1049 vbn.t92 VSS 0.26168f
C1050 vbn.t106 VSS 0.26168f
C1051 vbn.t120 VSS 0.26168f
C1052 vbn.t134 VSS 0.26168f
C1053 vbn.t148 VSS 0.26168f
C1054 vbn.t162 VSS 0.26168f
C1055 vbn.t176 VSS 0.26168f
C1056 vbn.t190 VSS 0.26168f
C1057 vbn.t204 VSS 0.26168f
C1058 vbn.t218 VSS 0.22378f
C1059 vbn.n1 VSS 0.05349f
C1060 vbn.t37 VSS 0.20032f
C1061 vbn.t51 VSS 0.26168f
C1062 vbn.t65 VSS 0.26168f
C1063 vbn.t79 VSS 0.26168f
C1064 vbn.t93 VSS 0.26168f
C1065 vbn.t107 VSS 0.26168f
C1066 vbn.t121 VSS 0.26168f
C1067 vbn.t135 VSS 0.26168f
C1068 vbn.t149 VSS 0.26168f
C1069 vbn.t163 VSS 0.26168f
C1070 vbn.t177 VSS 0.26168f
C1071 vbn.t191 VSS 0.26168f
C1072 vbn.t205 VSS 0.26168f
C1073 vbn.t219 VSS 0.22378f
C1074 vbn.n2 VSS 0.05349f
C1075 vbn.t38 VSS 0.20032f
C1076 vbn.t52 VSS 0.26168f
C1077 vbn.t66 VSS 0.26168f
C1078 vbn.t80 VSS 0.26168f
C1079 vbn.t94 VSS 0.26168f
C1080 vbn.t108 VSS 0.26168f
C1081 vbn.t122 VSS 0.26168f
C1082 vbn.t136 VSS 0.26168f
C1083 vbn.t150 VSS 0.26168f
C1084 vbn.t164 VSS 0.26168f
C1085 vbn.t178 VSS 0.26168f
C1086 vbn.t192 VSS 0.26168f
C1087 vbn.t206 VSS 0.26168f
C1088 vbn.t220 VSS 0.22378f
C1089 vbn.n3 VSS 0.05349f
C1090 vbn.t39 VSS 0.20032f
C1091 vbn.t53 VSS 0.26168f
C1092 vbn.t67 VSS 0.26168f
C1093 vbn.t81 VSS 0.26168f
C1094 vbn.t95 VSS 0.26168f
C1095 vbn.t109 VSS 0.26168f
C1096 vbn.t123 VSS 0.26168f
C1097 vbn.t137 VSS 0.26168f
C1098 vbn.t151 VSS 0.26168f
C1099 vbn.t165 VSS 0.26168f
C1100 vbn.t179 VSS 0.26168f
C1101 vbn.t193 VSS 0.26168f
C1102 vbn.t207 VSS 0.26168f
C1103 vbn.t221 VSS 0.22378f
C1104 vbn.n4 VSS 0.05349f
C1105 vbn.t40 VSS 0.20032f
C1106 vbn.t54 VSS 0.26168f
C1107 vbn.t68 VSS 0.26168f
C1108 vbn.t82 VSS 0.26168f
C1109 vbn.t96 VSS 0.26168f
C1110 vbn.t110 VSS 0.26168f
C1111 vbn.t124 VSS 0.26168f
C1112 vbn.t138 VSS 0.26168f
C1113 vbn.t152 VSS 0.26168f
C1114 vbn.t166 VSS 0.26168f
C1115 vbn.t180 VSS 0.26168f
C1116 vbn.t194 VSS 0.26168f
C1117 vbn.t208 VSS 0.26168f
C1118 vbn.t222 VSS 0.22378f
C1119 vbn.n5 VSS 0.05349f
C1120 vbn.t41 VSS 0.20032f
C1121 vbn.t55 VSS 0.26168f
C1122 vbn.t69 VSS 0.26168f
C1123 vbn.t83 VSS 0.26168f
C1124 vbn.t97 VSS 0.26168f
C1125 vbn.t111 VSS 0.26168f
C1126 vbn.t125 VSS 0.26168f
C1127 vbn.t139 VSS 0.26168f
C1128 vbn.t153 VSS 0.26168f
C1129 vbn.t167 VSS 0.26168f
C1130 vbn.t181 VSS 0.26168f
C1131 vbn.t195 VSS 0.26168f
C1132 vbn.t209 VSS 0.26168f
C1133 vbn.t223 VSS 0.22378f
C1134 vbn.n6 VSS 0.05349f
C1135 vbn.t42 VSS 0.20032f
C1136 vbn.t56 VSS 0.26168f
C1137 vbn.t70 VSS 0.26168f
C1138 vbn.t84 VSS 0.26168f
C1139 vbn.t98 VSS 0.26168f
C1140 vbn.t112 VSS 0.26168f
C1141 vbn.t126 VSS 0.26168f
C1142 vbn.t140 VSS 0.26168f
C1143 vbn.t154 VSS 0.26168f
C1144 vbn.t168 VSS 0.26168f
C1145 vbn.t182 VSS 0.26168f
C1146 vbn.t196 VSS 0.26168f
C1147 vbn.t210 VSS 0.26168f
C1148 vbn.t224 VSS 0.22378f
C1149 vbn.n7 VSS 0.03943f
C1150 vbn.t43 VSS 0.20032f
C1151 vbn.t57 VSS 0.26168f
C1152 vbn.t71 VSS 0.26168f
C1153 vbn.t85 VSS 0.26168f
C1154 vbn.t99 VSS 0.26168f
C1155 vbn.t113 VSS 0.26168f
C1156 vbn.t127 VSS 0.26168f
C1157 vbn.t141 VSS 0.26168f
C1158 vbn.t155 VSS 0.26168f
C1159 vbn.t169 VSS 0.26168f
C1160 vbn.t183 VSS 0.26168f
C1161 vbn.t197 VSS 0.26168f
C1162 vbn.t211 VSS 0.26168f
C1163 vbn.t225 VSS 0.22378f
C1164 vbn.t1 VSS 0.17686f
C1165 vbn.t3 VSS 0.17686f
C1166 vbn.n8 VSS 0.84332f
C1167 vbn.n9 VSS 0.09861f
C1168 vbn.n10 VSS 0.0408f
C1169 vbn.t44 VSS 0.20032f
C1170 vbn.t58 VSS 0.26168f
C1171 vbn.t72 VSS 0.26168f
C1172 vbn.t86 VSS 0.26168f
C1173 vbn.t100 VSS 0.26168f
C1174 vbn.t114 VSS 0.26168f
C1175 vbn.t128 VSS 0.26168f
C1176 vbn.t142 VSS 0.26168f
C1177 vbn.t156 VSS 0.26168f
C1178 vbn.t170 VSS 0.26168f
C1179 vbn.t184 VSS 0.26168f
C1180 vbn.t198 VSS 0.26168f
C1181 vbn.t212 VSS 0.26168f
C1182 vbn.t226 VSS 0.22378f
C1183 vbn.n11 VSS 0.05349f
C1184 vbn.t45 VSS 0.20032f
C1185 vbn.t59 VSS 0.26168f
C1186 vbn.t73 VSS 0.26168f
C1187 vbn.t87 VSS 0.26168f
C1188 vbn.t101 VSS 0.26168f
C1189 vbn.t115 VSS 0.26168f
C1190 vbn.t129 VSS 0.26168f
C1191 vbn.t143 VSS 0.26168f
C1192 vbn.t157 VSS 0.26168f
C1193 vbn.t171 VSS 0.26168f
C1194 vbn.t185 VSS 0.26168f
C1195 vbn.t199 VSS 0.26168f
C1196 vbn.t213 VSS 0.26168f
C1197 vbn.t227 VSS 0.22378f
C1198 vbn.n12 VSS 0.05349f
C1199 vbn.t46 VSS 0.20032f
C1200 vbn.t60 VSS 0.26168f
C1201 vbn.t74 VSS 0.26168f
C1202 vbn.t88 VSS 0.26168f
C1203 vbn.t102 VSS 0.26168f
C1204 vbn.t116 VSS 0.26168f
C1205 vbn.t130 VSS 0.26168f
C1206 vbn.t144 VSS 0.26168f
C1207 vbn.t158 VSS 0.26168f
C1208 vbn.t172 VSS 0.26168f
C1209 vbn.t186 VSS 0.26168f
C1210 vbn.t200 VSS 0.26168f
C1211 vbn.t214 VSS 0.26168f
C1212 vbn.t228 VSS 0.22378f
C1213 vbn.n13 VSS 0.05349f
C1214 vbn.t47 VSS 0.20032f
C1215 vbn.t61 VSS 0.26168f
C1216 vbn.t75 VSS 0.26168f
C1217 vbn.t89 VSS 0.26168f
C1218 vbn.t103 VSS 0.26168f
C1219 vbn.t117 VSS 0.26168f
C1220 vbn.t131 VSS 0.26168f
C1221 vbn.t145 VSS 0.26168f
C1222 vbn.t159 VSS 0.26168f
C1223 vbn.t173 VSS 0.26168f
C1224 vbn.t187 VSS 0.26168f
C1225 vbn.t201 VSS 0.26168f
C1226 vbn.t215 VSS 0.26168f
C1227 vbn.t229 VSS 0.22378f
C1228 vbn.n14 VSS 0.07989f
C1229 vbn.t48 VSS 0.20032f
C1230 vbn.t62 VSS 0.26168f
C1231 vbn.t76 VSS 0.26168f
C1232 vbn.t90 VSS 0.26168f
C1233 vbn.t104 VSS 0.26168f
C1234 vbn.t118 VSS 0.26168f
C1235 vbn.t132 VSS 0.26168f
C1236 vbn.t146 VSS 0.26168f
C1237 vbn.t160 VSS 0.26168f
C1238 vbn.t174 VSS 0.26168f
C1239 vbn.t188 VSS 0.26168f
C1240 vbn.t202 VSS 0.26168f
C1241 vbn.t216 VSS 0.26168f
C1242 vbn.t230 VSS 0.22378f
C1243 vbn.n15 VSS 0.06531f
C1244 vbn.t231 VSS 0.20032f
C1245 vbn.t238 VSS 0.26168f
C1246 vbn.t245 VSS 0.26168f
C1247 vbn.t252 VSS 0.26168f
C1248 vbn.t259 VSS 0.26168f
C1249 vbn.t266 VSS 0.26168f
C1250 vbn.t273 VSS 0.26168f
C1251 vbn.t280 VSS 0.26168f
C1252 vbn.t287 VSS 0.26168f
C1253 vbn.t294 VSS 0.26168f
C1254 vbn.t301 VSS 0.26168f
C1255 vbn.t308 VSS 0.26168f
C1256 vbn.t315 VSS 0.26168f
C1257 vbn.t31 VSS 0.22378f
C1258 vbn.t32 VSS 0.02527f
C1259 vbn.t30 VSS 0.02527f
C1260 vbn.n16 VSS 0.05946f
C1261 vbn.n17 VSS 0.12861f
C1262 vbn.n18 VSS 0.10452f
C1263 vbn.t232 VSS 0.20032f
C1264 vbn.t239 VSS 0.26168f
C1265 vbn.t246 VSS 0.26168f
C1266 vbn.t253 VSS 0.26168f
C1267 vbn.t260 VSS 0.26168f
C1268 vbn.t267 VSS 0.26168f
C1269 vbn.t274 VSS 0.26168f
C1270 vbn.t281 VSS 0.26168f
C1271 vbn.t288 VSS 0.26168f
C1272 vbn.t295 VSS 0.26168f
C1273 vbn.t302 VSS 0.26168f
C1274 vbn.t309 VSS 0.26168f
C1275 vbn.t316 VSS 0.26168f
C1276 vbn.t29 VSS 0.22378f
C1277 vbn.n19 VSS 0.10452f
C1278 vbn.t233 VSS 0.20032f
C1279 vbn.t240 VSS 0.26168f
C1280 vbn.t247 VSS 0.26168f
C1281 vbn.t254 VSS 0.26168f
C1282 vbn.t261 VSS 0.26168f
C1283 vbn.t268 VSS 0.26168f
C1284 vbn.t275 VSS 0.26168f
C1285 vbn.t282 VSS 0.26168f
C1286 vbn.t289 VSS 0.26168f
C1287 vbn.t296 VSS 0.26168f
C1288 vbn.t303 VSS 0.26168f
C1289 vbn.t310 VSS 0.26168f
C1290 vbn.t317 VSS 0.26168f
C1291 vbn.t27 VSS 0.22378f
C1292 vbn.t28 VSS 0.02527f
C1293 vbn.t26 VSS 0.02527f
C1294 vbn.n20 VSS 0.05946f
C1295 vbn.n21 VSS 0.13841f
C1296 vbn.n22 VSS 0.10452f
C1297 vbn.t234 VSS 0.20032f
C1298 vbn.t241 VSS 0.26168f
C1299 vbn.t248 VSS 0.26168f
C1300 vbn.t255 VSS 0.26168f
C1301 vbn.t262 VSS 0.26168f
C1302 vbn.t269 VSS 0.26168f
C1303 vbn.t276 VSS 0.26168f
C1304 vbn.t283 VSS 0.26168f
C1305 vbn.t290 VSS 0.26168f
C1306 vbn.t297 VSS 0.26168f
C1307 vbn.t304 VSS 0.26168f
C1308 vbn.t311 VSS 0.26168f
C1309 vbn.t318 VSS 0.26168f
C1310 vbn.t25 VSS 0.22378f
C1311 vbn.n23 VSS 0.10452f
C1312 vbn.t235 VSS 0.20032f
C1313 vbn.t242 VSS 0.26168f
C1314 vbn.t249 VSS 0.26168f
C1315 vbn.t256 VSS 0.26168f
C1316 vbn.t263 VSS 0.26168f
C1317 vbn.t270 VSS 0.26168f
C1318 vbn.t277 VSS 0.26168f
C1319 vbn.t284 VSS 0.26168f
C1320 vbn.t291 VSS 0.26168f
C1321 vbn.t298 VSS 0.26168f
C1322 vbn.t305 VSS 0.26168f
C1323 vbn.t312 VSS 0.26168f
C1324 vbn.t319 VSS 0.26168f
C1325 vbn.t23 VSS 0.22378f
C1326 vbn.t24 VSS 0.02527f
C1327 vbn.t22 VSS 0.02527f
C1328 vbn.n24 VSS 0.05946f
C1329 vbn.n25 VSS 0.13841f
C1330 vbn.n26 VSS 0.10452f
C1331 vbn.t236 VSS 0.20032f
C1332 vbn.t243 VSS 0.26168f
C1333 vbn.t250 VSS 0.26168f
C1334 vbn.t257 VSS 0.26168f
C1335 vbn.t264 VSS 0.26168f
C1336 vbn.t271 VSS 0.26168f
C1337 vbn.t278 VSS 0.26168f
C1338 vbn.t285 VSS 0.26168f
C1339 vbn.t292 VSS 0.26168f
C1340 vbn.t299 VSS 0.26168f
C1341 vbn.t306 VSS 0.26168f
C1342 vbn.t313 VSS 0.26168f
C1343 vbn.t320 VSS 0.26168f
C1344 vbn.t21 VSS 0.22378f
C1345 vbn.n27 VSS 0.10385f
C1346 vbn.t237 VSS 0.20032f
C1347 vbn.t244 VSS 0.26168f
C1348 vbn.t251 VSS 0.26168f
C1349 vbn.t258 VSS 0.26168f
C1350 vbn.t265 VSS 0.26168f
C1351 vbn.t272 VSS 0.26168f
C1352 vbn.t279 VSS 0.26168f
C1353 vbn.t286 VSS 0.26168f
C1354 vbn.t293 VSS 0.26168f
C1355 vbn.t300 VSS 0.26168f
C1356 vbn.t307 VSS 0.26168f
C1357 vbn.t314 VSS 0.26168f
C1358 vbn.t321 VSS 0.26168f
C1359 vbn.t19 VSS 0.22378f
C1360 vbn.t20 VSS 0.06973f
C1361 vbn.n28 VSS 0.17558f
C1362 vbn.n29 VSS 0.06501f
C1363 vbn.t322 VSS 0.20032f
C1364 vbn.t350 VSS 0.26168f
C1365 vbn.t378 VSS 0.26168f
C1366 vbn.t406 VSS 0.26168f
C1367 vbn.t434 VSS 0.26168f
C1368 vbn.t462 VSS 0.26168f
C1369 vbn.t490 VSS 0.26168f
C1370 vbn.t518 VSS 0.26168f
C1371 vbn.t546 VSS 0.26168f
C1372 vbn.t574 VSS 0.26168f
C1373 vbn.t602 VSS 0.26168f
C1374 vbn.t630 VSS 0.26168f
C1375 vbn.t658 VSS 0.26168f
C1376 vbn.t686 VSS 0.22378f
C1377 vbn.n30 VSS 0.05349f
C1378 vbn.t323 VSS 0.20032f
C1379 vbn.t351 VSS 0.26168f
C1380 vbn.t379 VSS 0.26168f
C1381 vbn.t407 VSS 0.26168f
C1382 vbn.t435 VSS 0.26168f
C1383 vbn.t463 VSS 0.26168f
C1384 vbn.t491 VSS 0.26168f
C1385 vbn.t519 VSS 0.26168f
C1386 vbn.t547 VSS 0.26168f
C1387 vbn.t575 VSS 0.26168f
C1388 vbn.t603 VSS 0.26168f
C1389 vbn.t631 VSS 0.26168f
C1390 vbn.t659 VSS 0.26168f
C1391 vbn.t687 VSS 0.22378f
C1392 vbn.n31 VSS 0.05349f
C1393 vbn.t324 VSS 0.20032f
C1394 vbn.t352 VSS 0.26168f
C1395 vbn.t380 VSS 0.26168f
C1396 vbn.t408 VSS 0.26168f
C1397 vbn.t436 VSS 0.26168f
C1398 vbn.t464 VSS 0.26168f
C1399 vbn.t492 VSS 0.26168f
C1400 vbn.t520 VSS 0.26168f
C1401 vbn.t548 VSS 0.26168f
C1402 vbn.t576 VSS 0.26168f
C1403 vbn.t604 VSS 0.26168f
C1404 vbn.t632 VSS 0.26168f
C1405 vbn.t660 VSS 0.26168f
C1406 vbn.t688 VSS 0.22378f
C1407 vbn.n32 VSS 0.05349f
C1408 vbn.t325 VSS 0.20032f
C1409 vbn.t353 VSS 0.26168f
C1410 vbn.t381 VSS 0.26168f
C1411 vbn.t409 VSS 0.26168f
C1412 vbn.t437 VSS 0.26168f
C1413 vbn.t465 VSS 0.26168f
C1414 vbn.t493 VSS 0.26168f
C1415 vbn.t521 VSS 0.26168f
C1416 vbn.t549 VSS 0.26168f
C1417 vbn.t577 VSS 0.26168f
C1418 vbn.t605 VSS 0.26168f
C1419 vbn.t633 VSS 0.26168f
C1420 vbn.t661 VSS 0.26168f
C1421 vbn.t689 VSS 0.22378f
C1422 vbn.n33 VSS 0.05349f
C1423 vbn.t326 VSS 0.20032f
C1424 vbn.t354 VSS 0.26168f
C1425 vbn.t382 VSS 0.26168f
C1426 vbn.t410 VSS 0.26168f
C1427 vbn.t438 VSS 0.26168f
C1428 vbn.t466 VSS 0.26168f
C1429 vbn.t494 VSS 0.26168f
C1430 vbn.t522 VSS 0.26168f
C1431 vbn.t550 VSS 0.26168f
C1432 vbn.t578 VSS 0.26168f
C1433 vbn.t606 VSS 0.26168f
C1434 vbn.t634 VSS 0.26168f
C1435 vbn.t662 VSS 0.26168f
C1436 vbn.t690 VSS 0.22378f
C1437 vbn.n34 VSS 0.05349f
C1438 vbn.t327 VSS 0.20032f
C1439 vbn.t355 VSS 0.26168f
C1440 vbn.t383 VSS 0.26168f
C1441 vbn.t411 VSS 0.26168f
C1442 vbn.t439 VSS 0.26168f
C1443 vbn.t467 VSS 0.26168f
C1444 vbn.t495 VSS 0.26168f
C1445 vbn.t523 VSS 0.26168f
C1446 vbn.t551 VSS 0.26168f
C1447 vbn.t579 VSS 0.26168f
C1448 vbn.t607 VSS 0.26168f
C1449 vbn.t635 VSS 0.26168f
C1450 vbn.t663 VSS 0.26168f
C1451 vbn.t691 VSS 0.22378f
C1452 vbn.n35 VSS 0.05349f
C1453 vbn.t328 VSS 0.20032f
C1454 vbn.t356 VSS 0.26168f
C1455 vbn.t384 VSS 0.26168f
C1456 vbn.t412 VSS 0.26168f
C1457 vbn.t440 VSS 0.26168f
C1458 vbn.t468 VSS 0.26168f
C1459 vbn.t496 VSS 0.26168f
C1460 vbn.t524 VSS 0.26168f
C1461 vbn.t552 VSS 0.26168f
C1462 vbn.t580 VSS 0.26168f
C1463 vbn.t608 VSS 0.26168f
C1464 vbn.t636 VSS 0.26168f
C1465 vbn.t664 VSS 0.26168f
C1466 vbn.t692 VSS 0.22378f
C1467 vbn.n36 VSS 0.05349f
C1468 vbn.t329 VSS 0.20032f
C1469 vbn.t357 VSS 0.26168f
C1470 vbn.t385 VSS 0.26168f
C1471 vbn.t413 VSS 0.26168f
C1472 vbn.t441 VSS 0.26168f
C1473 vbn.t469 VSS 0.26168f
C1474 vbn.t497 VSS 0.26168f
C1475 vbn.t525 VSS 0.26168f
C1476 vbn.t553 VSS 0.26168f
C1477 vbn.t581 VSS 0.26168f
C1478 vbn.t609 VSS 0.26168f
C1479 vbn.t637 VSS 0.26168f
C1480 vbn.t665 VSS 0.26168f
C1481 vbn.t693 VSS 0.22378f
C1482 vbn.n37 VSS 0.05349f
C1483 vbn.t330 VSS 0.20032f
C1484 vbn.t358 VSS 0.26168f
C1485 vbn.t386 VSS 0.26168f
C1486 vbn.t414 VSS 0.26168f
C1487 vbn.t442 VSS 0.26168f
C1488 vbn.t470 VSS 0.26168f
C1489 vbn.t498 VSS 0.26168f
C1490 vbn.t526 VSS 0.26168f
C1491 vbn.t554 VSS 0.26168f
C1492 vbn.t582 VSS 0.26168f
C1493 vbn.t610 VSS 0.26168f
C1494 vbn.t638 VSS 0.26168f
C1495 vbn.t666 VSS 0.26168f
C1496 vbn.t694 VSS 0.22378f
C1497 vbn.n38 VSS 0.05349f
C1498 vbn.t331 VSS 0.20032f
C1499 vbn.t359 VSS 0.26168f
C1500 vbn.t387 VSS 0.26168f
C1501 vbn.t415 VSS 0.26168f
C1502 vbn.t443 VSS 0.26168f
C1503 vbn.t471 VSS 0.26168f
C1504 vbn.t499 VSS 0.26168f
C1505 vbn.t527 VSS 0.26168f
C1506 vbn.t555 VSS 0.26168f
C1507 vbn.t583 VSS 0.26168f
C1508 vbn.t611 VSS 0.26168f
C1509 vbn.t639 VSS 0.26168f
C1510 vbn.t667 VSS 0.26168f
C1511 vbn.t695 VSS 0.22378f
C1512 vbn.n39 VSS 0.05349f
C1513 vbn.t332 VSS 0.20032f
C1514 vbn.t360 VSS 0.26168f
C1515 vbn.t388 VSS 0.26168f
C1516 vbn.t416 VSS 0.26168f
C1517 vbn.t444 VSS 0.26168f
C1518 vbn.t472 VSS 0.26168f
C1519 vbn.t500 VSS 0.26168f
C1520 vbn.t528 VSS 0.26168f
C1521 vbn.t556 VSS 0.26168f
C1522 vbn.t584 VSS 0.26168f
C1523 vbn.t612 VSS 0.26168f
C1524 vbn.t640 VSS 0.26168f
C1525 vbn.t668 VSS 0.26168f
C1526 vbn.t696 VSS 0.22378f
C1527 vbn.n40 VSS 0.05349f
C1528 vbn.t333 VSS 0.20032f
C1529 vbn.t361 VSS 0.26168f
C1530 vbn.t389 VSS 0.26168f
C1531 vbn.t417 VSS 0.26168f
C1532 vbn.t445 VSS 0.26168f
C1533 vbn.t473 VSS 0.26168f
C1534 vbn.t501 VSS 0.26168f
C1535 vbn.t529 VSS 0.26168f
C1536 vbn.t557 VSS 0.26168f
C1537 vbn.t585 VSS 0.26168f
C1538 vbn.t613 VSS 0.26168f
C1539 vbn.t641 VSS 0.26168f
C1540 vbn.t669 VSS 0.26168f
C1541 vbn.t697 VSS 0.22378f
C1542 vbn.n41 VSS 0.05349f
C1543 vbn.t334 VSS 0.20032f
C1544 vbn.t362 VSS 0.26168f
C1545 vbn.t390 VSS 0.26168f
C1546 vbn.t418 VSS 0.26168f
C1547 vbn.t446 VSS 0.26168f
C1548 vbn.t474 VSS 0.26168f
C1549 vbn.t502 VSS 0.26168f
C1550 vbn.t530 VSS 0.26168f
C1551 vbn.t558 VSS 0.26168f
C1552 vbn.t586 VSS 0.26168f
C1553 vbn.t614 VSS 0.26168f
C1554 vbn.t642 VSS 0.26168f
C1555 vbn.t670 VSS 0.26168f
C1556 vbn.t698 VSS 0.22378f
C1557 vbn.n42 VSS 0.05349f
C1558 vbn.t335 VSS 0.20032f
C1559 vbn.t363 VSS 0.26168f
C1560 vbn.t391 VSS 0.26168f
C1561 vbn.t419 VSS 0.26168f
C1562 vbn.t447 VSS 0.26168f
C1563 vbn.t475 VSS 0.26168f
C1564 vbn.t503 VSS 0.26168f
C1565 vbn.t531 VSS 0.26168f
C1566 vbn.t559 VSS 0.26168f
C1567 vbn.t587 VSS 0.26168f
C1568 vbn.t615 VSS 0.26168f
C1569 vbn.t643 VSS 0.26168f
C1570 vbn.t671 VSS 0.26168f
C1571 vbn.t699 VSS 0.22378f
C1572 vbn.n43 VSS 0.05349f
C1573 vbn.t336 VSS 0.20032f
C1574 vbn.t364 VSS 0.26168f
C1575 vbn.t392 VSS 0.26168f
C1576 vbn.t420 VSS 0.26168f
C1577 vbn.t448 VSS 0.26168f
C1578 vbn.t476 VSS 0.26168f
C1579 vbn.t504 VSS 0.26168f
C1580 vbn.t532 VSS 0.26168f
C1581 vbn.t560 VSS 0.26168f
C1582 vbn.t588 VSS 0.26168f
C1583 vbn.t616 VSS 0.26168f
C1584 vbn.t644 VSS 0.26168f
C1585 vbn.t672 VSS 0.26168f
C1586 vbn.t700 VSS 0.22378f
C1587 vbn.n44 VSS 0.05349f
C1588 vbn.t337 VSS 0.20032f
C1589 vbn.t365 VSS 0.26168f
C1590 vbn.t393 VSS 0.26168f
C1591 vbn.t421 VSS 0.26168f
C1592 vbn.t449 VSS 0.26168f
C1593 vbn.t477 VSS 0.26168f
C1594 vbn.t505 VSS 0.26168f
C1595 vbn.t533 VSS 0.26168f
C1596 vbn.t561 VSS 0.26168f
C1597 vbn.t589 VSS 0.26168f
C1598 vbn.t617 VSS 0.26168f
C1599 vbn.t645 VSS 0.26168f
C1600 vbn.t673 VSS 0.26168f
C1601 vbn.t701 VSS 0.22378f
C1602 vbn.n45 VSS 0.05349f
C1603 vbn.t338 VSS 0.20032f
C1604 vbn.t366 VSS 0.26168f
C1605 vbn.t394 VSS 0.26168f
C1606 vbn.t422 VSS 0.26168f
C1607 vbn.t450 VSS 0.26168f
C1608 vbn.t478 VSS 0.26168f
C1609 vbn.t506 VSS 0.26168f
C1610 vbn.t534 VSS 0.26168f
C1611 vbn.t562 VSS 0.26168f
C1612 vbn.t590 VSS 0.26168f
C1613 vbn.t618 VSS 0.26168f
C1614 vbn.t646 VSS 0.26168f
C1615 vbn.t674 VSS 0.26168f
C1616 vbn.t702 VSS 0.22378f
C1617 vbn.n46 VSS 0.05349f
C1618 vbn.t339 VSS 0.20032f
C1619 vbn.t367 VSS 0.26168f
C1620 vbn.t395 VSS 0.26168f
C1621 vbn.t423 VSS 0.26168f
C1622 vbn.t451 VSS 0.26168f
C1623 vbn.t479 VSS 0.26168f
C1624 vbn.t507 VSS 0.26168f
C1625 vbn.t535 VSS 0.26168f
C1626 vbn.t563 VSS 0.26168f
C1627 vbn.t591 VSS 0.26168f
C1628 vbn.t619 VSS 0.26168f
C1629 vbn.t647 VSS 0.26168f
C1630 vbn.t675 VSS 0.26168f
C1631 vbn.t703 VSS 0.22378f
C1632 vbn.n47 VSS 0.05349f
C1633 vbn.t340 VSS 0.20032f
C1634 vbn.t368 VSS 0.26168f
C1635 vbn.t396 VSS 0.26168f
C1636 vbn.t424 VSS 0.26168f
C1637 vbn.t452 VSS 0.26168f
C1638 vbn.t480 VSS 0.26168f
C1639 vbn.t508 VSS 0.26168f
C1640 vbn.t536 VSS 0.26168f
C1641 vbn.t564 VSS 0.26168f
C1642 vbn.t592 VSS 0.26168f
C1643 vbn.t620 VSS 0.26168f
C1644 vbn.t648 VSS 0.26168f
C1645 vbn.t676 VSS 0.26168f
C1646 vbn.t704 VSS 0.22378f
C1647 vbn.n48 VSS 0.05349f
C1648 vbn.t341 VSS 0.20032f
C1649 vbn.t369 VSS 0.26168f
C1650 vbn.t397 VSS 0.26168f
C1651 vbn.t425 VSS 0.26168f
C1652 vbn.t453 VSS 0.26168f
C1653 vbn.t481 VSS 0.26168f
C1654 vbn.t509 VSS 0.26168f
C1655 vbn.t537 VSS 0.26168f
C1656 vbn.t565 VSS 0.26168f
C1657 vbn.t593 VSS 0.26168f
C1658 vbn.t621 VSS 0.26168f
C1659 vbn.t649 VSS 0.26168f
C1660 vbn.t677 VSS 0.26168f
C1661 vbn.t705 VSS 0.22378f
C1662 vbn.n49 VSS 0.05349f
C1663 vbn.t342 VSS 0.20032f
C1664 vbn.t370 VSS 0.26168f
C1665 vbn.t398 VSS 0.26168f
C1666 vbn.t426 VSS 0.26168f
C1667 vbn.t454 VSS 0.26168f
C1668 vbn.t482 VSS 0.26168f
C1669 vbn.t510 VSS 0.26168f
C1670 vbn.t538 VSS 0.26168f
C1671 vbn.t566 VSS 0.26168f
C1672 vbn.t594 VSS 0.26168f
C1673 vbn.t622 VSS 0.26168f
C1674 vbn.t650 VSS 0.26168f
C1675 vbn.t678 VSS 0.26168f
C1676 vbn.t706 VSS 0.22378f
C1677 vbn.n50 VSS 0.05349f
C1678 vbn.t343 VSS 0.20032f
C1679 vbn.t371 VSS 0.26168f
C1680 vbn.t399 VSS 0.26168f
C1681 vbn.t427 VSS 0.26168f
C1682 vbn.t455 VSS 0.26168f
C1683 vbn.t483 VSS 0.26168f
C1684 vbn.t511 VSS 0.26168f
C1685 vbn.t539 VSS 0.26168f
C1686 vbn.t567 VSS 0.26168f
C1687 vbn.t595 VSS 0.26168f
C1688 vbn.t623 VSS 0.26168f
C1689 vbn.t651 VSS 0.26168f
C1690 vbn.t679 VSS 0.26168f
C1691 vbn.t707 VSS 0.22378f
C1692 vbn.n51 VSS 0.05349f
C1693 vbn.t344 VSS 0.20032f
C1694 vbn.t372 VSS 0.26168f
C1695 vbn.t400 VSS 0.26168f
C1696 vbn.t428 VSS 0.26168f
C1697 vbn.t456 VSS 0.26168f
C1698 vbn.t484 VSS 0.26168f
C1699 vbn.t512 VSS 0.26168f
C1700 vbn.t540 VSS 0.26168f
C1701 vbn.t568 VSS 0.26168f
C1702 vbn.t596 VSS 0.26168f
C1703 vbn.t624 VSS 0.26168f
C1704 vbn.t652 VSS 0.26168f
C1705 vbn.t680 VSS 0.26168f
C1706 vbn.t708 VSS 0.22378f
C1707 vbn.n52 VSS 0.05349f
C1708 vbn.t345 VSS 0.20032f
C1709 vbn.t373 VSS 0.26168f
C1710 vbn.t401 VSS 0.26168f
C1711 vbn.t429 VSS 0.26168f
C1712 vbn.t457 VSS 0.26168f
C1713 vbn.t485 VSS 0.26168f
C1714 vbn.t513 VSS 0.26168f
C1715 vbn.t541 VSS 0.26168f
C1716 vbn.t569 VSS 0.26168f
C1717 vbn.t597 VSS 0.26168f
C1718 vbn.t625 VSS 0.26168f
C1719 vbn.t653 VSS 0.26168f
C1720 vbn.t681 VSS 0.26168f
C1721 vbn.t709 VSS 0.22378f
C1722 vbn.n53 VSS 0.05349f
C1723 vbn.t346 VSS 0.20032f
C1724 vbn.t374 VSS 0.26168f
C1725 vbn.t402 VSS 0.26168f
C1726 vbn.t430 VSS 0.26168f
C1727 vbn.t458 VSS 0.26168f
C1728 vbn.t486 VSS 0.26168f
C1729 vbn.t514 VSS 0.26168f
C1730 vbn.t542 VSS 0.26168f
C1731 vbn.t570 VSS 0.26168f
C1732 vbn.t598 VSS 0.26168f
C1733 vbn.t626 VSS 0.26168f
C1734 vbn.t654 VSS 0.26168f
C1735 vbn.t682 VSS 0.26168f
C1736 vbn.t710 VSS 0.22378f
C1737 vbn.n54 VSS 0.05349f
C1738 vbn.t347 VSS 0.20032f
C1739 vbn.t375 VSS 0.26168f
C1740 vbn.t403 VSS 0.26168f
C1741 vbn.t431 VSS 0.26168f
C1742 vbn.t459 VSS 0.26168f
C1743 vbn.t487 VSS 0.26168f
C1744 vbn.t515 VSS 0.26168f
C1745 vbn.t543 VSS 0.26168f
C1746 vbn.t571 VSS 0.26168f
C1747 vbn.t599 VSS 0.26168f
C1748 vbn.t627 VSS 0.26168f
C1749 vbn.t655 VSS 0.26168f
C1750 vbn.t683 VSS 0.26168f
C1751 vbn.t711 VSS 0.22378f
C1752 vbn.n55 VSS 0.05349f
C1753 vbn.t348 VSS 0.20032f
C1754 vbn.t376 VSS 0.26168f
C1755 vbn.t404 VSS 0.26168f
C1756 vbn.t432 VSS 0.26168f
C1757 vbn.t460 VSS 0.26168f
C1758 vbn.t488 VSS 0.26168f
C1759 vbn.t516 VSS 0.26168f
C1760 vbn.t544 VSS 0.26168f
C1761 vbn.t572 VSS 0.26168f
C1762 vbn.t600 VSS 0.26168f
C1763 vbn.t628 VSS 0.26168f
C1764 vbn.t656 VSS 0.26168f
C1765 vbn.t684 VSS 0.26168f
C1766 vbn.t712 VSS 0.22378f
C1767 vbn.n56 VSS 0.07989f
C1768 vbn.t349 VSS 0.20032f
C1769 vbn.t377 VSS 0.26168f
C1770 vbn.t405 VSS 0.26168f
C1771 vbn.t433 VSS 0.26168f
C1772 vbn.t461 VSS 0.26168f
C1773 vbn.t489 VSS 0.26168f
C1774 vbn.t517 VSS 0.26168f
C1775 vbn.t545 VSS 0.26168f
C1776 vbn.t573 VSS 0.26168f
C1777 vbn.t601 VSS 0.26168f
C1778 vbn.t629 VSS 0.26168f
C1779 vbn.t657 VSS 0.26168f
C1780 vbn.t685 VSS 0.26168f
C1781 vbn.t713 VSS 0.22378f
C1782 vbn.n57 VSS 0.06531f
C1783 vbn.t714 VSS 0.20032f
C1784 vbn.t721 VSS 0.26168f
C1785 vbn.t728 VSS 0.26168f
C1786 vbn.t735 VSS 0.26168f
C1787 vbn.t742 VSS 0.26168f
C1788 vbn.t749 VSS 0.26168f
C1789 vbn.t756 VSS 0.26168f
C1790 vbn.t763 VSS 0.26168f
C1791 vbn.t770 VSS 0.26168f
C1792 vbn.t777 VSS 0.26168f
C1793 vbn.t784 VSS 0.26168f
C1794 vbn.t791 VSS 0.26168f
C1795 vbn.t798 VSS 0.26168f
C1796 vbn.t17 VSS 0.22378f
C1797 vbn.t18 VSS 0.02527f
C1798 vbn.t16 VSS 0.02527f
C1799 vbn.n58 VSS 0.05946f
C1800 vbn.n59 VSS 0.12861f
C1801 vbn.n60 VSS 0.10452f
C1802 vbn.t715 VSS 0.20032f
C1803 vbn.t722 VSS 0.26168f
C1804 vbn.t729 VSS 0.26168f
C1805 vbn.t736 VSS 0.26168f
C1806 vbn.t743 VSS 0.26168f
C1807 vbn.t750 VSS 0.26168f
C1808 vbn.t757 VSS 0.26168f
C1809 vbn.t764 VSS 0.26168f
C1810 vbn.t771 VSS 0.26168f
C1811 vbn.t778 VSS 0.26168f
C1812 vbn.t785 VSS 0.26168f
C1813 vbn.t792 VSS 0.26168f
C1814 vbn.t799 VSS 0.26168f
C1815 vbn.t15 VSS 0.22378f
C1816 vbn.n61 VSS 0.10452f
C1817 vbn.t716 VSS 0.20032f
C1818 vbn.t723 VSS 0.26168f
C1819 vbn.t730 VSS 0.26168f
C1820 vbn.t737 VSS 0.26168f
C1821 vbn.t744 VSS 0.26168f
C1822 vbn.t751 VSS 0.26168f
C1823 vbn.t758 VSS 0.26168f
C1824 vbn.t765 VSS 0.26168f
C1825 vbn.t772 VSS 0.26168f
C1826 vbn.t779 VSS 0.26168f
C1827 vbn.t786 VSS 0.26168f
C1828 vbn.t793 VSS 0.26168f
C1829 vbn.t800 VSS 0.26168f
C1830 vbn.t13 VSS 0.22378f
C1831 vbn.t14 VSS 0.02527f
C1832 vbn.t12 VSS 0.02527f
C1833 vbn.n62 VSS 0.05946f
C1834 vbn.n63 VSS 0.13841f
C1835 vbn.n64 VSS 0.10452f
C1836 vbn.t717 VSS 0.20032f
C1837 vbn.t724 VSS 0.26168f
C1838 vbn.t731 VSS 0.26168f
C1839 vbn.t738 VSS 0.26168f
C1840 vbn.t745 VSS 0.26168f
C1841 vbn.t752 VSS 0.26168f
C1842 vbn.t759 VSS 0.26168f
C1843 vbn.t766 VSS 0.26168f
C1844 vbn.t773 VSS 0.26168f
C1845 vbn.t780 VSS 0.26168f
C1846 vbn.t787 VSS 0.26168f
C1847 vbn.t794 VSS 0.26168f
C1848 vbn.t801 VSS 0.26168f
C1849 vbn.t11 VSS 0.22378f
C1850 vbn.n65 VSS 0.10452f
C1851 vbn.t718 VSS 0.20032f
C1852 vbn.t725 VSS 0.26168f
C1853 vbn.t732 VSS 0.26168f
C1854 vbn.t739 VSS 0.26168f
C1855 vbn.t746 VSS 0.26168f
C1856 vbn.t753 VSS 0.26168f
C1857 vbn.t760 VSS 0.26168f
C1858 vbn.t767 VSS 0.26168f
C1859 vbn.t774 VSS 0.26168f
C1860 vbn.t781 VSS 0.26168f
C1861 vbn.t788 VSS 0.26168f
C1862 vbn.t795 VSS 0.26168f
C1863 vbn.t802 VSS 0.26168f
C1864 vbn.t9 VSS 0.22378f
C1865 vbn.t10 VSS 0.02527f
C1866 vbn.t8 VSS 0.02527f
C1867 vbn.n66 VSS 0.05946f
C1868 vbn.n67 VSS 0.13841f
C1869 vbn.n68 VSS 0.10452f
C1870 vbn.t719 VSS 0.20032f
C1871 vbn.t726 VSS 0.26168f
C1872 vbn.t733 VSS 0.26168f
C1873 vbn.t740 VSS 0.26168f
C1874 vbn.t747 VSS 0.26168f
C1875 vbn.t754 VSS 0.26168f
C1876 vbn.t761 VSS 0.26168f
C1877 vbn.t768 VSS 0.26168f
C1878 vbn.t775 VSS 0.26168f
C1879 vbn.t782 VSS 0.26168f
C1880 vbn.t789 VSS 0.26168f
C1881 vbn.t796 VSS 0.26168f
C1882 vbn.t803 VSS 0.26168f
C1883 vbn.t7 VSS 0.22378f
C1884 vbn.n69 VSS 0.10385f
C1885 vbn.t720 VSS 0.20032f
C1886 vbn.t727 VSS 0.26168f
C1887 vbn.t734 VSS 0.26168f
C1888 vbn.t741 VSS 0.26168f
C1889 vbn.t748 VSS 0.26168f
C1890 vbn.t755 VSS 0.26168f
C1891 vbn.t762 VSS 0.26168f
C1892 vbn.t769 VSS 0.26168f
C1893 vbn.t776 VSS 0.26168f
C1894 vbn.t783 VSS 0.26168f
C1895 vbn.t790 VSS 0.26168f
C1896 vbn.t797 VSS 0.26168f
C1897 vbn.t804 VSS 0.26168f
C1898 vbn.t5 VSS 0.22378f
C1899 vbn.t6 VSS 0.06973f
C1900 vbn.n70 VSS 0.17558f
C1901 vbn.n71 VSS 0.06501f
C1902 vbn.t805 VSS 0.20032f
C1903 vbn.t819 VSS 0.26168f
C1904 vbn.t833 VSS 0.26168f
C1905 vbn.t847 VSS 0.26168f
C1906 vbn.t861 VSS 0.26168f
C1907 vbn.t875 VSS 0.26168f
C1908 vbn.t889 VSS 0.26168f
C1909 vbn.t903 VSS 0.26168f
C1910 vbn.t917 VSS 0.26168f
C1911 vbn.t931 VSS 0.26168f
C1912 vbn.t945 VSS 0.26168f
C1913 vbn.t959 VSS 0.26168f
C1914 vbn.t973 VSS 0.26168f
C1915 vbn.t987 VSS 0.22378f
C1916 vbn.n72 VSS 0.05349f
C1917 vbn.t806 VSS 0.20032f
C1918 vbn.t820 VSS 0.26168f
C1919 vbn.t834 VSS 0.26168f
C1920 vbn.t848 VSS 0.26168f
C1921 vbn.t862 VSS 0.26168f
C1922 vbn.t876 VSS 0.26168f
C1923 vbn.t890 VSS 0.26168f
C1924 vbn.t904 VSS 0.26168f
C1925 vbn.t918 VSS 0.26168f
C1926 vbn.t932 VSS 0.26168f
C1927 vbn.t946 VSS 0.26168f
C1928 vbn.t960 VSS 0.26168f
C1929 vbn.t974 VSS 0.26168f
C1930 vbn.t988 VSS 0.22378f
C1931 vbn.n73 VSS 0.05349f
C1932 vbn.t807 VSS 0.20032f
C1933 vbn.t821 VSS 0.26168f
C1934 vbn.t835 VSS 0.26168f
C1935 vbn.t849 VSS 0.26168f
C1936 vbn.t863 VSS 0.26168f
C1937 vbn.t877 VSS 0.26168f
C1938 vbn.t891 VSS 0.26168f
C1939 vbn.t905 VSS 0.26168f
C1940 vbn.t919 VSS 0.26168f
C1941 vbn.t933 VSS 0.26168f
C1942 vbn.t947 VSS 0.26168f
C1943 vbn.t961 VSS 0.26168f
C1944 vbn.t975 VSS 0.26168f
C1945 vbn.t989 VSS 0.22378f
C1946 vbn.n74 VSS 0.05349f
C1947 vbn.t808 VSS 0.20032f
C1948 vbn.t822 VSS 0.26168f
C1949 vbn.t836 VSS 0.26168f
C1950 vbn.t850 VSS 0.26168f
C1951 vbn.t864 VSS 0.26168f
C1952 vbn.t878 VSS 0.26168f
C1953 vbn.t892 VSS 0.26168f
C1954 vbn.t906 VSS 0.26168f
C1955 vbn.t920 VSS 0.26168f
C1956 vbn.t934 VSS 0.26168f
C1957 vbn.t948 VSS 0.26168f
C1958 vbn.t962 VSS 0.26168f
C1959 vbn.t976 VSS 0.26168f
C1960 vbn.t990 VSS 0.22378f
C1961 vbn.n75 VSS 0.0408f
C1962 vbn.t809 VSS 0.20032f
C1963 vbn.t823 VSS 0.26168f
C1964 vbn.t837 VSS 0.26168f
C1965 vbn.t851 VSS 0.26168f
C1966 vbn.t865 VSS 0.26168f
C1967 vbn.t879 VSS 0.26168f
C1968 vbn.t893 VSS 0.26168f
C1969 vbn.t907 VSS 0.26168f
C1970 vbn.t921 VSS 0.26168f
C1971 vbn.t935 VSS 0.26168f
C1972 vbn.t949 VSS 0.26168f
C1973 vbn.t963 VSS 0.26168f
C1974 vbn.t977 VSS 0.26168f
C1975 vbn.t991 VSS 0.22378f
C1976 vbn.t2 VSS 0.17686f
C1977 vbn.t0 VSS 0.17686f
C1978 vbn.n76 VSS 0.84332f
C1979 vbn.n77 VSS 0.09861f
C1980 vbn.n78 VSS 0.03943f
C1981 vbn.t810 VSS 0.20032f
C1982 vbn.t824 VSS 0.26168f
C1983 vbn.t838 VSS 0.26168f
C1984 vbn.t852 VSS 0.26168f
C1985 vbn.t866 VSS 0.26168f
C1986 vbn.t880 VSS 0.26168f
C1987 vbn.t894 VSS 0.26168f
C1988 vbn.t908 VSS 0.26168f
C1989 vbn.t922 VSS 0.26168f
C1990 vbn.t936 VSS 0.26168f
C1991 vbn.t950 VSS 0.26168f
C1992 vbn.t964 VSS 0.26168f
C1993 vbn.t978 VSS 0.26168f
C1994 vbn.t992 VSS 0.22378f
C1995 vbn.n79 VSS 0.05349f
C1996 vbn.t811 VSS 0.20032f
C1997 vbn.t825 VSS 0.26168f
C1998 vbn.t839 VSS 0.26168f
C1999 vbn.t853 VSS 0.26168f
C2000 vbn.t867 VSS 0.26168f
C2001 vbn.t881 VSS 0.26168f
C2002 vbn.t895 VSS 0.26168f
C2003 vbn.t909 VSS 0.26168f
C2004 vbn.t923 VSS 0.26168f
C2005 vbn.t937 VSS 0.26168f
C2006 vbn.t951 VSS 0.26168f
C2007 vbn.t965 VSS 0.26168f
C2008 vbn.t979 VSS 0.26168f
C2009 vbn.t993 VSS 0.22378f
C2010 vbn.n80 VSS 0.05349f
C2011 vbn.t812 VSS 0.20032f
C2012 vbn.t826 VSS 0.26168f
C2013 vbn.t840 VSS 0.26168f
C2014 vbn.t854 VSS 0.26168f
C2015 vbn.t868 VSS 0.26168f
C2016 vbn.t882 VSS 0.26168f
C2017 vbn.t896 VSS 0.26168f
C2018 vbn.t910 VSS 0.26168f
C2019 vbn.t924 VSS 0.26168f
C2020 vbn.t938 VSS 0.26168f
C2021 vbn.t952 VSS 0.26168f
C2022 vbn.t966 VSS 0.26168f
C2023 vbn.t980 VSS 0.26168f
C2024 vbn.t994 VSS 0.22378f
C2025 vbn.n81 VSS 0.05349f
C2026 vbn.t813 VSS 0.20032f
C2027 vbn.t827 VSS 0.26168f
C2028 vbn.t841 VSS 0.26168f
C2029 vbn.t855 VSS 0.26168f
C2030 vbn.t869 VSS 0.26168f
C2031 vbn.t883 VSS 0.26168f
C2032 vbn.t897 VSS 0.26168f
C2033 vbn.t911 VSS 0.26168f
C2034 vbn.t925 VSS 0.26168f
C2035 vbn.t939 VSS 0.26168f
C2036 vbn.t953 VSS 0.26168f
C2037 vbn.t967 VSS 0.26168f
C2038 vbn.t981 VSS 0.26168f
C2039 vbn.t995 VSS 0.22378f
C2040 vbn.n82 VSS 0.05349f
C2041 vbn.t814 VSS 0.20032f
C2042 vbn.t828 VSS 0.26168f
C2043 vbn.t842 VSS 0.26168f
C2044 vbn.t856 VSS 0.26168f
C2045 vbn.t870 VSS 0.26168f
C2046 vbn.t884 VSS 0.26168f
C2047 vbn.t898 VSS 0.26168f
C2048 vbn.t912 VSS 0.26168f
C2049 vbn.t926 VSS 0.26168f
C2050 vbn.t940 VSS 0.26168f
C2051 vbn.t954 VSS 0.26168f
C2052 vbn.t968 VSS 0.26168f
C2053 vbn.t982 VSS 0.26168f
C2054 vbn.t996 VSS 0.22378f
C2055 vbn.n83 VSS 0.05349f
C2056 vbn.t815 VSS 0.20032f
C2057 vbn.t829 VSS 0.26168f
C2058 vbn.t843 VSS 0.26168f
C2059 vbn.t857 VSS 0.26168f
C2060 vbn.t871 VSS 0.26168f
C2061 vbn.t885 VSS 0.26168f
C2062 vbn.t899 VSS 0.26168f
C2063 vbn.t913 VSS 0.26168f
C2064 vbn.t927 VSS 0.26168f
C2065 vbn.t941 VSS 0.26168f
C2066 vbn.t955 VSS 0.26168f
C2067 vbn.t969 VSS 0.26168f
C2068 vbn.t983 VSS 0.26168f
C2069 vbn.t997 VSS 0.22378f
C2070 vbn.n84 VSS 0.05349f
C2071 vbn.t816 VSS 0.20032f
C2072 vbn.t830 VSS 0.26168f
C2073 vbn.t844 VSS 0.26168f
C2074 vbn.t858 VSS 0.26168f
C2075 vbn.t872 VSS 0.26168f
C2076 vbn.t886 VSS 0.26168f
C2077 vbn.t900 VSS 0.26168f
C2078 vbn.t914 VSS 0.26168f
C2079 vbn.t928 VSS 0.26168f
C2080 vbn.t942 VSS 0.26168f
C2081 vbn.t956 VSS 0.26168f
C2082 vbn.t970 VSS 0.26168f
C2083 vbn.t984 VSS 0.26168f
C2084 vbn.t998 VSS 0.22378f
C2085 vbn.n85 VSS 0.06559f
C2086 vbn.t817 VSS 0.20032f
C2087 vbn.t831 VSS 0.26168f
C2088 vbn.t845 VSS 0.26168f
C2089 vbn.t859 VSS 0.26168f
C2090 vbn.t873 VSS 0.26168f
C2091 vbn.t887 VSS 0.26168f
C2092 vbn.t901 VSS 0.26168f
C2093 vbn.t915 VSS 0.26168f
C2094 vbn.t929 VSS 0.26168f
C2095 vbn.t943 VSS 0.26168f
C2096 vbn.t957 VSS 0.26168f
C2097 vbn.t971 VSS 0.26168f
C2098 vbn.t985 VSS 0.26168f
C2099 vbn.t999 VSS 0.22378f
C2100 vbn.t33 VSS 0.31402f
C2101 vbn.n86 VSS 2.75195f
C2102 vbn.t818 VSS 0.20032f
C2103 vbn.t832 VSS 0.26168f
C2104 vbn.t846 VSS 0.26168f
C2105 vbn.t860 VSS 0.26168f
C2106 vbn.t874 VSS 0.26168f
C2107 vbn.t888 VSS 0.26168f
C2108 vbn.t902 VSS 0.26168f
C2109 vbn.t916 VSS 0.26168f
C2110 vbn.t930 VSS 0.26168f
C2111 vbn.t944 VSS 0.26168f
C2112 vbn.t958 VSS 0.26168f
C2113 vbn.t972 VSS 0.26168f
C2114 vbn.t986 VSS 0.26168f
C2115 vbn.t1000 VSS 0.22378f
C2116 vbn.n87 VSS 1.68972f
C2117 vbn.n88 VSS 0.12833f
C2118 vbn.n89 VSS 0.12833f
C2119 vbn.n90 VSS 0.12833f
C2120 vbn.n91 VSS 0.12833f
C2121 vbn.n92 VSS 0.12833f
C2122 vbn.n93 VSS 0.12833f
C2123 vbn.n94 VSS 0.12833f
C2124 vbn.n95 VSS 0.12833f
C2125 vbn.n96 VSS 0.12833f
C2126 vbn.n97 VSS 0.12833f
C2127 vbn.n98 VSS 0.12833f
C2128 vbn.n99 VSS 0.12833f
C2129 vbn.n100 VSS 0.15404f
C2130 vbn.n101 VSS 0.15404f
C2131 vbn.n102 VSS 0.12833f
C2132 vbn.n103 VSS 0.12833f
C2133 vbn.n104 VSS 0.12833f
C2134 vbn.n105 VSS 0.12833f
C2135 vbn.n106 VSS 0.12833f
C2136 vbn.n107 VSS 0.15404f
C2137 vbn.n108 VSS 0.15404f
C2138 vbn.n109 VSS 0.12833f
C2139 vbn.n110 VSS 0.12833f
C2140 vbn.n111 VSS 0.12833f
C2141 vbn.n112 VSS 0.12833f
C2142 vbn.n113 VSS 0.12833f
C2143 vbn.n114 VSS 0.12833f
C2144 vbn.n115 VSS 0.12833f
C2145 vbn.n116 VSS 0.12833f
C2146 vbn.n117 VSS 0.12833f
C2147 vbn.n118 VSS 0.12833f
C2148 vbn.n119 VSS 0.12833f
C2149 vbn.n120 VSS 0.12833f
C2150 vbn.n121 VSS 0.12833f
C2151 vbn.n122 VSS 0.12833f
C2152 vbn.n123 VSS 0.12833f
C2153 vbn.n124 VSS 0.12833f
C2154 vbn.n125 VSS 0.12833f
C2155 vbn.n126 VSS 0.12833f
C2156 vbn.n127 VSS 0.12833f
C2157 vbn.n128 VSS 0.12833f
C2158 vbn.n129 VSS 0.12833f
C2159 vbn.n130 VSS 0.12833f
C2160 vbn.n131 VSS 0.12833f
C2161 vbn.n132 VSS 0.12833f
C2162 vbn.n133 VSS 0.12833f
C2163 vbn.n134 VSS 0.12833f
C2164 vbn.n135 VSS 0.15404f
C2165 vbn.n136 VSS 0.15404f
C2166 vbn.n137 VSS 0.12833f
C2167 vbn.n138 VSS 0.12833f
C2168 vbn.n139 VSS 0.12833f
C2169 vbn.n140 VSS 0.12833f
C2170 vbn.n141 VSS 0.12833f
C2171 vbn.n142 VSS 0.15404f
C2172 vbn.n143 VSS 0.15404f
C2173 vbn.n144 VSS 0.12833f
C2174 vbn.n145 VSS 0.12833f
C2175 vbn.n146 VSS 0.12833f
C2176 vbn.n147 VSS 0.12833f
C2177 vbn.n148 VSS 0.12833f
C2178 vbn.n149 VSS 0.12833f
C2179 vbn.n150 VSS 0.12833f
C2180 vbn.n151 VSS 0.12833f
C2181 vbn.n152 VSS 0.12833f
C2182 vbn.n153 VSS 0.12833f
C2183 vbn.n154 VSS 0.12833f
C2184 vbn.n155 VSS 0.12833f
C2185 vbn.n156 VSS 1.68972f
C2186 vbn.n157 VSS 1.68575f
C2187 vbn.n158 VSS 0.74122f
C2188 vbn.t34 VSS 0.04571f
C2189 vbn.n159 VSS 0.17107f
C2190 ls.t1 VSS 0.5544f
C2191 ls.t0 VSS 0.19416f
C2192 ls.n0 VSS 0.90454f
C2193 ls.t6 VSS 0.10317f
C2194 ls.t4 VSS 0.05782f
C2195 ls.n1 VSS 0.41541f
C2196 ls.t5 VSS 0.12613f
C2197 ls.n2 VSS 0.4576f
C2198 ls.t2 VSS 0.1155f
C2199 ls.n3 VSS 1.5836f
C2200 ls.n4 VSS 0.24571f
C2201 ls.t3 VSS 0.05787f
C2202 ls.n5 VSS 0.18037f
C2203 ls.n6 VSS 0.01202f
C2204 vbnf.t11 VSS 3.60499f
C2205 vbnf.t12 VSS 3.55271f
C2206 vbnf.n0 VSS 2.01263f
C2207 vbnf.t13 VSS 3.55271f
C2208 vbnf.n1 VSS 1.03184f
C2209 vbnf.t14 VSS 3.55271f
C2210 vbnf.n2 VSS 1.03184f
C2211 vbnf.t15 VSS 3.55271f
C2212 vbnf.n3 VSS 1.03184f
C2213 vbnf.t16 VSS 3.55271f
C2214 vbnf.n4 VSS 1.03184f
C2215 vbnf.t17 VSS 3.55271f
C2216 vbnf.n5 VSS 1.03184f
C2217 vbnf.t18 VSS 3.55271f
C2218 vbnf.n6 VSS 1.03184f
C2219 vbnf.t19 VSS 3.55271f
C2220 vbnf.n7 VSS 1.03184f
C2221 vbnf.t20 VSS 3.55271f
C2222 vbnf.n8 VSS 1.00031f
C2223 vbnf.t5 VSS 0.00432f
C2224 vbnf.n9 VSS 0.04836f
C2225 vbnf.t9 VSS 0.01146f
C2226 vbnf.t3 VSS 0.01446f
C2227 vbnf.n10 VSS 0.03661f
C2228 vbnf.t8 VSS 0.01146f
C2229 vbnf.t2 VSS 0.01446f
C2230 vbnf.n11 VSS 0.03548f
C2231 vbnf.n12 VSS 0.0203f
C2232 vbnf.t7 VSS 0.01146f
C2233 vbnf.t1 VSS 0.01446f
C2234 vbnf.n13 VSS 0.03548f
C2235 vbnf.n14 VSS 0.01359f
C2236 vbnf.t0 VSS 0.01146f
C2237 vbnf.t6 VSS 0.01446f
C2238 vbnf.n15 VSS 0.03548f
C2239 vbnf.n16 VSS 0.01359f
C2240 vbnf.t10 VSS 0.01146f
C2241 vbnf.t4 VSS 0.01446f
C2242 vbnf.n17 VSS 0.03548f
C2243 vbnf.n18 VSS 0.00995f
C2244 vbnf.t22 VSS 0.07459f
C2245 vbnf.t21 VSS 0.07129f
C2246 vbnf.n19 VSS 0.14833f
C2247 vbnf.t23 VSS 0.09083f
C2248 vbnf.n20 VSS 0.15182f
C2249 vbnf.t24 VSS 0.0742f
C2250 vbnf.t25 VSS 0.07479f
C2251 vbnf.n21 VSS 0.14186f
C2252 vbnf.n22 VSS 0.02859f
C2253 vbnf.t26 VSS 0.09044f
C2254 vbnf.n23 VSS 0.17149f
C2255 vbnf.n24 VSS 0.02081f
C2256 vbnf.n25 VSS 0.05508f
C2257 ck.t1 VSS 0.2156f
C2258 ck.t0 VSS 0.068f
C2259 ck.n0 VSS 0.75642f
C2260 a0.t0 VSS 0.94256f
C2261 a0.t1 VSS 0.29517f
C2262 a0.n0 VSS 1.11282f
C2263 a0.t3 VSS 0.432f
C2264 a0.t2 VSS 0.222f
C2265 a0.n1 VSS 0.60875f
C2266 a0.n2 VSS 0.66798f
C2267 bitb0.t1 VSS 0.28175f
C2268 bitb0.t0 VSS 0.08585f
C2269 bitb0.n0 VSS 0.93506f
C2270 bitb1.t1 VSS 0.32651f
C2271 bitb1.t0 VSS 0.09948f
C2272 bitb1.n0 VSS 1.08359f
C2273 bitb2.t1 VSS 0.32639f
C2274 bitb2.t0 VSS 0.09945f
C2275 bitb2.n0 VSS 1.08319f
C2276 bitb3.t1 VSS 0.32644f
C2277 bitb3.t0 VSS 0.09946f
C2278 bitb3.n0 VSS 1.08337f
C2279 bitb4.t1 VSS 0.3254f
C2280 bitb4.t0 VSS 0.09914f
C2281 bitb4.n0 VSS 1.07991f
C2282 bit0.t0 VSS 0.33688f
C2283 bit1.t0 VSS 0.33779f
C2284 bit2.t0 VSS 0.33772f
C2285 bit3.t0 VSS 0.33786f
C2286 bit4.t0 VSS 0.24777f
C2287 vg.t14 VSS 0.0081f
C2288 vg.t38 VSS 0.0081f
C2289 vg.n0 VSS 0.06147f
C2290 vg.t40 VSS 0.0081f
C2291 vg.t33 VSS 0.0081f
C2292 vg.n1 VSS 0.02923f
C2293 vg.n2 VSS 0.31338f
C2294 vg.t6 VSS 0.0081f
C2295 vg.t32 VSS 0.0081f
C2296 vg.n3 VSS 0.02923f
C2297 vg.n4 VSS 0.22292f
C2298 vg.n5 VSS 0.10204f
C2299 vg.t29 VSS 0.0081f
C2300 vg.t17 VSS 0.0081f
C2301 vg.n6 VSS 0.06147f
C2302 vg.t28 VSS 0.0081f
C2303 vg.t10 VSS 0.0081f
C2304 vg.n7 VSS 0.02923f
C2305 vg.n8 VSS 0.31338f
C2306 vg.t27 VSS 0.0081f
C2307 vg.t4 VSS 0.0081f
C2308 vg.n9 VSS 0.02923f
C2309 vg.n10 VSS 0.22292f
C2310 vg.n11 VSS 0.08537f
C2311 vg.t3 VSS 0.0081f
C2312 vg.t26 VSS 0.0081f
C2313 vg.n12 VSS 0.06147f
C2314 vg.t7 VSS 0.0081f
C2315 vg.t13 VSS 0.0081f
C2316 vg.n13 VSS 0.02923f
C2317 vg.n14 VSS 0.31338f
C2318 vg.t0 VSS 0.0081f
C2319 vg.t37 VSS 0.0081f
C2320 vg.n15 VSS 0.02923f
C2321 vg.n16 VSS 0.22292f
C2322 vg.n17 VSS 0.0916f
C2323 vg.t18 VSS 0.0081f
C2324 vg.t9 VSS 0.0081f
C2325 vg.n18 VSS 0.10983f
C2326 vg.n19 VSS 0.19884f
C2327 vg.t36 VSS 0.0081f
C2328 vg.t39 VSS 0.0081f
C2329 vg.n20 VSS 0.06147f
C2330 vg.t16 VSS 0.0081f
C2331 vg.t1 VSS 0.0081f
C2332 vg.n21 VSS 0.02923f
C2333 vg.n22 VSS 0.31338f
C2334 vg.t35 VSS 0.0081f
C2335 vg.t8 VSS 0.0081f
C2336 vg.n23 VSS 0.02923f
C2337 vg.n24 VSS 0.22292f
C2338 vg.n25 VSS 0.08537f
C2339 vg.t2 VSS 0.0081f
C2340 vg.t34 VSS 0.0081f
C2341 vg.n26 VSS 0.06147f
C2342 vg.t11 VSS 0.0081f
C2343 vg.t31 VSS 0.0081f
C2344 vg.n27 VSS 0.02923f
C2345 vg.n28 VSS 0.31338f
C2346 vg.t21 VSS 0.0081f
C2347 vg.t30 VSS 0.0081f
C2348 vg.n29 VSS 0.02923f
C2349 vg.n30 VSS 0.22292f
C2350 vg.n31 VSS 0.08537f
C2351 vg.t24 VSS 0.0081f
C2352 vg.t5 VSS 0.0081f
C2353 vg.n32 VSS 0.06147f
C2354 vg.t23 VSS 0.0081f
C2355 vg.t22 VSS 0.0081f
C2356 vg.n33 VSS 0.02923f
C2357 vg.n34 VSS 0.31338f
C2358 vg.t25 VSS 0.0081f
C2359 vg.t15 VSS 0.0081f
C2360 vg.n35 VSS 0.02923f
C2361 vg.n36 VSS 0.22292f
C2362 vg.n37 VSS 0.11243f
C2363 vg.n38 VSS 0.14459f
C2364 vg.n39 VSS 0.04338f
C2365 vg.t44 VSS 4.39527f
C2366 vg.n40 VSS 0.10043f
C2367 vg.n41 VSS 0.14459f
C2368 vg.n42 VSS 0.14459f
C2369 vg.n43 VSS 0.07688f
C2370 vg.t45 VSS 4.39527f
C2371 vg.n44 VSS 0.08543f
C2372 vg.n45 VSS 0.14459f
C2373 vg.t20 VSS 0.03741f
C2374 vg.n46 VSS 0.0724f
C2375 vg.t41 VSS 0.03741f
C2376 vg.n47 VSS 0.05652f
C2377 vg.n48 VSS 0.14459f
C2378 vg.t42 VSS 0.03741f
C2379 vg.n49 VSS 0.09156f
C2380 vg.n50 VSS 0.04392f
C2381 vg.t12 VSS 0.03741f
C2382 vg.n51 VSS 0.06421f
C2383 vg.t48 VSS 4.39527f
C2384 vg.t19 VSS 0.03741f
C2385 vg.n52 VSS 0.08758f
C2386 vg.n53 VSS 0.24218f
C2387 vg.n54 VSS 0.1411f
C2388 vg.n55 VSS 1.54913f
C2389 vg.n56 VSS 0.05413f
C2390 vg.n57 VSS 0.11981f
C2391 vg.n58 VSS 0.10565f
C2392 vg.t47 VSS 4.39527f
C2393 vg.n59 VSS 1.54913f
C2394 vg.n60 VSS 0.05977f
C2395 vg.n61 VSS 0.04338f
C2396 vg.n62 VSS 0.14459f
C2397 vg.n63 VSS 0.14459f
C2398 vg.n64 VSS 0.06597f
C2399 vg.n65 VSS 0.12048f
C2400 vg.n66 VSS 0.07873f
C2401 vg.t46 VSS 4.39527f
C2402 vg.n67 VSS 1.54913f
C2403 vg.n68 VSS 0.0576f
C2404 vg.n69 VSS 0.05809f
C2405 vg.n70 VSS 0.14459f
C2406 vg.n71 VSS 0.14459f
C2407 vg.n72 VSS 0.08241f
C2408 vg.n73 VSS 0.10043f
C2409 vg.n74 VSS 1.54913f
C2410 vg.n75 VSS 0.05552f
C2411 vg.n76 VSS 0.1372f
C2412 vg.n77 VSS 0.14459f
C2413 vg.n78 VSS 0.14459f
C2414 vg.n79 VSS 0.04338f
C2415 vg.n80 VSS 0.07229f
C2416 vg.n81 VSS 1.54913f
C2417 vg.n82 VSS 0.10043f
C2418 vg.n83 VSS 0.15128f
C2419 vg.t43 VSS 4.62543f
C2420 vg.n84 VSS 1.5821f
C2421 vg.n85 VSS 0.35647f
C2422 vg.n86 VSS 0.3941f
C2423 vctrl.t0 VSS 13.3205f
.ends
