* vco_top: magic R+C extraction of layout/vco_top.gds (layout/gen/pex.sh)
* extracted 2026-11-10T21:37:10+01:00 with magic 8.3.642, mode rc, from vco_top.gds
.subckt vco_top VDD VDD_LS VSS vctrl bit0 bit1 bit2 bit3 bit4 bitb0 bitb1 bitb2 bitb3 bitb4 ck a0 vbn vg ls vbnf
X0 a_36978_7027# vbn.t972 a_36688_7607# VSS.t86 nfet_03v3 ad=0.56p pd=2.56u as=0.9p ps=4.9u w=2u l=1u
X1 w_36626_300# vbn.t811 a_36978_1227# VSS.t103 nfet_03v3 ad=0.56p pd=2.56u as=0.56p ps=2.56u w=2u l=1u
X2 a_41364_6447# vbn.t787 a_41654_7027# VSS.t93 nfet_03v3 ad=0.56p pd=2.56u as=0.56p ps=2.56u w=2u l=1u
X3 VDD.t31 VSS.t176 a_60350_8387# VDD.t30 pfet_03v3 ad=0.225p pd=1.9u as=0.225p ps=1.9u w=0.5u l=10u
X4 a_36978_3547# vbn.t880 a_36688_4127# VSS.t98 nfet_03v3 ad=0.56p pd=2.56u as=0.56p ps=2.56u w=2u l=1u
X5 a_36978_8187# vbn.t681 a_36688_7607# VSS.t91 nfet_03v3 ad=0.56p pd=2.56u as=0.56p ps=2.56u w=2u l=1u
X6 a_36978_5867# vbn.t589 a_36688_6447# VSS.t94 nfet_03v3 ad=0.56p pd=2.56u as=0.56p ps=2.56u w=2u l=1u
X7 a_36688_5287# vbn.t542 a_36978_4707# VSS.t96 nfet_03v3 ad=0.56p pd=2.56u as=0.56p ps=2.56u w=2u l=1u
X8 a_36688_6447# vbn.t933 a_36978_5867# VSS.t94 nfet_03v3 ad=0.56p pd=2.56u as=0.56p ps=2.56u w=2u l=1u
X9 a_41654_3547# vbn.t751 a_41364_4127# VSS.t98 nfet_03v3 ad=0.56p pd=2.56u as=0.56p ps=2.56u w=2u l=1u
X10 a_41654_3547# vbn.t748 a_41364_2967# VSS.t99 nfet_03v3 ad=0.56p pd=2.56u as=0.9p ps=4.9u w=2u l=1u
X11 a_36978_1227# vbn.t329 w_36626_300# VSS.t103 nfet_03v3 ad=0.56p pd=2.56u as=0.56p ps=2.56u w=2u l=1u
X12 a_41364_6447# vbn.t785 a_41654_7027# VSS.t93 nfet_03v3 ad=0.56p pd=2.56u as=0.56p ps=2.56u w=2u l=1u
X13 a_36688_4127# vbn.t488 a_36978_3547# VSS.t98 nfet_03v3 ad=0.56p pd=2.56u as=0.56p ps=2.56u w=2u l=1u
X14 a_36978_1227# vbn.t349 w_36626_300# VSS.t103 nfet_03v3 ad=0.56p pd=2.56u as=0.9p ps=4.9u w=2u l=1u
X15 a_36978_2387# vbn.t381 a_36688_1807# VSS.t101 nfet_03v3 ad=0.56p pd=2.56u as=0.56p ps=2.56u w=2u l=1u
X16 vg.t0 a_6896_6633# VSS.t36 VSS.t1 nfet_03v3 ad=0.336p pd=1.76u as=0.336p ps=1.76u w=1.2u l=5.335u
X17 a_36688_2967# vbn.t424 a_36978_2387# VSS.t100 nfet_03v3 ad=0.56p pd=2.56u as=0.56p ps=2.56u w=2u l=1u
X18 vbnf.t4 bitb0.t1 a_6156_6633# VDD.t6 pfet_03v3 ad=2.25p pd=10.9u as=2.25p ps=10.9u w=5u l=0.28u
X19 a_36978_5867# vbn.t587 a_36688_6447# VSS.t94 nfet_03v3 ad=0.56p pd=2.56u as=0.56p ps=2.56u w=2u l=1u
X20 a_36978_5867# vbn.t563 a_36688_5287# VSS.t95 nfet_03v3 ad=0.56p pd=2.56u as=0.56p ps=2.56u w=2u l=1u
X21 a_36688_5287# vbn.t540 a_36978_4707# VSS.t96 nfet_03v3 ad=0.56p pd=2.56u as=0.56p ps=2.56u w=2u l=1u
X22 a_36978_7027# vbn.t202 a_36688_7607# VSS.t92 nfet_03v3 ad=0.56p pd=2.56u as=0.9p ps=4.9u w=2u l=1u
X23 vg.t4 a_6006_896# VSS.t54 VSS.t1 nfet_03v3 ad=0.336p pd=1.76u as=0.336p ps=1.76u w=1.2u l=5.335u
X24 a_36688_1807# vbn.t63 a_36978_2387# VSS.t101 nfet_03v3 ad=0.9p pd=4.9u as=0.56p ps=2.56u w=2u l=1u
X25 a_36978_8187# vbn.t226 a_36666_9481# VSS.t90 nfet_03v3 ad=0.56p pd=2.56u as=0.56p ps=2.56u w=2u l=1u
X26 VSS.t156 vg.t48 VSS.t156 VSS.t155 nfet_03v3 ad=13.8195p pd=62.32u as=0 ps=0 w=30.71u l=4u
X27 VSS.t16 vbnf.t21 vg.t15 VSS.t15 nfet_03v3 ad=0.336p pd=1.76u as=0.336p ps=1.76u w=1.2u l=5.335u
X28 a_36978_8187# vbn.t978 a_36688_7607# VSS.t91 nfet_03v3 ad=0.56p pd=2.56u as=0.56p ps=2.56u w=2u l=1u
X29 a_36688_5287# vbn.t909 a_36978_4707# VSS.t96 nfet_03v3 ad=0.56p pd=2.56u as=0.56p ps=2.56u w=2u l=1u
X30 a_36978_7027# vbn.t200 a_36688_7607# VSS.t92 nfet_03v3 ad=0.56p pd=2.56u as=0.56p ps=2.56u w=2u l=1u
X31 a_36688_1807# vbn.t823 a_36978_1227# VSS.t102 nfet_03v3 ad=0.56p pd=2.56u as=0.56p ps=2.56u w=2u l=1u
X32 a_41654_7027# vbn.t790 a_41364_6447# VSS.t93 nfet_03v3 ad=0.56p pd=2.56u as=0.9p ps=4.9u w=2u l=1u
X33 a_36978_4707# vbn.t525 a_36688_5287# VSS.t96 nfet_03v3 ad=0.56p pd=2.56u as=0.56p ps=2.56u w=2u l=1u
X34 a_36688_4127# vbn.t883 a_36978_3547# VSS.t98 nfet_03v3 ad=0.56p pd=2.56u as=0.56p ps=2.56u w=2u l=1u
X35 a_41654_8187# vbn.t800 a_41364_7607# VSS.t91 nfet_03v3 ad=0.56p pd=2.56u as=0.56p ps=2.56u w=2u l=1u
X36 a_36688_7607# vbn.t684 a_36978_8187# VSS.t91 nfet_03v3 ad=0.56p pd=2.56u as=0.56p ps=2.56u w=2u l=1u
X37 a_36978_7027# vbn.t639 a_36688_7607# VSS.t92 nfet_03v3 ad=0.56p pd=2.56u as=0.56p ps=2.56u w=2u l=1u
X38 a_36688_6447# vbn.t592 a_36978_5867# VSS.t94 nfet_03v3 ad=0.56p pd=2.56u as=0.56p ps=2.56u w=2u l=1u
X39 a_36978_4707# vbn.t545 a_36688_5287# VSS.t96 nfet_03v3 ad=0.56p pd=2.56u as=0.9p ps=4.9u w=2u l=1u
X40 a_41654_4707# vbn.t756 a_41364_4127# VSS.t97 nfet_03v3 ad=0.9p pd=4.9u as=0.56p ps=2.56u w=2u l=1u
X41 a_36978_2387# vbn.t68 a_36688_1807# VSS.t101 nfet_03v3 ad=0.56p pd=2.56u as=0.56p ps=2.56u w=2u l=1u
X42 a_36978_2387# vbn.t407 a_36688_2967# VSS.t100 nfet_03v3 ad=0.56p pd=2.56u as=0.56p ps=2.56u w=2u l=1u
X43 a_36978_2387# vbn.t427 a_36688_2967# VSS.t100 nfet_03v3 ad=0.56p pd=2.56u as=0.56p ps=2.56u w=2u l=1u
X44 a_36688_4127# vbn.t113 a_36978_3547# VSS.t98 nfet_03v3 ad=0.56p pd=2.56u as=0.56p ps=2.56u w=2u l=1u
X45 a_36688_1807# vbn.t53 a_36978_1227# VSS.t102 nfet_03v3 ad=0.56p pd=2.56u as=0.56p ps=2.56u w=2u l=1u
X46 a_36978_1227# vbn.t44 w_36626_300# VSS.t103 nfet_03v3 ad=0.56p pd=2.56u as=0.56p ps=2.56u w=2u l=1u
X47 a_36978_3547# vbn.t888 a_36688_4127# VSS.t86 nfet_03v3 ad=0.56p pd=2.56u as=0.9p ps=4.9u w=2u l=1u
X48 w_36626_300# w_37791_300# VSS nwell r_width=2u r_length=5.025u
X49 VSS.t68 a_n5549_6703# q1 VSS.t67 nfet_03v3 ad=0.27p pd=2.1u as=0.6p ps=3.2u w=0.6u l=0.28u
X50 a_36688_7607# vbn.t981 a_36978_8187# VSS.t91 nfet_03v3 ad=0.56p pd=2.56u as=0.56p ps=2.56u w=2u l=1u
X51 a_36688_5287# vbn.t921 a_36978_5867# VSS.t95 nfet_03v3 ad=0.56p pd=2.56u as=0.56p ps=2.56u w=2u l=1u
X52 a_36978_7027# vbn.t960 a_36688_7607# VSS.t92 nfet_03v3 ad=0.56p pd=2.56u as=0.56p ps=2.56u w=2u l=1u
X53 a_41364_4127# vbn.t761 a_41654_4707# VSS.t97 nfet_03v3 ad=0.56p pd=2.56u as=0.56p ps=2.56u w=2u l=1u
X54 a_6006_4704# bitb2.t0 VSS.t169 VSS.t168 nfet_03v3 ad=0.45p pd=2.9u as=0.45p ps=2.9u w=1u l=0.28u
X55 a_41654_7027# vbn.t795 a_41364_7607# VSS.t92 nfet_03v3 ad=0.56p pd=2.56u as=0.56p ps=2.56u w=2u l=1u
X56 a_36978_5867# vbn.t575 a_36688_6447# VSS.t94 nfet_03v3 ad=0.56p pd=2.56u as=0.56p ps=2.56u w=2u l=1u
X57 a_36688_2967# vbn.t436 a_36978_3547# VSS.t99 nfet_03v3 ad=0.56p pd=2.56u as=0.56p ps=2.56u w=2u l=1u
X58 a_36688_2967# vbn.t412 a_36978_2387# VSS.t100 nfet_03v3 ad=0.56p pd=2.56u as=0.56p ps=2.56u w=2u l=1u
X59 a_41654_8187# vbn.t18 vbn.t19 VSS.t90 nfet_03v3 ad=0.9p pd=4.9u as=0.56p ps=2.56u w=2u l=1u
X60 a_36688_7607# vbn.t642 a_36978_7027# VSS.t92 nfet_03v3 ad=0.56p pd=2.56u as=0.56p ps=2.56u w=2u l=1u
X61 a_36978_5867# vbn.t595 a_36688_6447# VSS.t94 nfet_03v3 ad=0.56p pd=2.56u as=0.56p ps=2.56u w=2u l=1u
X62 a_36978_3547# vbn.t118 a_36688_4127# VSS.t98 nfet_03v3 ad=0.56p pd=2.56u as=0.9p ps=4.9u w=2u l=1u
X63 a_36978_2387# vbn.t395 a_36688_1807# VSS.t101 nfet_03v3 ad=0.56p pd=2.56u as=0.56p ps=2.56u w=2u l=1u
X64 a_36978_4707# vbn.t142 a_36688_5287# VSS.t96 nfet_03v3 ad=0.56p pd=2.56u as=0.56p ps=2.56u w=2u l=1u
X65 a_36688_5287# vbn.t151 a_36978_5867# VSS.t95 nfet_03v3 ad=0.56p pd=2.56u as=0.56p ps=2.56u w=2u l=1u
X66 a_36688_7607# vbn.t211 a_36978_8187# VSS.t91 nfet_03v3 ad=0.56p pd=2.56u as=0.56p ps=2.56u w=2u l=1u
X67 a_36978_8187# vbn.t986 a_36688_7607# VSS.t86 nfet_03v3 ad=0.56p pd=2.56u as=0.9p ps=4.9u w=2u l=1u
X68 a_41364_2967# vbn.t264 a_41654_3547# VSS.t99 nfet_03v3 ad=0.56p pd=2.56u as=0.56p ps=2.56u w=2u l=1u
X69 a_36978_3547# vbn.t116 a_36688_4127# VSS.t98 nfet_03v3 ad=0.56p pd=2.56u as=0.56p ps=2.56u w=2u l=1u
X70 a_36978_1227# vbn.t56 a_36688_1807# VSS.t102 nfet_03v3 ad=0.56p pd=2.56u as=0.56p ps=2.56u w=2u l=1u
X71 a_36688_6447# vbn.t604 a_36978_7027# VSS.t93 nfet_03v3 ad=0.56p pd=2.56u as=0.56p ps=2.56u w=2u l=1u
X72 a_36688_6447# vbn.t580 a_36978_5867# VSS.t94 nfet_03v3 ad=0.56p pd=2.56u as=0.56p ps=2.56u w=2u l=1u
X73 a_36978_2387# vbn.t80 a_36688_2967# VSS.t100 nfet_03v3 ad=0.56p pd=2.56u as=0.56p ps=2.56u w=2u l=1u
X74 VSS.t28 vbnf.t12 VSS.t28 VSS.t27 nfet_03v3 ad=13.7592p pd=49.7u as=0 ps=0 w=49.14u l=10u
X75 a_36688_7607# vbn.t971 a_36978_7027# VSS.t87 nfet_03v3 ad=0.56p pd=2.56u as=0.56p ps=2.56u w=2u l=1u
X76 vbn.t9 vbn.t8 a_41654_8187# VSS.t90 nfet_03v3 ad=0.56p pd=2.56u as=0.56p ps=2.56u w=2u l=1u
X77 a_36978_3547# vbn.t471 a_36688_4127# VSS.t98 nfet_03v3 ad=0.56p pd=2.56u as=0.56p ps=2.56u w=2u l=1u
X78 a_36978_8187# vbn.t216 a_36688_7607# VSS.t91 nfet_03v3 ad=0.56p pd=2.56u as=0.9p ps=4.9u w=2u l=1u
X79 a_41654_1227# vbn.t714 VSS.t110 VSS.t103 nfet_03v3 ad=0.9p pd=4.9u as=0.56p ps=2.56u w=2u l=1u
X80 a_36978_4707# vbn.t900 a_36688_4127# VSS.t88 nfet_03v3 ad=0.56p pd=2.56u as=0.56p ps=2.56u w=2u l=1u
X81 a_41364_4127# vbn.t274 a_41654_4707# VSS.t97 nfet_03v3 ad=0.56p pd=2.56u as=0.56p ps=2.56u w=2u l=1u
X82 a_41364_6447# vbn.t306 a_41654_7027# VSS.t93 nfet_03v3 ad=0.56p pd=2.56u as=0.56p ps=2.56u w=2u l=1u
X83 a_n4384_6451# a_n4642_7514# a_n5234_7514# VSS.t167 nfet_03v3 ad=0.28p pd=1.56u as=1p ps=4u w=1u l=0.28u
X84 a_36688_1807# vbn.t61 a_36978_1227# VSS.t102 nfet_03v3 ad=0.56p pd=2.56u as=0.56p ps=2.56u w=2u l=1u
X85 a_36978_5867# vbn.t154 a_36688_5287# VSS.t95 nfet_03v3 ad=0.56p pd=2.56u as=0.56p ps=2.56u w=2u l=1u
X86 a_36978_5867# vbn.t164 a_36688_6447# VSS.t94 nfet_03v3 ad=0.56p pd=2.56u as=0.56p ps=2.56u w=2u l=1u
X87 a_36978_8187# vbn.t214 a_36688_7607# VSS.t91 nfet_03v3 ad=0.56p pd=2.56u as=0.56p ps=2.56u w=2u l=1u
X88 a_36688_1807# vbn.t837 a_36978_2387# VSS.t101 nfet_03v3 ad=0.56p pd=2.56u as=0.56p ps=2.56u w=2u l=1u
X89 a_36978_3547# vbn.t876 a_36688_4127# VSS.t98 nfet_03v3 ad=0.56p pd=2.56u as=0.56p ps=2.56u w=2u l=1u
X90 a_36688_1807# vbn.t59 a_36978_1227# VSS.t102 nfet_03v3 ad=0.56p pd=2.56u as=0.56p ps=2.56u w=2u l=1u
X91 a_41654_3547# vbn.t753 a_41364_4127# VSS.t98 nfet_03v3 ad=0.56p pd=2.56u as=0.56p ps=2.56u w=2u l=1u
X92 VSS.t105 vbn.t719 a_41654_1227# VSS.t103 nfet_03v3 ad=0.56p pd=2.56u as=0.56p ps=2.56u w=2u l=1u
X93 a_36978_8187# vbn.t667 a_36688_7607# VSS.t91 nfet_03v3 ad=0.56p pd=2.56u as=0.56p ps=2.56u w=2u l=1u
X94 a_41654_4707# vbn.t763 a_41364_5287# VSS.t96 nfet_03v3 ad=0.9p pd=4.9u as=0.56p ps=2.56u w=2u l=1u
X95 a_41654_4707# vbn.t279 a_41364_4127# VSS.t97 nfet_03v3 ad=0.56p pd=2.56u as=0.9p ps=4.9u w=2u l=1u
X96 a_36978_8187# vbn.t998 a_36666_9481# VSS.t88 nfet_03v3 ad=0.56p pd=2.56u as=0.56p ps=2.56u w=2u l=1u
X97 a_36688_4127# vbn.t474 a_36978_3547# VSS.t98 nfet_03v3 ad=0.56p pd=2.56u as=0.56p ps=2.56u w=2u l=1u
X98 a_36688_2967# vbn.t450 a_36978_3547# VSS.t99 nfet_03v3 ad=0.56p pd=2.56u as=0.56p ps=2.56u w=2u l=1u
X99 vbn.t31 vbn.t30 a_41654_8187# VSS.t90 nfet_03v3 ad=0.56p pd=2.56u as=0.56p ps=2.56u w=2u l=1u
X100 a_36688_1807# vbn.t358 a_36978_1227# VSS.t102 nfet_03v3 ad=0.56p pd=2.56u as=0.56p ps=2.56u w=2u l=1u
X101 a_36688_5287# vbn.t159 a_36978_5867# VSS.t95 nfet_03v3 ad=0.56p pd=2.56u as=0.56p ps=2.56u w=2u l=1u
X102 a_36688_1807# vbn.t67 a_36978_2387# VSS.t101 nfet_03v3 ad=0.56p pd=2.56u as=0.56p ps=2.56u w=2u l=1u
X103 VSS.t26 vbnf.t14 VSS.t26 VSS.t25 nfet_03v3 ad=13.7592p pd=49.7u as=0 ps=0 w=49.14u l=10u
X104 a_41654_4707# vbn.t277 a_41364_4127# VSS.t97 nfet_03v3 ad=0.56p pd=2.56u as=0.56p ps=2.56u w=2u l=1u
X105 a_36688_2967# vbn.t426 a_36978_2387# VSS.t100 nfet_03v3 ad=0.56p pd=2.56u as=0.56p ps=2.56u w=2u l=1u
X106 a_36688_5287# vbn.t157 a_36978_5867# VSS.t95 nfet_03v3 ad=0.56p pd=2.56u as=0.56p ps=2.56u w=2u l=1u
X107 a_36978_8187# vbn.t974 a_36688_7607# VSS.t91 nfet_03v3 ad=0.56p pd=2.56u as=0.56p ps=2.56u w=2u l=1u
X108 a_36688_4127# vbn.t887 a_36978_3547# VSS.t87 nfet_03v3 ad=0.56p pd=2.56u as=0.56p ps=2.56u w=2u l=1u
X109 a_41364_5287# vbn.t768 a_41654_4707# VSS.t96 nfet_03v3 ad=0.56p pd=2.56u as=0.56p ps=2.56u w=2u l=1u
X110 a_41654_8187# vbn.t802 a_41364_7607# VSS.t91 nfet_03v3 ad=0.56p pd=2.56u as=0.56p ps=2.56u w=2u l=1u
X111 a_36688_6447# vbn.t618 a_36978_7027# VSS.t93 nfet_03v3 ad=0.56p pd=2.56u as=0.56p ps=2.56u w=2u l=1u
X112 a_41654_8187# vbn.t20 vbn.t21 VSS.t90 nfet_03v3 ad=0.56p pd=2.56u as=0.9p ps=4.9u w=2u l=1u
X113 a_36688_1807# vbn.t819 a_36978_1227# VSS.t102 nfet_03v3 ad=0.9p pd=4.9u as=0.56p ps=2.56u w=2u l=1u
X114 a_36688_5287# vbn.t554 a_36978_5867# VSS.t95 nfet_03v3 ad=0.56p pd=2.56u as=0.56p ps=2.56u w=2u l=1u
X115 a_36688_7607# vbn.t670 a_36978_8187# VSS.t91 nfet_03v3 ad=0.56p pd=2.56u as=0.56p ps=2.56u w=2u l=1u
X116 a_36978_7027# vbn.t635 a_36688_7607# VSS.t92 nfet_03v3 ad=0.56p pd=2.56u as=0.56p ps=2.56u w=2u l=1u
X117 a_1867_7085# a_1632_6633# VDD.t8 VDD.t7 pfet_03v3 ad=2.25p pd=10.9u as=2.25p ps=10.9u w=5u l=0.28u
X118 a_36978_1227# vbn.t816 w_36626_300# VSS.t88 nfet_03v3 ad=0.56p pd=2.56u as=0.56p ps=2.56u w=2u l=1u
X119 VSS.t116 vbn.t232 a_41654_1227# VSS.t103 nfet_03v3 ad=0.56p pd=2.56u as=0.56p ps=2.56u w=2u l=1u
X120 a_36688_6447# vbn.t594 a_36978_5867# VSS.t94 nfet_03v3 ad=0.56p pd=2.56u as=0.56p ps=2.56u w=2u l=1u
X121 a_36978_2387# vbn.t431 a_36688_2967# VSS.t100 nfet_03v3 ad=0.56p pd=2.56u as=0.56p ps=2.56u w=2u l=1u
X122 a_41654_8187# vbn.t24 vbn.t25 VSS.t90 nfet_03v3 ad=0.56p pd=2.56u as=0.56p ps=2.56u w=2u l=1u
X123 a_36978_1227# vbn.t361 a_36688_1807# VSS.t102 nfet_03v3 ad=0.56p pd=2.56u as=0.56p ps=2.56u w=2u l=1u
X124 a_36688_7607# vbn.t191 a_36978_7027# VSS.t92 nfet_03v3 ad=0.56p pd=2.56u as=0.56p ps=2.56u w=2u l=1u
X125 VSS.t48 a_n7601_6703# a_n8217_6703# VSS.t47 nfet_03v3 ad=0.27p pd=2.1u as=0.6p ps=3.2u w=0.6u l=0.28u
X126 a_36978_2387# vbn.t70 a_36688_1807# VSS.t101 nfet_03v3 ad=0.56p pd=2.56u as=0.56p ps=2.56u w=2u l=1u
X127 a_36978_3547# vbn.t864 a_36688_2967# VSS.t99 nfet_03v3 ad=0.56p pd=2.56u as=0.56p ps=2.56u w=2u l=1u
X128 VDD_LS.t15 a_n5549_6703# q1 VDD_LS.t14 pfet_03v3 ad=0.675p pd=3.9u as=1.5p ps=5u w=1.5u l=0.28u
X129 a_36688_7607# vbn.t985 a_36978_8187# VSS.t87 nfet_03v3 ad=0.56p pd=2.56u as=0.56p ps=2.56u w=2u l=1u
X130 a_36688_5287# vbn.t917 a_36978_5867# VSS.t95 nfet_03v3 ad=0.9p pd=4.9u as=0.56p ps=2.56u w=2u l=1u
X131 a_41654_1227# vbn.t237 VSS.t111 VSS.t103 nfet_03v3 ad=0.56p pd=2.56u as=0.9p ps=4.9u w=2u l=1u
X132 a_36978_4707# vbn.t914 a_36688_5287# VSS.t88 nfet_03v3 ad=0.56p pd=2.56u as=0.56p ps=2.56u w=2u l=1u
X133 a_36978_2387# vbn.t854 a_36688_2967# VSS.t100 nfet_03v3 ad=0.56p pd=2.56u as=0.56p ps=2.56u w=2u l=1u
X134 a_36978_5867# vbn.t599 a_36688_6447# VSS.t94 nfet_03v3 ad=0.56p pd=2.56u as=0.56p ps=2.56u w=2u l=1u
X135 a_36978_5867# vbn.t557 a_36688_5287# VSS.t95 nfet_03v3 ad=0.56p pd=2.56u as=0.56p ps=2.56u w=2u l=1u
X136 a_36688_1807# vbn.t75 a_36978_2387# VSS.t101 nfet_03v3 ad=0.56p pd=2.56u as=0.56p ps=2.56u w=2u l=1u
X137 a_41364_5287# vbn.t281 a_41654_4707# VSS.t96 nfet_03v3 ad=0.56p pd=2.56u as=0.56p ps=2.56u w=2u l=1u
X138 a_36978_7027# vbn.t948 a_36688_6447# VSS.t93 nfet_03v3 ad=0.56p pd=2.56u as=0.56p ps=2.56u w=2u l=1u
X139 a_36978_1227# vbn.t828 a_36688_1807# VSS.t102 nfet_03v3 ad=0.56p pd=2.56u as=0.56p ps=2.56u w=2u l=1u
X140 a_36688_2967# vbn.t438 a_36978_3547# VSS.t99 nfet_03v3 ad=0.56p pd=2.56u as=0.56p ps=2.56u w=2u l=1u
X141 a_41654_1227# vbn.t235 VSS.t113 VSS.t103 nfet_03v3 ad=0.56p pd=2.56u as=0.56p ps=2.56u w=2u l=1u
X142 vg.t30 a_6006_14# VSS.t139 VSS.t1 nfet_03v3 ad=0.336p pd=1.76u as=0.336p ps=1.76u w=1.2u l=5.335u
X143 a_36688_7607# vbn.t644 a_36978_7027# VSS.t92 nfet_03v3 ad=0.56p pd=2.56u as=0.56p ps=2.56u w=2u l=1u
X144 a_36978_3547# vbn.t92 a_36688_2967# VSS.t99 nfet_03v3 ad=0.56p pd=2.56u as=0.56p ps=2.56u w=2u l=1u
X145 a_36688_1807# vbn.t73 a_36978_2387# VSS.t101 nfet_03v3 ad=0.56p pd=2.56u as=0.56p ps=2.56u w=2u l=1u
X146 a_36978_5867# vbn.t938 a_36688_6447# VSS.t94 nfet_03v3 ad=0.56p pd=2.56u as=0.56p ps=2.56u w=2u l=1u
X147 a_41654_4707# vbn.t286 a_41364_5287# VSS.t96 nfet_03v3 ad=0.56p pd=2.56u as=0.9p ps=4.9u w=2u l=1u
X148 a_36688_1807# vbn.t386 a_36978_2387# VSS.t101 nfet_03v3 ad=0.56p pd=2.56u as=0.56p ps=2.56u w=2u l=1u
X149 vbn.t3 a_36666_9481# VDD.t10 VDD.t9 pfet_03v3 ad=3.92p pd=14.56u as=6.3p ps=28.9u w=14u l=14u
X150 a_36688_6447# vbn.t606 a_36978_7027# VSS.t93 nfet_03v3 ad=0.56p pd=2.56u as=0.56p ps=2.56u w=2u l=1u
X151 a_36688_4127# vbn.t490 a_36978_4707# VSS.t97 nfet_03v3 ad=0.9p pd=4.9u as=0.56p ps=2.56u w=2u l=1u
X152 a_36978_3547# vbn.t467 a_36688_4127# VSS.t98 nfet_03v3 ad=0.56p pd=2.56u as=0.56p ps=2.56u w=2u l=1u
X153 a_36688_2967# vbn.t857 a_36978_2387# VSS.t89 nfet_03v3 ad=0.56p pd=2.56u as=0.56p ps=2.56u w=2u l=1u
X154 a_36978_7027# vbn.t649 a_36688_7607# VSS.t92 nfet_03v3 ad=0.56p pd=2.56u as=0.56p ps=2.56u w=2u l=1u
X155 a_41654_2387# vbn.t252 a_41364_2967# VSS.t100 nfet_03v3 ad=0.9p pd=4.9u as=0.56p ps=2.56u w=2u l=1u
X156 a_36978_5867# vbn.t926 a_36688_5287# VSS.t95 nfet_03v3 ad=0.56p pd=2.56u as=0.56p ps=2.56u w=2u l=1u
X157 a_36688_2967# vbn.t97 a_36978_3547# VSS.t99 nfet_03v3 ad=0.56p pd=2.56u as=0.56p ps=2.56u w=2u l=1u
X158 a_41654_4707# vbn.t284 a_41364_5287# VSS.t96 nfet_03v3 ad=0.56p pd=2.56u as=0.56p ps=2.56u w=2u l=1u
X159 vg.t39 vbnf.t26 VSS.t2 VSS.t1 nfet_03v3 ad=0.336p pd=1.76u as=0.336p ps=1.76u w=1.2u l=5.335u
X160 a_36688_4127# vbn.t107 a_36978_3547# VSS.t98 nfet_03v3 ad=0.56p pd=2.56u as=0.56p ps=2.56u w=2u l=1u
X161 a_36978_7027# vbn.t176 a_36688_6447# VSS.t93 nfet_03v3 ad=0.56p pd=2.56u as=0.56p ps=2.56u w=2u l=1u
X162 a_41654_1227# vbn.t240 a_41364_1807# VSS.t102 nfet_03v3 ad=0.56p pd=2.56u as=0.56p ps=2.56u w=2u l=1u
X163 a_n4810_7514# a_n5549_6703# VDD_LS.t17 VDD_LS.t16 pfet_03v3 ad=0.56p pd=2.56u as=0.56p ps=2.56u w=2u l=0.28u
X164 vg.t20 a_6006_14# VSS.t149 VSS.t1 nfet_03v3 ad=0.336p pd=1.76u as=0.336p ps=1.76u w=1.2u l=5.335u
X165 a_36688_1807# vbn.t833 a_36978_2387# VSS.t101 nfet_03v3 ad=0.9p pd=4.9u as=0.56p ps=2.56u w=2u l=1u
X166 a_36688_6447# vbn.t941 a_36978_5867# VSS.t89 nfet_03v3 ad=0.56p pd=2.56u as=0.56p ps=2.56u w=2u l=1u
X167 a_36666_9481# vbn.t686 a_36978_8187# VSS.t90 nfet_03v3 ad=0.9p pd=4.9u as=0.56p ps=2.56u w=2u l=1u
X168 a_36978_8187# vbn.t663 a_36688_7607# VSS.t91 nfet_03v3 ad=0.56p pd=2.56u as=0.56p ps=2.56u w=2u l=1u
X169 a_36688_7607# vbn.t654 a_36978_7027# VSS.t92 nfet_03v3 ad=0.56p pd=2.56u as=0.56p ps=2.56u w=2u l=1u
X170 a_41654_5867# vbn.t294 a_41364_6447# VSS.t94 nfet_03v3 ad=0.9p pd=4.9u as=0.56p ps=2.56u w=2u l=1u
X171 vg.t40 a_6156_6633# VSS.t171 VSS.t170 nfet_03v3 ad=0.336p pd=1.76u as=0.54p ps=3.3u w=1.2u l=5.335u
X172 a_36688_6447# vbn.t181 a_36978_7027# VSS.t93 nfet_03v3 ad=0.56p pd=2.56u as=0.56p ps=2.56u w=2u l=1u
X173 a_36978_2387# vbn.t389 a_36688_1807# VSS.t101 nfet_03v3 ad=0.56p pd=2.56u as=0.56p ps=2.56u w=2u l=1u
X174 a_36978_4707# vbn.t493 a_36688_4127# VSS.t97 nfet_03v3 ad=0.56p pd=2.56u as=0.56p ps=2.56u w=2u l=1u
X175 a_36688_7607# vbn.t205 a_36978_8187# VSS.t91 nfet_03v3 ad=0.56p pd=2.56u as=0.56p ps=2.56u w=2u l=1u
X176 a_36688_7607# vbn.t652 a_36978_7027# VSS.t92 nfet_03v3 ad=0.56p pd=2.56u as=0.56p ps=2.56u w=2u l=1u
X177 a_41364_2967# vbn.t255 a_41654_2387# VSS.t100 nfet_03v3 ad=0.56p pd=2.56u as=0.56p ps=2.56u w=2u l=1u
X178 a_36688_4127# vbn.t476 a_36978_3547# VSS.t98 nfet_03v3 ad=0.56p pd=2.56u as=0.56p ps=2.56u w=2u l=1u
X179 a_41654_5867# vbn.t289 a_41364_5287# VSS.t95 nfet_03v3 ad=0.56p pd=2.56u as=0.56p ps=2.56u w=2u l=1u
X180 a_36688_1807# vbn.t360 a_36978_1227# VSS.t102 nfet_03v3 ad=0.56p pd=2.56u as=0.56p ps=2.56u w=2u l=1u
X181 vbnf.t8 bit1.t0 a_6896_6633# VSS.t173 nfet_03v3 ad=0.9p pd=4.9u as=0.9p ps=4.9u w=2u l=0.28u
X182 vg.t26 a_6006_14# VSS.t143 VSS.t52 nfet_03v3 ad=0.336p pd=1.76u as=0.54p ps=3.3u w=1.2u l=5.335u
X183 a_36688_4127# vbn.t119 a_36978_4707# VSS.t97 nfet_03v3 ad=0.9p pd=4.9u as=0.56p ps=2.56u w=2u l=1u
X184 a_996_6587# a_1867_7085# VDD.t3 VDD.t2 pfet_03v3 ad=2.25p pd=10.9u as=2.25p ps=10.9u w=5u l=0.28u
X185 a_36688_7607# vbn.t965 a_36978_7027# VSS.t92 nfet_03v3 ad=0.56p pd=2.56u as=0.56p ps=2.56u w=2u l=1u
X186 a_36978_7027# vbn.t637 a_36688_7607# VSS.t92 nfet_03v3 ad=0.56p pd=2.56u as=0.56p ps=2.56u w=2u l=1u
X187 w_36626_300# vbn.t322 a_36978_1227# VSS.t103 nfet_03v3 ad=0.9p pd=4.9u as=0.56p ps=2.56u w=2u l=1u
X188 a_41364_2967# vbn.t738 a_41654_2387# VSS.t100 nfet_03v3 ad=0.56p pd=2.56u as=0.56p ps=2.56u w=2u l=1u
X189 a_36978_8187# vbn.t689 a_36666_9481# VSS.t90 nfet_03v3 ad=0.56p pd=2.56u as=0.56p ps=2.56u w=2u l=1u
X190 a_36978_7027# vbn.t657 a_36688_7607# VSS.t92 nfet_03v3 ad=0.56p pd=2.56u as=0.9p ps=4.9u w=2u l=1u
X191 a_36978_1227# vbn.t365 a_36688_1807# VSS.t102 nfet_03v3 ad=0.56p pd=2.56u as=0.56p ps=2.56u w=2u l=1u
X192 a_36978_2387# vbn.t842 a_36688_1807# VSS.t101 nfet_03v3 ad=0.56p pd=2.56u as=0.56p ps=2.56u w=2u l=1u
X193 a_36688_1807# vbn.t821 a_36978_1227# VSS.t102 nfet_03v3 ad=0.56p pd=2.56u as=0.56p ps=2.56u w=2u l=1u
X194 a_36978_3547# vbn.t481 a_36688_4127# VSS.t98 nfet_03v3 ad=0.56p pd=2.56u as=0.56p ps=2.56u w=2u l=1u
X195 a_36978_3547# vbn.t457 a_36688_2967# VSS.t99 nfet_03v3 ad=0.56p pd=2.56u as=0.56p ps=2.56u w=2u l=1u
X196 a_36978_4707# vbn.t124 a_36688_4127# VSS.t97 nfet_03v3 ad=0.56p pd=2.56u as=0.56p ps=2.56u w=2u l=1u
X197 a_41364_6447# vbn.t297 a_41654_5867# VSS.t94 nfet_03v3 ad=0.56p pd=2.56u as=0.56p ps=2.56u w=2u l=1u
X198 a_36688_7607# vbn.t672 a_36978_8187# VSS.t91 nfet_03v3 ad=0.56p pd=2.56u as=0.56p ps=2.56u w=2u l=1u
X199 a_36688_5287# vbn.t556 a_36978_5867# VSS.t95 nfet_03v3 ad=0.56p pd=2.56u as=0.56p ps=2.56u w=2u l=1u
X200 a_36666_9481# vbn.t217 a_36978_8187# VSS.t90 nfet_03v3 ad=0.9p pd=4.9u as=0.56p ps=2.56u w=2u l=1u
X201 a_41364_2967# vbn.t736 a_41654_2387# VSS.t100 nfet_03v3 ad=0.56p pd=2.56u as=0.56p ps=2.56u w=2u l=1u
X202 a_36978_1227# vbn.t363 a_36688_1807# VSS.t102 nfet_03v3 ad=0.56p pd=2.56u as=0.56p ps=2.56u w=2u l=1u
X203 vbnf.t2 bitb4.t1 a_6006_14# VDD.t4 pfet_03v3 ad=2.25p pd=10.9u as=2.25p ps=10.9u w=5u l=0.28u
X204 a_41364_6447# vbn.t780 a_41654_5867# VSS.t94 nfet_03v3 ad=0.56p pd=2.56u as=0.56p ps=2.56u w=2u l=1u
X205 a_36688_5287# vbn.t518 a_36978_4707# VSS.t96 nfet_03v3 ad=0.9p pd=4.9u as=0.56p ps=2.56u w=2u l=1u
X206 a_36688_4127# vbn.t486 a_36978_3547# VSS.t98 nfet_03v3 ad=0.56p pd=2.56u as=0.56p ps=2.56u w=2u l=1u
X207 a_36978_3547# vbn.t866 a_36688_2967# VSS.t99 nfet_03v3 ad=0.56p pd=2.56u as=0.56p ps=2.56u w=2u l=1u
X208 a_36978_7027# vbn.t625 a_36688_6447# VSS.t93 nfet_03v3 ad=0.56p pd=2.56u as=0.56p ps=2.56u w=2u l=1u
X209 a_36978_8187# vbn.t677 a_36688_7607# VSS.t91 nfet_03v3 ad=0.56p pd=2.56u as=0.56p ps=2.56u w=2u l=1u
X210 a_36978_5867# vbn.t561 a_36688_5287# VSS.t95 nfet_03v3 ad=0.56p pd=2.56u as=0.56p ps=2.56u w=2u l=1u
X211 a_36688_5287# vbn.t919 a_36978_5867# VSS.t95 nfet_03v3 ad=0.56p pd=2.56u as=0.56p ps=2.56u w=2u l=1u
X212 a_36978_8187# vbn.t222 a_36666_9481# VSS.t90 nfet_03v3 ad=0.56p pd=2.56u as=0.56p ps=2.56u w=2u l=1u
X213 a_36978_1227# vbn.t325 w_36626_300# VSS.t103 nfet_03v3 ad=0.56p pd=2.56u as=0.56p ps=2.56u w=2u l=1u
X214 a_41364_6447# vbn.t778 a_41654_5867# VSS.t94 nfet_03v3 ad=0.56p pd=2.56u as=0.56p ps=2.56u w=2u l=1u
X215 a_41654_3547# vbn.t744 a_41364_2967# VSS.t99 nfet_03v3 ad=0.56p pd=2.56u as=0.56p ps=2.56u w=2u l=1u
X216 a_41654_2387# vbn.t741 a_41364_2967# VSS.t100 nfet_03v3 ad=0.56p pd=2.56u as=0.9p ps=4.9u w=2u l=1u
X217 a_36688_1807# vbn.t368 a_36978_1227# VSS.t102 nfet_03v3 ad=0.56p pd=2.56u as=0.56p ps=2.56u w=2u l=1u
X218 a_36978_4707# vbn.t507 a_36688_4127# VSS.t97 nfet_03v3 ad=0.56p pd=2.56u as=0.56p ps=2.56u w=2u l=1u
X219 a_36688_4127# vbn.t484 a_36978_3547# VSS.t98 nfet_03v3 ad=0.56p pd=2.56u as=0.56p ps=2.56u w=2u l=1u
X220 a_36688_2967# vbn.t460 a_36978_3547# VSS.t99 nfet_03v3 ad=0.56p pd=2.56u as=0.56p ps=2.56u w=2u l=1u
X221 a_41654_2387# vbn.t247 a_41364_1807# VSS.t101 nfet_03v3 ad=0.56p pd=2.56u as=0.56p ps=2.56u w=2u l=1u
X222 a_36978_5867# vbn.t559 a_36688_5287# VSS.t95 nfet_03v3 ad=0.56p pd=2.56u as=0.56p ps=2.56u w=2u l=1u
X223 w_36626_300# vbn.t35 a_36978_1227# VSS.t103 nfet_03v3 ad=0.9p pd=4.9u as=0.56p ps=2.56u w=2u l=1u
X224 a_36978_7027# vbn.t198 a_36688_7607# VSS.t92 nfet_03v3 ad=0.56p pd=2.56u as=0.56p ps=2.56u w=2u l=1u
X225 VSS.t160 vg.t46 VSS.t160 VSS.t159 nfet_03v3 ad=8.5988p pd=31.27u as=0 ps=0 w=30.71u l=4u
X226 vg.t8 a_6006_896# VSS.t57 VSS.t52 nfet_03v3 ad=0.336p pd=1.76u as=0.54p ps=3.3u w=1.2u l=5.335u
X227 VSS.t12 vbnf.t19 VSS.t12 VSS.t11 nfet_03v3 ad=13.7592p pd=49.7u as=0 ps=0 w=49.14u l=10u
X228 a_36978_7027# vbn.t950 a_36688_6447# VSS.t93 nfet_03v3 ad=0.56p pd=2.56u as=0.56p ps=2.56u w=2u l=1u
X229 a_36688_4127# vbn.t881 a_36978_3547# VSS.t98 nfet_03v3 ad=0.56p pd=2.56u as=0.56p ps=2.56u w=2u l=1u
X230 a_36688_7607# vbn.t682 a_36978_8187# VSS.t91 nfet_03v3 ad=0.56p pd=2.56u as=0.56p ps=2.56u w=2u l=1u
X231 a_36978_3547# vbn.t469 a_36688_4127# VSS.t98 nfet_03v3 ad=0.56p pd=2.56u as=0.56p ps=2.56u w=2u l=1u
X232 vg.t10 a_6006_896# VSS.t53 VSS.t52 nfet_03v3 ad=0.336p pd=1.76u as=0.54p ps=3.3u w=1.2u l=5.335u
X233 a_41654_7027# vbn.t786 a_41364_6447# VSS.t93 nfet_03v3 ad=0.56p pd=2.56u as=0.56p ps=2.56u w=2u l=1u
X234 a_41654_5867# vbn.t783 a_41364_6447# VSS.t94 nfet_03v3 ad=0.56p pd=2.56u as=0.9p ps=4.9u w=2u l=1u
X235 a_36978_4707# vbn.t521 a_36688_5287# VSS.t96 nfet_03v3 ad=0.56p pd=2.56u as=0.56p ps=2.56u w=2u l=1u
X236 a_36978_3547# vbn.t489 a_36688_4127# VSS.t98 nfet_03v3 ad=0.56p pd=2.56u as=0.9p ps=4.9u w=2u l=1u
X237 a_36688_2967# vbn.t869 a_36978_3547# VSS.t99 nfet_03v3 ad=0.56p pd=2.56u as=0.56p ps=2.56u w=2u l=1u
X238 a_36688_6447# vbn.t628 a_36978_7027# VSS.t93 nfet_03v3 ad=0.56p pd=2.56u as=0.56p ps=2.56u w=2u l=1u
X239 a_36978_8187# vbn.t703 a_36666_9481# VSS.t90 nfet_03v3 ad=0.56p pd=2.56u as=0.56p ps=2.56u w=2u l=1u
X240 a_36688_7607# vbn.t680 a_36978_8187# VSS.t91 nfet_03v3 ad=0.56p pd=2.56u as=0.56p ps=2.56u w=2u l=1u
X241 a_36688_5287# vbn.t564 a_36978_5867# VSS.t95 nfet_03v3 ad=0.56p pd=2.56u as=0.56p ps=2.56u w=2u l=1u
X242 a_36978_1227# vbn.t40 w_36626_300# VSS.t103 nfet_03v3 ad=0.56p pd=2.56u as=0.56p ps=2.56u w=2u l=1u
X243 a_36688_1807# vbn.t388 a_36978_2387# VSS.t101 nfet_03v3 ad=0.56p pd=2.56u as=0.56p ps=2.56u w=2u l=1u
X244 VSS.t121 VDD_LS.t31 VSS.t121 VSS.t120 nfet_03v3 ad=22.113p pd=99.18u as=0 ps=0 w=49.14u l=10u
X245 a_36688_5287# vbn.t133 a_36978_4707# VSS.t96 nfet_03v3 ad=0.9p pd=4.9u as=0.56p ps=2.56u w=2u l=1u
X246 a_36978_1227# vbn.t351 a_36688_1807# VSS.t102 nfet_03v3 ad=0.56p pd=2.56u as=0.56p ps=2.56u w=2u l=1u
X247 a_36978_1227# vbn.t371 a_36688_1807# VSS.t102 nfet_03v3 ad=0.56p pd=2.56u as=0.56p ps=2.56u w=2u l=1u
X248 a_36688_7607# vbn.t979 a_36978_8187# VSS.t91 nfet_03v3 ad=0.56p pd=2.56u as=0.56p ps=2.56u w=2u l=1u
X249 a_36688_2967# vbn.t99 a_36978_3547# VSS.t99 nfet_03v3 ad=0.56p pd=2.56u as=0.56p ps=2.56u w=2u l=1u
X250 VDD_LS.t3 q1 a_n7286_7514# VDD_LS.t2 pfet_03v3 ad=0.336p pd=1.76u as=1.2p ps=4.4u w=1.2u l=0.28u
X251 a_36978_3547# vbn.t874 a_36688_2967# VSS.t86 nfet_03v3 ad=0.56p pd=2.56u as=0.9p ps=4.9u w=2u l=1u
X252 a_36688_6447# vbn.t953 a_36978_7027# VSS.t93 nfet_03v3 ad=0.56p pd=2.56u as=0.56p ps=2.56u w=2u l=1u
X253 a_36688_4127# vbn.t893 a_36978_4707# VSS.t97 nfet_03v3 ad=0.56p pd=2.56u as=0.56p ps=2.56u w=2u l=1u
X254 a_36978_8187# vbn.t665 a_36688_7607# VSS.t91 nfet_03v3 ad=0.56p pd=2.56u as=0.56p ps=2.56u w=2u l=1u
X255 a_36978_8187# vbn.t685 a_36688_7607# VSS.t91 nfet_03v3 ad=0.56p pd=2.56u as=0.9p ps=4.9u w=2u l=1u
X256 a_36978_2387# vbn.t393 a_36688_1807# VSS.t101 nfet_03v3 ad=0.56p pd=2.56u as=0.56p ps=2.56u w=2u l=1u
X257 a_n4642_7514# ls.t5 a_n4810_7514# VDD_LS.t13 pfet_03v3 ad=2p pd=6u as=0.56p ps=2.56u w=2u l=0.28u
X258 a_n4642_7514# a_n5549_6703# VSS.t70 VSS.t69 nfet_03v3 ad=1p pd=4u as=0.28p ps=1.56u w=1u l=0.28u
X259 a_36688_1807# vbn.t835 a_36978_2387# VSS.t101 nfet_03v3 ad=0.56p pd=2.56u as=0.56p ps=2.56u w=2u l=1u
X260 a_36978_4707# vbn.t138 a_36688_5287# VSS.t96 nfet_03v3 ad=0.56p pd=2.56u as=0.56p ps=2.56u w=2u l=1u
X261 a_36688_1807# vbn.t356 a_36978_1227# VSS.t102 nfet_03v3 ad=0.56p pd=2.56u as=0.56p ps=2.56u w=2u l=1u
X262 a_41654_7027# vbn.t791 a_41364_7607# VSS.t92 nfet_03v3 ad=0.9p pd=4.9u as=0.56p ps=2.56u w=2u l=1u
X263 a_36978_5867# vbn.t547 a_36688_5287# VSS.t95 nfet_03v3 ad=0.56p pd=2.56u as=0.56p ps=2.56u w=2u l=1u
X264 a_36688_2967# vbn.t408 a_36978_2387# VSS.t100 nfet_03v3 ad=0.56p pd=2.56u as=0.56p ps=2.56u w=2u l=1u
X265 a_6006_896# bitb3.t0 VSS.t133 VSS.t132 nfet_03v3 ad=0.45p pd=2.9u as=0.45p ps=2.9u w=1u l=0.28u
X266 a_36978_1227# vbn.t339 w_36626_300# VSS.t103 nfet_03v3 ad=0.56p pd=2.56u as=0.56p ps=2.56u w=2u l=1u
X267 a_36978_5867# vbn.t567 a_36688_5287# VSS.t95 nfet_03v3 ad=0.56p pd=2.56u as=0.56p ps=2.56u w=2u l=1u
X268 a_36688_4127# vbn.t123 a_36978_4707# VSS.t97 nfet_03v3 ad=0.56p pd=2.56u as=0.56p ps=2.56u w=2u l=1u
X269 a_36978_3547# vbn.t114 a_36688_4127# VSS.t98 nfet_03v3 ad=0.56p pd=2.56u as=0.56p ps=2.56u w=2u l=1u
X270 a_36978_3547# vbn.t104 a_36688_2967# VSS.t99 nfet_03v3 ad=0.56p pd=2.56u as=0.9p ps=4.9u w=2u l=1u
X271 a_36978_2387# vbn.t391 a_36688_1807# VSS.t101 nfet_03v3 ad=0.56p pd=2.56u as=0.56p ps=2.56u w=2u l=1u
X272 a_36688_6447# vbn.t183 a_36978_7027# VSS.t93 nfet_03v3 ad=0.56p pd=2.56u as=0.56p ps=2.56u w=2u l=1u
X273 VSS.t22 vbnf.t16 VSS.t22 VSS.t21 nfet_03v3 ad=13.7592p pd=49.7u as=0 ps=0 w=49.14u l=10u
X274 a_36978_7027# vbn.t958 a_36688_6447# VSS.t86 nfet_03v3 ad=0.56p pd=2.56u as=0.9p ps=4.9u w=2u l=1u
X275 vg.t2 a_996_6587# a0.t1 VSS.t37 nfet_03v3 ad=0.9p pd=4.9u as=0.9p ps=4.9u w=2u l=0.28u
X276 a_36666_9481# vbn.t991 a_36978_8187# VSS.t90 nfet_03v3 ad=0.56p pd=2.56u as=0.56p ps=2.56u w=2u l=1u
X277 a_41364_2967# vbn.t257 a_41654_2387# VSS.t100 nfet_03v3 ad=0.56p pd=2.56u as=0.56p ps=2.56u w=2u l=1u
X278 a_36978_3547# vbn.t102 a_36688_2967# VSS.t99 nfet_03v3 ad=0.56p pd=2.56u as=0.56p ps=2.56u w=2u l=1u
X279 a_36978_1227# vbn.t52 a_36688_1807# VSS.t102 nfet_03v3 ad=0.56p pd=2.56u as=0.56p ps=2.56u w=2u l=1u
X280 a_41364_7607# vbn.t796 a_41654_7027# VSS.t92 nfet_03v3 ad=0.56p pd=2.56u as=0.56p ps=2.56u w=2u l=1u
X281 a_36688_6447# vbn.t576 a_36978_5867# VSS.t94 nfet_03v3 ad=0.56p pd=2.56u as=0.56p ps=2.56u w=2u l=1u
X282 a_36688_5287# vbn.t552 a_36978_5867# VSS.t95 nfet_03v3 ad=0.56p pd=2.56u as=0.56p ps=2.56u w=2u l=1u
X283 VSS.t55 a_6006_896# vg.t9 VSS.t15 nfet_03v3 ad=0.336p pd=1.76u as=0.336p ps=1.76u w=1.2u l=5.335u
X284 a_36978_3547# vbn.t443 a_36688_2967# VSS.t99 nfet_03v3 ad=0.56p pd=2.56u as=0.56p ps=2.56u w=2u l=1u
X285 a_36978_7027# vbn.t188 a_36688_6447# VSS.t93 nfet_03v3 ad=0.56p pd=2.56u as=0.9p ps=4.9u w=2u l=1u
X286 a_36688_1807# vbn.t396 a_36978_2387# VSS.t101 nfet_03v3 ad=0.56p pd=2.56u as=0.56p ps=2.56u w=2u l=1u
X287 a_36978_4707# vbn.t535 a_36688_5287# VSS.t96 nfet_03v3 ad=0.56p pd=2.56u as=0.56p ps=2.56u w=2u l=1u
X288 a_36978_8187# vbn.t212 a_36688_7607# VSS.t91 nfet_03v3 ad=0.56p pd=2.56u as=0.56p ps=2.56u w=2u l=1u
X289 a_36666_9481# vbn.t221 a_36978_8187# VSS.t90 nfet_03v3 ad=0.56p pd=2.56u as=0.56p ps=2.56u w=2u l=1u
X290 a_41364_6447# vbn.t299 a_41654_5867# VSS.t94 nfet_03v3 ad=0.56p pd=2.56u as=0.56p ps=2.56u w=2u l=1u
X291 a_36978_4707# vbn.t126 a_36688_4127# VSS.t97 nfet_03v3 ad=0.56p pd=2.56u as=0.56p ps=2.56u w=2u l=1u
X292 a_36978_7027# vbn.t186 a_36688_6447# VSS.t93 nfet_03v3 ad=0.56p pd=2.56u as=0.56p ps=2.56u w=2u l=1u
X293 a_36978_5867# vbn.t150 a_36688_5287# VSS.t95 nfet_03v3 ad=0.56p pd=2.56u as=0.56p ps=2.56u w=2u l=1u
X294 w_36626_300# vbn.t809 a_36978_1227# VSS.t103 nfet_03v3 ad=0.56p pd=2.56u as=0.56p ps=2.56u w=2u l=1u
X295 a_36978_7027# vbn.t611 a_36688_6447# VSS.t93 nfet_03v3 ad=0.56p pd=2.56u as=0.56p ps=2.56u w=2u l=1u
X296 a_36978_3547# vbn.t862 a_36688_2967# VSS.t99 nfet_03v3 ad=0.56p pd=2.56u as=0.56p ps=2.56u w=2u l=1u
X297 a_41654_3547# vbn.t749 a_41364_4127# VSS.t98 nfet_03v3 ad=0.9p pd=4.9u as=0.56p ps=2.56u w=2u l=1u
X298 a_41654_3547# vbn.t746 a_41364_2967# VSS.t99 nfet_03v3 ad=0.56p pd=2.56u as=0.56p ps=2.56u w=2u l=1u
X299 VSS.t127 VDD_LS.t28 VSS.t127 VSS.t126 nfet_03v3 ad=13.7592p pd=49.7u as=0 ps=0 w=49.14u l=10u
X300 VSS.t44 q1 a_n6436_6531# VSS.t43 nfet_03v3 ad=0.168p pd=1.16u as=0.168p ps=1.16u w=0.6u l=0.28u
X301 vbnf.t7 bit2.t0 a_6006_4704# VSS.t172 nfet_03v3 ad=0.9p pd=4.9u as=0.9p ps=4.9u w=2u l=0.28u
X302 VSS.t162 vg.t45 VSS.t162 VSS.t161 nfet_03v3 ad=8.5988p pd=31.27u as=0 ps=0 w=30.71u l=4u
X303 a_36978_7027# vbn.t970 a_36688_7607# VSS.t88 nfet_03v3 ad=0.56p pd=2.56u as=0.56p ps=2.56u w=2u l=1u
X304 a_41364_7607# vbn.t309 a_41654_7027# VSS.t92 nfet_03v3 ad=0.56p pd=2.56u as=0.56p ps=2.56u w=2u l=1u
X305 a_36978_2387# vbn.t379 a_36688_1807# VSS.t101 nfet_03v3 ad=0.56p pd=2.56u as=0.56p ps=2.56u w=2u l=1u
X306 a_36688_2967# vbn.t446 a_36978_3547# VSS.t99 nfet_03v3 ad=0.56p pd=2.56u as=0.56p ps=2.56u w=2u l=1u
X307 a_36688_2967# vbn.t422 a_36978_2387# VSS.t100 nfet_03v3 ad=0.56p pd=2.56u as=0.56p ps=2.56u w=2u l=1u
X308 a_36688_4127# vbn.t131 a_36978_4707# VSS.t97 nfet_03v3 ad=0.56p pd=2.56u as=0.56p ps=2.56u w=2u l=1u
X309 a_36978_2387# vbn.t399 a_36688_1807# VSS.t101 nfet_03v3 ad=0.56p pd=2.56u as=0.56p ps=2.56u w=2u l=1u
X310 w_36626_300# vbn.t39 a_36978_1227# VSS.t103 nfet_03v3 ad=0.56p pd=2.56u as=0.56p ps=2.56u w=2u l=1u
X311 a_36978_8187# vbn.t224 a_36666_9481# VSS.t90 nfet_03v3 ad=0.56p pd=2.56u as=0.56p ps=2.56u w=2u l=1u
X312 a_36688_5287# vbn.t907 a_36978_4707# VSS.t96 nfet_03v3 ad=0.56p pd=2.56u as=0.56p ps=2.56u w=2u l=1u
X313 a_36688_1807# vbn.t370 a_36978_1227# VSS.t102 nfet_03v3 ad=0.56p pd=2.56u as=0.56p ps=2.56u w=2u l=1u
X314 a_36978_7027# vbn.t946 a_36688_6447# VSS.t93 nfet_03v3 ad=0.56p pd=2.56u as=0.56p ps=2.56u w=2u l=1u
X315 a_36688_4127# vbn.t129 a_36978_4707# VSS.t97 nfet_03v3 ad=0.56p pd=2.56u as=0.56p ps=2.56u w=2u l=1u
X316 a_41654_7027# vbn.t788 a_41364_6447# VSS.t93 nfet_03v3 ad=0.56p pd=2.56u as=0.56p ps=2.56u w=2u l=1u
X317 a_41364_4127# vbn.t754 a_41654_3547# VSS.t98 nfet_03v3 ad=0.56p pd=2.56u as=0.56p ps=2.56u w=2u l=1u
X318 VSS.t58 a_6006_896# vg.t5 VSS.t3 nfet_03v3 ad=0.336p pd=1.76u as=0.336p ps=1.76u w=1.2u l=5.335u
X319 a_36688_2967# vbn.t873 a_36978_3547# VSS.t87 nfet_03v3 ad=0.56p pd=2.56u as=0.56p ps=2.56u w=2u l=1u
X320 a_41654_7027# vbn.t314 a_41364_7607# VSS.t92 nfet_03v3 ad=0.56p pd=2.56u as=0.9p ps=4.9u w=2u l=1u
X321 a_36688_1807# vbn.t384 a_36978_2387# VSS.t101 nfet_03v3 ad=0.56p pd=2.56u as=0.56p ps=2.56u w=2u l=1u
X322 a_41654_8187# vbn.t798 a_41364_7607# VSS.t91 nfet_03v3 ad=0.9p pd=4.9u as=0.56p ps=2.56u w=2u l=1u
X323 a_36688_6447# vbn.t614 a_36978_7027# VSS.t93 nfet_03v3 ad=0.56p pd=2.56u as=0.56p ps=2.56u w=2u l=1u
X324 a_36688_6447# vbn.t590 a_36978_5867# VSS.t94 nfet_03v3 ad=0.56p pd=2.56u as=0.56p ps=2.56u w=2u l=1u
X325 a_36688_4127# vbn.t498 a_36978_4707# VSS.t97 nfet_03v3 ad=0.56p pd=2.56u as=0.56p ps=2.56u w=2u l=1u
X326 a_36666_9481# vbn.t229 a_36978_8187# VSS.t90 nfet_03v3 ad=0.56p pd=2.56u as=0.56p ps=2.56u w=2u l=1u
X327 VSS.t146 a_6006_14# vg.t21 VSS.t15 nfet_03v3 ad=0.336p pd=1.76u as=0.336p ps=1.76u w=1.2u l=5.335u
X328 a_36688_5287# vbn.t137 a_36978_4707# VSS.t96 nfet_03v3 ad=0.56p pd=2.56u as=0.56p ps=2.56u w=2u l=1u
X329 a_41654_7027# vbn.t312 a_41364_7607# VSS.t92 nfet_03v3 ad=0.56p pd=2.56u as=0.56p ps=2.56u w=2u l=1u
X330 a_36978_1227# vbn.t375 a_36688_1807# VSS.t102 nfet_03v3 ad=0.56p pd=2.56u as=0.56p ps=2.56u w=2u l=1u
X331 VSS.t152 a_6006_4704# vg.t35 VSS.t15 nfet_03v3 ad=0.336p pd=1.76u as=0.336p ps=1.76u w=1.2u l=5.335u
X332 VDD.t24 a_36666_9481# vbn.t2 VDD.t23 pfet_03v3 ad=6.3p pd=28.9u as=3.92p ps=14.56u w=14u l=14u
X333 a_36688_5287# vbn.t566 a_36978_5867# VSS.t95 nfet_03v3 ad=0.56p pd=2.56u as=0.56p ps=2.56u w=2u l=1u
X334 a_36978_1227# vbn.t42 w_36626_300# VSS.t103 nfet_03v3 ad=0.56p pd=2.56u as=0.56p ps=2.56u w=2u l=1u
X335 VDD.t12 a_36666_9481# vbn.t5 VDD.t11 pfet_03v3 ad=3.92p pd=14.56u as=3.92p ps=14.56u w=14u l=14u
X336 a_41364_7607# vbn.t803 a_41654_8187# VSS.t91 nfet_03v3 ad=0.56p pd=2.56u as=0.56p ps=2.56u w=2u l=1u
X337 a_36978_2387# vbn.t66 a_36688_1807# VSS.t101 nfet_03v3 ad=0.56p pd=2.56u as=0.56p ps=2.56u w=2u l=1u
X338 a_36666_9481# vbn.t227 a_36978_8187# VSS.t90 nfet_03v3 ad=0.56p pd=2.56u as=0.56p ps=2.56u w=2u l=1u
X339 a_36688_6447# vbn.t957 a_36978_7027# VSS.t87 nfet_03v3 ad=0.56p pd=2.56u as=0.56p ps=2.56u w=2u l=1u
X340 a_36978_2387# vbn.t850 a_36688_2967# VSS.t100 nfet_03v3 ad=0.56p pd=2.56u as=0.56p ps=2.56u w=2u l=1u
X341 a_36688_4127# vbn.t889 a_36978_4707# VSS.t97 nfet_03v3 ad=0.9p pd=4.9u as=0.56p ps=2.56u w=2u l=1u
X342 a_36666_9481# vbn.t694 a_36978_8187# VSS.t90 nfet_03v3 ad=0.56p pd=2.56u as=0.56p ps=2.56u w=2u l=1u
X343 a_36978_3547# vbn.t886 a_36688_4127# VSS.t88 nfet_03v3 ad=0.56p pd=2.56u as=0.56p ps=2.56u w=2u l=1u
X344 a_36978_1227# vbn.t826 a_36688_1807# VSS.t102 nfet_03v3 ad=0.56p pd=2.56u as=0.56p ps=2.56u w=2u l=1u
X345 a_36978_5867# vbn.t571 a_36688_5287# VSS.t95 nfet_03v3 ad=0.56p pd=2.56u as=0.56p ps=2.56u w=2u l=1u
X346 a_36978_4707# vbn.t501 a_36688_4127# VSS.t97 nfet_03v3 ad=0.56p pd=2.56u as=0.56p ps=2.56u w=2u l=1u
X347 w_36626_300# vbn.t47 a_36978_1227# VSS.t103 nfet_03v3 ad=0.56p pd=2.56u as=0.56p ps=2.56u w=2u l=1u
X348 a_41364_4127# vbn.t267 a_41654_3547# VSS.t98 nfet_03v3 ad=0.56p pd=2.56u as=0.56p ps=2.56u w=2u l=1u
X349 a_36978_4707# vbn.t140 a_36688_5287# VSS.t96 nfet_03v3 ad=0.56p pd=2.56u as=0.56p ps=2.56u w=2u l=1u
X350 a_36978_5867# vbn.t934 a_36688_6447# VSS.t94 nfet_03v3 ad=0.56p pd=2.56u as=0.56p ps=2.56u w=2u l=1u
X351 a_36688_2967# vbn.t410 a_36978_2387# VSS.t100 nfet_03v3 ad=0.56p pd=2.56u as=0.56p ps=2.56u w=2u l=1u
X352 a_n3607_6703# a_n3101_6703# VDD_LS.t10 VDD_LS.t9 pfet_03v3 ad=1.5p pd=5u as=0.675p ps=3.9u w=1.5u l=0.28u
X353 w_36626_300# vbn.t45 a_36978_1227# VSS.t103 nfet_03v3 ad=0.56p pd=2.56u as=0.56p ps=2.56u w=2u l=1u
X354 vbn.t0 a_60350_8387# a_36666_9481# VSS.t34 nfet_03v3 ad=0.45p pd=2.9u as=0.45p ps=2.9u w=1u l=0.28u
X355 a_36666_9481# vbn.t987 a_36978_8187# VSS.t90 nfet_03v3 ad=0.9p pd=4.9u as=0.56p ps=2.56u w=2u l=1u
X356 a_36978_2387# vbn.t78 a_36688_2967# VSS.t100 nfet_03v3 ad=0.56p pd=2.56u as=0.56p ps=2.56u w=2u l=1u
X357 a_41654_3547# vbn.t272 a_41364_4127# VSS.t98 nfet_03v3 ad=0.56p pd=2.56u as=0.9p ps=4.9u w=2u l=1u
X358 a_36978_5867# vbn.t924 a_36688_5287# VSS.t95 nfet_03v3 ad=0.56p pd=2.56u as=0.56p ps=2.56u w=2u l=1u
X359 w_36626_300# vbn.t330 a_36978_1227# VSS.t103 nfet_03v3 ad=0.56p pd=2.56u as=0.56p ps=2.56u w=2u l=1u
X360 vg.t29 a_6006_14# VSS.t138 VSS.t52 nfet_03v3 ad=0.336p pd=1.76u as=0.54p ps=3.3u w=1.2u l=5.335u
X361 a_36978_8187# vbn.t984 a_36688_7607# VSS.t88 nfet_03v3 ad=0.56p pd=2.56u as=0.56p ps=2.56u w=2u l=1u
X362 a_36978_8187# vbn.t697 a_36666_9481# VSS.t90 nfet_03v3 ad=0.56p pd=2.56u as=0.56p ps=2.56u w=2u l=1u
X363 a_41364_7607# vbn.t316 a_41654_8187# VSS.t91 nfet_03v3 ad=0.56p pd=2.56u as=0.56p ps=2.56u w=2u l=1u
X364 a_36688_5287# vbn.t145 a_36978_4707# VSS.t96 nfet_03v3 ad=0.56p pd=2.56u as=0.56p ps=2.56u w=2u l=1u
X365 a_36978_4707# vbn.t898 a_36688_4127# VSS.t97 nfet_03v3 ad=0.56p pd=2.56u as=0.56p ps=2.56u w=2u l=1u
X366 a_36688_1807# vbn.t829 a_36978_1227# VSS.t89 nfet_03v3 ad=0.56p pd=2.56u as=0.56p ps=2.56u w=2u l=1u
X367 a_36688_6447# vbn.t578 a_36978_5867# VSS.t94 nfet_03v3 ad=0.56p pd=2.56u as=0.56p ps=2.56u w=2u l=1u
X368 a_36978_3547# vbn.t439 a_36688_2967# VSS.t99 nfet_03v3 ad=0.56p pd=2.56u as=0.56p ps=2.56u w=2u l=1u
X369 a_41654_1227# vbn.t238 a_41364_1807# VSS.t102 nfet_03v3 ad=0.9p pd=4.9u as=0.56p ps=2.56u w=2u l=1u
X370 a_41654_3547# vbn.t270 a_41364_4127# VSS.t98 nfet_03v3 ad=0.56p pd=2.56u as=0.56p ps=2.56u w=2u l=1u
X371 a_36688_1807# vbn.t398 a_36978_2387# VSS.t101 nfet_03v3 ad=0.56p pd=2.56u as=0.56p ps=2.56u w=2u l=1u
X372 a_36688_2967# vbn.t93 a_36978_3547# VSS.t99 nfet_03v3 ad=0.56p pd=2.56u as=0.56p ps=2.56u w=2u l=1u
X373 a_36688_2967# vbn.t83 a_36978_2387# VSS.t100 nfet_03v3 ad=0.56p pd=2.56u as=0.56p ps=2.56u w=2u l=1u
X374 a_36688_5287# vbn.t143 a_36978_4707# VSS.t96 nfet_03v3 ad=0.56p pd=2.56u as=0.56p ps=2.56u w=2u l=1u
X375 a_36978_5867# vbn.t162 a_36688_6447# VSS.t94 nfet_03v3 ad=0.56p pd=2.56u as=0.56p ps=2.56u w=2u l=1u
X376 VSS.t164 vg.t44 VSS.t164 VSS.t163 nfet_03v3 ad=8.5988p pd=31.27u as=0 ps=0 w=30.71u l=4u
X377 w_36626_300# vbn.t805 a_36978_1227# VSS.t103 nfet_03v3 ad=0.9p pd=4.9u as=0.56p ps=2.56u w=2u l=1u
X378 a_41654_8187# vbn.t321 a_41364_7607# VSS.t91 nfet_03v3 ad=0.56p pd=2.56u as=0.9p ps=4.9u w=2u l=1u
X379 vg.t23 a_6006_14# VSS.t144 VSS.t5 nfet_03v3 ad=0.336p pd=1.76u as=0.336p ps=1.76u w=1.2u l=5.335u
X380 a_36688_5287# vbn.t526 a_36978_4707# VSS.t96 nfet_03v3 ad=0.56p pd=2.56u as=0.56p ps=2.56u w=2u l=1u
X381 vg.t37 a_6006_4704# VSS.t151 VSS.t52 nfet_03v3 ad=0.336p pd=1.76u as=0.54p ps=3.3u w=1.2u l=5.335u
X382 a_36688_7607# vbn.t630 a_36978_7027# VSS.t92 nfet_03v3 ad=0.9p pd=4.9u as=0.56p ps=2.56u w=2u l=1u
X383 a_36978_7027# vbn.t607 a_36688_6447# VSS.t93 nfet_03v3 ad=0.56p pd=2.56u as=0.56p ps=2.56u w=2u l=1u
X384 a_n7601_6703# a_n7286_7514# VDD_LS.t25 VDD_LS.t24 pfet_03v3 ad=1.2p pd=4.4u as=0.54p ps=3.3u w=1.2u l=0.28u
X385 a_36688_5287# vbn.t927 a_36978_5867# VSS.t89 nfet_03v3 ad=0.56p pd=2.56u as=0.56p ps=2.56u w=2u l=1u
X386 a_36978_1227# vbn.t333 w_36626_300# VSS.t103 nfet_03v3 ad=0.56p pd=2.56u as=0.56p ps=2.56u w=2u l=1u
X387 a_36978_8187# vbn.t996 a_36666_9481# VSS.t90 nfet_03v3 ad=0.56p pd=2.56u as=0.56p ps=2.56u w=2u l=1u
X388 a_41654_5867# vbn.t287 a_41364_5287# VSS.t95 nfet_03v3 ad=0.9p pd=4.9u as=0.56p ps=2.56u w=2u l=1u
X389 a_41654_8187# vbn.t319 a_41364_7607# VSS.t91 nfet_03v3 ad=0.56p pd=2.56u as=0.56p ps=2.56u w=2u l=1u
X390 a_36978_2387# vbn.t403 a_36688_1807# VSS.t101 nfet_03v3 ad=0.56p pd=2.56u as=0.56p ps=2.56u w=2u l=1u
X391 a_36688_6447# vbn.t167 a_36978_5867# VSS.t94 nfet_03v3 ad=0.56p pd=2.56u as=0.56p ps=2.56u w=2u l=1u
X392 a_36688_6447# vbn.t177 a_36978_7027# VSS.t93 nfet_03v3 ad=0.56p pd=2.56u as=0.56p ps=2.56u w=2u l=1u
X393 a_n6694_7514# a_n7601_6703# VSS.t46 VSS.t45 nfet_03v3 ad=0.6p pd=3.2u as=0.168p ps=1.16u w=0.6u l=0.28u
X394 a_41364_1807# vbn.t241 a_41654_1227# VSS.t102 nfet_03v3 ad=0.56p pd=2.56u as=0.56p ps=2.56u w=2u l=1u
X395 a_41654_4707# vbn.t275 a_41364_4127# VSS.t97 nfet_03v3 ad=0.56p pd=2.56u as=0.56p ps=2.56u w=2u l=1u
X396 a_36688_2967# vbn.t448 a_36978_3547# VSS.t99 nfet_03v3 ad=0.56p pd=2.56u as=0.56p ps=2.56u w=2u l=1u
X397 a_36688_5287# vbn.t903 a_36978_4707# VSS.t96 nfet_03v3 ad=0.9p pd=4.9u as=0.56p ps=2.56u w=2u l=1u
X398 a_1632_6633# a_452_6633# vg.t14 VSS.t81 nfet_03v3 ad=0.9p pd=4.9u as=0.9p ps=4.9u w=2u l=0.28u
X399 a_36978_2387# vbn.t840 a_36688_1807# VSS.t101 nfet_03v3 ad=0.56p pd=2.56u as=0.56p ps=2.56u w=2u l=1u
X400 a_41364_1807# vbn.t724 a_41654_1227# VSS.t102 nfet_03v3 ad=0.56p pd=2.56u as=0.56p ps=2.56u w=2u l=1u
X401 a_36978_4707# vbn.t529 a_36688_5287# VSS.t96 nfet_03v3 ad=0.56p pd=2.56u as=0.56p ps=2.56u w=2u l=1u
X402 a_36978_7027# vbn.t633 a_36688_7607# VSS.t92 nfet_03v3 ad=0.56p pd=2.56u as=0.56p ps=2.56u w=2u l=1u
X403 a_36978_1227# vbn.t814 w_36626_300# VSS.t103 nfet_03v3 ad=0.56p pd=2.56u as=0.56p ps=2.56u w=2u l=1u
X404 a_36688_6447# vbn.t616 a_36978_7027# VSS.t93 nfet_03v3 ad=0.56p pd=2.56u as=0.56p ps=2.56u w=2u l=1u
X405 a_36688_4127# vbn.t500 a_36978_4707# VSS.t97 nfet_03v3 ad=0.56p pd=2.56u as=0.56p ps=2.56u w=2u l=1u
X406 a_36978_3547# vbn.t453 a_36688_2967# VSS.t99 nfet_03v3 ad=0.56p pd=2.56u as=0.56p ps=2.56u w=2u l=1u
X407 a_36978_2387# vbn.t429 a_36688_2967# VSS.t100 nfet_03v3 ad=0.56p pd=2.56u as=0.56p ps=2.56u w=2u l=1u
X408 a_41364_5287# vbn.t290 a_41654_5867# VSS.t95 nfet_03v3 ad=0.56p pd=2.56u as=0.56p ps=2.56u w=2u l=1u
X409 a_41654_8187# vbn.t28 vbn.t29 VSS.t90 nfet_03v3 ad=0.56p pd=2.56u as=0.56p ps=2.56u w=2u l=1u
X410 a_36688_7607# vbn.t189 a_36978_7027# VSS.t92 nfet_03v3 ad=0.9p pd=4.9u as=0.56p ps=2.56u w=2u l=1u
X411 a_41364_1807# vbn.t722 a_41654_1227# VSS.t102 nfet_03v3 ad=0.56p pd=2.56u as=0.56p ps=2.56u w=2u l=1u
X412 a_36688_4127# vbn.t462 a_36978_3547# VSS.t98 nfet_03v3 ad=0.9p pd=4.9u as=0.56p ps=2.56u w=2u l=1u
X413 vg.t41 vbnf.t22 VSS.t8 VSS.t5 nfet_03v3 ad=0.336p pd=1.76u as=0.336p ps=1.76u w=1.2u l=5.335u
X414 vg.t19 a_6006_14# VSS.t148 VSS.t52 nfet_03v3 ad=0.336p pd=1.76u as=0.54p ps=3.3u w=1.2u l=5.335u
X415 VSS.t30 vbnf.t11 VSS.t30 VSS.t29 nfet_03v3 ad=13.7592p pd=49.7u as=0 ps=0 w=49.14u l=10u
X416 a_41364_5287# vbn.t773 a_41654_5867# VSS.t95 nfet_03v3 ad=0.56p pd=2.56u as=0.56p ps=2.56u w=2u l=1u
X417 a_36688_2967# vbn.t458 a_36978_3547# VSS.t99 nfet_03v3 ad=0.56p pd=2.56u as=0.56p ps=2.56u w=2u l=1u
X418 a_36978_4707# vbn.t912 a_36688_5287# VSS.t96 nfet_03v3 ad=0.56p pd=2.56u as=0.56p ps=2.56u w=2u l=1u
X419 a_36978_2387# vbn.t852 a_36688_2967# VSS.t100 nfet_03v3 ad=0.56p pd=2.56u as=0.56p ps=2.56u w=2u l=1u
X420 a_36688_1807# vbn.t843 a_36978_2387# VSS.t89 nfet_03v3 ad=0.56p pd=2.56u as=0.56p ps=2.56u w=2u l=1u
X421 a_36978_7027# vbn.t621 a_36688_6447# VSS.t93 nfet_03v3 ad=0.56p pd=2.56u as=0.56p ps=2.56u w=2u l=1u
X422 a_36978_5867# vbn.t597 a_36688_6447# VSS.t94 nfet_03v3 ad=0.56p pd=2.56u as=0.56p ps=2.56u w=2u l=1u
X423 a_36978_4707# vbn.t505 a_36688_4127# VSS.t97 nfet_03v3 ad=0.56p pd=2.56u as=0.56p ps=2.56u w=2u l=1u
X424 a_41654_2387# vbn.t245 a_41364_1807# VSS.t101 nfet_03v3 ad=0.9p pd=4.9u as=0.56p ps=2.56u w=2u l=1u
X425 a_36688_4127# vbn.t891 a_36978_4707# VSS.t97 nfet_03v3 ad=0.56p pd=2.56u as=0.56p ps=2.56u w=2u l=1u
X426 a_41654_1227# vbn.t727 a_41364_1807# VSS.t102 nfet_03v3 ad=0.56p pd=2.56u as=0.9p ps=4.9u w=2u l=1u
X427 a_36666_9481# vbn.t696 a_36978_8187# VSS.t90 nfet_03v3 ad=0.56p pd=2.56u as=0.56p ps=2.56u w=2u l=1u
X428 a_36978_7027# vbn.t194 a_36688_7607# VSS.t92 nfet_03v3 ad=0.56p pd=2.56u as=0.56p ps=2.56u w=2u l=1u
X429 VSS.t33 a_n7872_8894# VSS.t33 VSS.t32 nfet_03v3 ad=7.2p pd=32.9u as=0 ps=0 w=16u l=16u
X430 vg.t42 vbnf.t24 VSS.t6 VSS.t5 nfet_03v3 ad=0.336p pd=1.76u as=0.336p ps=1.76u w=1.2u l=5.335u
X431 a_41364_5287# vbn.t771 a_41654_5867# VSS.t95 nfet_03v3 ad=0.56p pd=2.56u as=0.56p ps=2.56u w=2u l=1u
X432 a_41654_2387# vbn.t737 a_41364_2967# VSS.t100 nfet_03v3 ad=0.56p pd=2.56u as=0.56p ps=2.56u w=2u l=1u
X433 a_41654_1227# vbn.t233 VSS.t115 VSS.t103 nfet_03v3 ad=0.56p pd=2.56u as=0.56p ps=2.56u w=2u l=1u
X434 a_36978_4707# vbn.t503 a_36688_4127# VSS.t97 nfet_03v3 ad=0.56p pd=2.56u as=0.56p ps=2.56u w=2u l=1u
X435 a_36688_2967# vbn.t456 a_36978_3547# VSS.t99 nfet_03v3 ad=0.56p pd=2.56u as=0.56p ps=2.56u w=2u l=1u
X436 a_36688_2967# vbn.t432 a_36978_2387# VSS.t100 nfet_03v3 ad=0.56p pd=2.56u as=0.56p ps=2.56u w=2u l=1u
X437 a_36978_5867# vbn.t936 a_36688_6447# VSS.t94 nfet_03v3 ad=0.56p pd=2.56u as=0.56p ps=2.56u w=2u l=1u
X438 a_36688_2967# vbn.t867 a_36978_3547# VSS.t99 nfet_03v3 ad=0.56p pd=2.56u as=0.56p ps=2.56u w=2u l=1u
X439 a_36688_7607# vbn.t658 a_36978_8187# VSS.t91 nfet_03v3 ad=0.9p pd=4.9u as=0.56p ps=2.56u w=2u l=1u
X440 a_36688_6447# vbn.t626 a_36978_7027# VSS.t93 nfet_03v3 ad=0.56p pd=2.56u as=0.56p ps=2.56u w=2u l=1u
X441 a_36978_8187# vbn.t701 a_36666_9481# VSS.t90 nfet_03v3 ad=0.56p pd=2.56u as=0.56p ps=2.56u w=2u l=1u
X442 a_36666_9481# vbn.t989 a_36978_8187# VSS.t90 nfet_03v3 ad=0.56p pd=2.56u as=0.56p ps=2.56u w=2u l=1u
X443 a_36978_3547# vbn.t465 a_36688_4127# VSS.t98 nfet_03v3 ad=0.56p pd=2.56u as=0.56p ps=2.56u w=2u l=1u
X444 a_36978_3547# vbn.t441 a_36688_2967# VSS.t99 nfet_03v3 ad=0.56p pd=2.56u as=0.56p ps=2.56u w=2u l=1u
X445 a_41654_5867# vbn.t779 a_41364_6447# VSS.t94 nfet_03v3 ad=0.56p pd=2.56u as=0.56p ps=2.56u w=2u l=1u
X446 a_41654_5867# vbn.t776 a_41364_5287# VSS.t95 nfet_03v3 ad=0.56p pd=2.56u as=0.9p ps=4.9u w=2u l=1u
X447 a_36978_3547# vbn.t461 a_36688_2967# VSS.t99 nfet_03v3 ad=0.56p pd=2.56u as=0.9p ps=4.9u w=2u l=1u
X448 VSS.t158 vg.t47 VSS.t158 VSS.t157 nfet_03v3 ad=8.5988p pd=31.27u as=0 ps=0 w=30.71u l=4u
X449 a_36688_2967# vbn.t855 a_36978_2387# VSS.t100 nfet_03v3 ad=0.56p pd=2.56u as=0.56p ps=2.56u w=2u l=1u
X450 a_36978_7027# vbn.t647 a_36688_7607# VSS.t92 nfet_03v3 ad=0.56p pd=2.56u as=0.56p ps=2.56u w=2u l=1u
X451 a_36688_6447# vbn.t624 a_36978_7027# VSS.t93 nfet_03v3 ad=0.56p pd=2.56u as=0.56p ps=2.56u w=2u l=1u
X452 a_36688_6447# vbn.t600 a_36978_5867# VSS.t94 nfet_03v3 ad=0.56p pd=2.56u as=0.56p ps=2.56u w=2u l=1u
X453 a_36688_4127# vbn.t508 a_36978_4707# VSS.t97 nfet_03v3 ad=0.56p pd=2.56u as=0.56p ps=2.56u w=2u l=1u
X454 a_41364_1807# vbn.t248 a_41654_2387# VSS.t101 nfet_03v3 ad=0.56p pd=2.56u as=0.56p ps=2.56u w=2u l=1u
X455 w_36626_300# vbn.t332 a_36978_1227# VSS.t103 nfet_03v3 ad=0.56p pd=2.56u as=0.56p ps=2.56u w=2u l=1u
X456 a_36978_8187# vbn.t699 a_36666_9481# VSS.t90 nfet_03v3 ad=0.56p pd=2.56u as=0.56p ps=2.56u w=2u l=1u
X457 a_36688_4127# vbn.t105 a_36978_3547# VSS.t98 nfet_03v3 ad=0.9p pd=4.9u as=0.56p ps=2.56u w=2u l=1u
X458 a_41654_4707# vbn.t282 a_41364_5287# VSS.t96 nfet_03v3 ad=0.56p pd=2.56u as=0.56p ps=2.56u w=2u l=1u
X459 VSS.t35 a_6896_6633# vg.t1 VSS.t15 nfet_03v3 ad=0.336p pd=1.76u as=0.336p ps=1.76u w=1.2u l=5.335u
X460 VSS.t64 ls.t3 a_n4384_6451# VSS.t63 nfet_03v3 ad=0.28p pd=1.56u as=0.28p ps=1.56u w=1u l=0.28u
X461 VSS.t14 vbnf.t13 VSS.t14 VSS.t13 nfet_03v3 ad=13.7592p pd=49.7u as=0 ps=0 w=49.14u l=10u
X462 a_36688_6447# vbn.t951 a_36978_7027# VSS.t93 nfet_03v3 ad=0.56p pd=2.56u as=0.56p ps=2.56u w=2u l=1u
X463 a_36978_7027# vbn.t609 a_36688_6447# VSS.t93 nfet_03v3 ad=0.56p pd=2.56u as=0.56p ps=2.56u w=2u l=1u
X464 a_36688_2967# vbn.t85 a_36978_2387# VSS.t100 nfet_03v3 ad=0.56p pd=2.56u as=0.56p ps=2.56u w=2u l=1u
X465 a_41364_1807# vbn.t731 a_41654_2387# VSS.t101 nfet_03v3 ad=0.56p pd=2.56u as=0.56p ps=2.56u w=2u l=1u
X466 a_36688_6447# vbn.t939 a_36978_5867# VSS.t94 nfet_03v3 ad=0.56p pd=2.56u as=0.56p ps=2.56u w=2u l=1u
X467 a_36978_2387# vbn.t860 a_36688_2967# VSS.t86 nfet_03v3 ad=0.56p pd=2.56u as=0.9p ps=4.9u w=2u l=1u
X468 a_36978_8187# vbn.t661 a_36688_7607# VSS.t91 nfet_03v3 ad=0.56p pd=2.56u as=0.56p ps=2.56u w=2u l=1u
X469 a_36978_7027# vbn.t629 a_36688_6447# VSS.t93 nfet_03v3 ad=0.56p pd=2.56u as=0.9p ps=4.9u w=2u l=1u
X470 a_36978_1227# vbn.t337 w_36626_300# VSS.t103 nfet_03v3 ad=0.56p pd=2.56u as=0.56p ps=2.56u w=2u l=1u
X471 VDD_LS.t12 ls.t6 a_n5234_7514# VDD_LS.t11 pfet_03v3 ad=0.56p pd=2.56u as=2p ps=6u w=2u l=0.28u
X472 w_36626_300# vbn.t807 a_36978_1227# VSS.t103 nfet_03v3 ad=0.56p pd=2.56u as=0.56p ps=2.56u w=2u l=1u
X473 a_36666_9481# vbn.t704 a_36978_8187# VSS.t90 nfet_03v3 ad=0.56p pd=2.56u as=0.56p ps=2.56u w=2u l=1u
X474 a_36978_3547# vbn.t110 a_36688_4127# VSS.t98 nfet_03v3 ad=0.56p pd=2.56u as=0.56p ps=2.56u w=2u l=1u
X475 a_36688_5287# vbn.t528 a_36978_4707# VSS.t96 nfet_03v3 ad=0.56p pd=2.56u as=0.56p ps=2.56u w=2u l=1u
X476 a_36978_4707# vbn.t491 a_36688_4127# VSS.t97 nfet_03v3 ad=0.56p pd=2.56u as=0.56p ps=2.56u w=2u l=1u
X477 a_36688_1807# vbn.t352 a_36978_1227# VSS.t102 nfet_03v3 ad=0.56p pd=2.56u as=0.56p ps=2.56u w=2u l=1u
X478 a_41364_1807# vbn.t729 a_41654_2387# VSS.t101 nfet_03v3 ad=0.56p pd=2.56u as=0.56p ps=2.56u w=2u l=1u
X479 a_36978_4707# vbn.t511 a_36688_4127# VSS.t97 nfet_03v3 ad=0.56p pd=2.56u as=0.56p ps=2.56u w=2u l=1u
X480 a_36688_7607# vbn.t203 a_36978_8187# VSS.t91 nfet_03v3 ad=0.9p pd=4.9u as=0.56p ps=2.56u w=2u l=1u
X481 VSS.t136 a_6006_14# vg.t31 VSS.t15 nfet_03v3 ad=0.336p pd=1.76u as=0.336p ps=1.76u w=1.2u l=5.335u
X482 a_36978_1227# vbn.t335 w_36626_300# VSS.t103 nfet_03v3 ad=0.56p pd=2.56u as=0.56p ps=2.56u w=2u l=1u
X483 a_36978_3547# vbn.t100 a_36688_2967# VSS.t99 nfet_03v3 ad=0.56p pd=2.56u as=0.56p ps=2.56u w=2u l=1u
X484 a_36978_2387# vbn.t90 a_36688_2967# VSS.t100 nfet_03v3 ad=0.56p pd=2.56u as=0.9p ps=4.9u w=2u l=1u
X485 a_36688_6447# vbn.t169 a_36978_5867# VSS.t94 nfet_03v3 ad=0.56p pd=2.56u as=0.56p ps=2.56u w=2u l=1u
X486 a_36688_7607# vbn.t963 a_36978_7027# VSS.t92 nfet_03v3 ad=0.56p pd=2.56u as=0.56p ps=2.56u w=2u l=1u
X487 a_36978_5867# vbn.t944 a_36688_6447# VSS.t86 nfet_03v3 ad=0.56p pd=2.56u as=0.9p ps=4.9u w=2u l=1u
X488 a_41364_1807# vbn.t243 a_41654_1227# VSS.t102 nfet_03v3 ad=0.56p pd=2.56u as=0.56p ps=2.56u w=2u l=1u
X489 a_36978_4707# vbn.t533 a_36688_5287# VSS.t96 nfet_03v3 ad=0.56p pd=2.56u as=0.56p ps=2.56u w=2u l=1u
X490 a_36688_4127# vbn.t496 a_36978_4707# VSS.t97 nfet_03v3 ad=0.56p pd=2.56u as=0.56p ps=2.56u w=2u l=1u
X491 a_36978_2387# vbn.t88 a_36688_2967# VSS.t100 nfet_03v3 ad=0.56p pd=2.56u as=0.56p ps=2.56u w=2u l=1u
X492 a_36978_8187# vbn.t208 a_36688_7607# VSS.t91 nfet_03v3 ad=0.56p pd=2.56u as=0.56p ps=2.56u w=2u l=1u
X493 a_36688_5287# vbn.t905 a_36978_4707# VSS.t96 nfet_03v3 ad=0.56p pd=2.56u as=0.56p ps=2.56u w=2u l=1u
X494 a_41654_2387# vbn.t734 a_41364_1807# VSS.t101 nfet_03v3 ad=0.56p pd=2.56u as=0.9p ps=4.9u w=2u l=1u
X495 a_36688_5287# vbn.t548 a_36978_5867# VSS.t95 nfet_03v3 ad=0.56p pd=2.56u as=0.56p ps=2.56u w=2u l=1u
X496 VSS.t77 vctrl.t0 vg.t12 VSS.t15 nfet_03v3 ad=0.54p pd=3.3u as=0.336p ps=1.76u w=1.2u l=21.335u
X497 a_36978_8187# vbn.t687 a_36666_9481# VSS.t90 nfet_03v3 ad=0.56p pd=2.56u as=0.56p ps=2.56u w=2u l=1u
X498 a_36978_3547# vbn.t479 a_36688_4127# VSS.t98 nfet_03v3 ad=0.56p pd=2.56u as=0.56p ps=2.56u w=2u l=1u
X499 w_36626_300# vbn.t340 a_36978_1227# VSS.t103 nfet_03v3 ad=0.56p pd=2.56u as=0.56p ps=2.56u w=2u l=1u
X500 a_36978_8187# vbn.t707 a_36666_9481# VSS.t90 nfet_03v3 ad=0.56p pd=2.56u as=0.56p ps=2.56u w=2u l=1u
X501 a_36978_2387# vbn.t415 a_36688_2967# VSS.t100 nfet_03v3 ad=0.56p pd=2.56u as=0.56p ps=2.56u w=2u l=1u
X502 a_36978_5867# vbn.t174 a_36688_6447# VSS.t94 nfet_03v3 ad=0.56p pd=2.56u as=0.9p ps=4.9u w=2u l=1u
X503 a_36978_7027# vbn.t184 a_36688_6447# VSS.t93 nfet_03v3 ad=0.56p pd=2.56u as=0.56p ps=2.56u w=2u l=1u
X504 a_36688_7607# vbn.t193 a_36978_7027# VSS.t92 nfet_03v3 ad=0.56p pd=2.56u as=0.56p ps=2.56u w=2u l=1u
X505 a_36978_4707# vbn.t531 a_36688_5287# VSS.t96 nfet_03v3 ad=0.56p pd=2.56u as=0.56p ps=2.56u w=2u l=1u
X506 a_n6436_6531# a_n6694_7514# a_n7286_7514# VSS.t31 nfet_03v3 ad=0.168p pd=1.16u as=0.6p ps=3.2u w=0.6u l=0.28u
X507 a_36978_4707# vbn.t122 a_36688_4127# VSS.t97 nfet_03v3 ad=0.56p pd=2.56u as=0.56p ps=2.56u w=2u l=1u
X508 a_41364_5287# vbn.t292 a_41654_5867# VSS.t95 nfet_03v3 ad=0.56p pd=2.56u as=0.56p ps=2.56u w=2u l=1u
X509 a_36666_9481# vbn.t692 a_36978_8187# VSS.t90 nfet_03v3 ad=0.56p pd=2.56u as=0.56p ps=2.56u w=2u l=1u
X510 a_36978_5867# vbn.t172 a_36688_6447# VSS.t94 nfet_03v3 ad=0.56p pd=2.56u as=0.56p ps=2.56u w=2u l=1u
X511 a_36688_5287# vbn.t536 a_36978_4707# VSS.t96 nfet_03v3 ad=0.56p pd=2.56u as=0.56p ps=2.56u w=2u l=1u
X512 a_36978_2387# vbn.t848 a_36688_2967# VSS.t100 nfet_03v3 ad=0.56p pd=2.56u as=0.56p ps=2.56u w=2u l=1u
X513 a_36978_8187# vbn.t675 a_36688_7607# VSS.t91 nfet_03v3 ad=0.56p pd=2.56u as=0.56p ps=2.56u w=2u l=1u
X514 a_36978_5867# vbn.t583 a_36688_6447# VSS.t94 nfet_03v3 ad=0.56p pd=2.56u as=0.56p ps=2.56u w=2u l=1u
X515 vbnf.t3 bitb1.t1 a_6896_6633# VDD.t5 pfet_03v3 ad=2.25p pd=10.9u as=2.25p ps=10.9u w=5u l=0.28u
X516 a_41654_3547# vbn.t742 a_41364_2967# VSS.t99 nfet_03v3 ad=0.9p pd=4.9u as=0.56p ps=2.56u w=2u l=1u
X517 a_41654_2387# vbn.t739 a_41364_2967# VSS.t100 nfet_03v3 ad=0.56p pd=2.56u as=0.56p ps=2.56u w=2u l=1u
X518 a_36978_1227# vbn.t323 w_36626_300# VSS.t103 nfet_03v3 ad=0.56p pd=2.56u as=0.56p ps=2.56u w=2u l=1u
X519 a_36978_1227# vbn.t343 w_36626_300# VSS.t103 nfet_03v3 ad=0.56p pd=2.56u as=0.56p ps=2.56u w=2u l=1u
X520 a_36688_1807# vbn.t366 a_36978_1227# VSS.t102 nfet_03v3 ad=0.56p pd=2.56u as=0.56p ps=2.56u w=2u l=1u
X521 vbnf.t0 bit3.t0 a_6006_896# VSS.t0 nfet_03v3 ad=0.9p pd=4.9u as=0.9p ps=4.9u w=2u l=0.28u
X522 a_36688_2967# vbn.t418 a_36978_2387# VSS.t100 nfet_03v3 ad=0.56p pd=2.56u as=0.56p ps=2.56u w=2u l=1u
X523 a_36978_7027# vbn.t196 a_36688_7607# VSS.t92 nfet_03v3 ad=0.56p pd=2.56u as=0.56p ps=2.56u w=2u l=1u
X524 a_36688_4127# vbn.t879 a_36978_3547# VSS.t98 nfet_03v3 ad=0.56p pd=2.56u as=0.56p ps=2.56u w=2u l=1u
X525 a_36978_8187# vbn.t220 a_36666_9481# VSS.t90 nfet_03v3 ad=0.56p pd=2.56u as=0.56p ps=2.56u w=2u l=1u
X526 a_36978_5867# vbn.t932 a_36688_6447# VSS.t94 nfet_03v3 ad=0.56p pd=2.56u as=0.56p ps=2.56u w=2u l=1u
X527 w_36626_300# vbn.t328 a_36978_1227# VSS.t103 nfet_03v3 ad=0.56p pd=2.56u as=0.56p ps=2.56u w=2u l=1u
X528 a_41654_7027# vbn.t784 a_41364_6447# VSS.t93 nfet_03v3 ad=0.9p pd=4.9u as=0.56p ps=2.56u w=2u l=1u
X529 a_41654_5867# vbn.t781 a_41364_6447# VSS.t94 nfet_03v3 ad=0.56p pd=2.56u as=0.56p ps=2.56u w=2u l=1u
X530 a_41364_2967# vbn.t747 a_41654_3547# VSS.t99 nfet_03v3 ad=0.56p pd=2.56u as=0.56p ps=2.56u w=2u l=1u
X531 a_36688_2967# vbn.t859 a_36978_2387# VSS.t87 nfet_03v3 ad=0.56p pd=2.56u as=0.56p ps=2.56u w=2u l=1u
X532 a_36978_4707# vbn.t519 a_36688_5287# VSS.t96 nfet_03v3 ad=0.56p pd=2.56u as=0.56p ps=2.56u w=2u l=1u
X533 a_36688_1807# vbn.t380 a_36978_2387# VSS.t101 nfet_03v3 ad=0.56p pd=2.56u as=0.56p ps=2.56u w=2u l=1u
X534 a_36688_6447# vbn.t586 a_36978_5867# VSS.t94 nfet_03v3 ad=0.56p pd=2.56u as=0.56p ps=2.56u w=2u l=1u
X535 a_36688_5287# vbn.t562 a_36978_5867# VSS.t95 nfet_03v3 ad=0.56p pd=2.56u as=0.56p ps=2.56u w=2u l=1u
X536 a_36978_4707# vbn.t539 a_36688_5287# VSS.t96 nfet_03v3 ad=0.56p pd=2.56u as=0.56p ps=2.56u w=2u l=1u
X537 a_36688_7607# vbn.t201 a_36978_7027# VSS.t92 nfet_03v3 ad=0.56p pd=2.56u as=0.56p ps=2.56u w=2u l=1u
X538 a_36688_4127# vbn.t109 a_36978_3547# VSS.t98 nfet_03v3 ad=0.56p pd=2.56u as=0.56p ps=2.56u w=2u l=1u
X539 w_37791_300# VSS.t131 VSS.t130 nplus_u r_width=2u r_length=100u
X540 a_36688_4127# vbn.t510 a_36978_4707# VSS.t97 nfet_03v3 ad=0.56p pd=2.56u as=0.56p ps=2.56u w=2u l=1u
X541 a_36688_7607# vbn.t977 a_36978_8187# VSS.t91 nfet_03v3 ad=0.56p pd=2.56u as=0.56p ps=2.56u w=2u l=1u
X542 a_36688_7607# vbn.t199 a_36978_7027# VSS.t92 nfet_03v3 ad=0.56p pd=2.56u as=0.56p ps=2.56u w=2u l=1u
X543 a_41364_1807# vbn.t250 a_41654_2387# VSS.t101 nfet_03v3 ad=0.56p pd=2.56u as=0.56p ps=2.56u w=2u l=1u
X544 a_41364_6447# vbn.t789 a_41654_7027# VSS.t93 nfet_03v3 ad=0.56p pd=2.56u as=0.56p ps=2.56u w=2u l=1u
X545 a_36978_1227# vbn.t38 w_36626_300# VSS.t103 nfet_03v3 ad=0.56p pd=2.56u as=0.56p ps=2.56u w=2u l=1u
X546 a_36978_1227# vbn.t822 a_36688_1807# VSS.t102 nfet_03v3 ad=0.56p pd=2.56u as=0.56p ps=2.56u w=2u l=1u
X547 a_36688_5287# vbn.t524 a_36978_4707# VSS.t96 nfet_03v3 ad=0.56p pd=2.56u as=0.56p ps=2.56u w=2u l=1u
X548 a_36688_6447# vbn.t943 a_36978_5867# VSS.t87 nfet_03v3 ad=0.56p pd=2.56u as=0.56p ps=2.56u w=2u l=1u
X549 a_36688_7607# vbn.t638 a_36978_7027# VSS.t92 nfet_03v3 ad=0.56p pd=2.56u as=0.56p ps=2.56u w=2u l=1u
X550 a_36688_7607# vbn.t207 a_36978_8187# VSS.t91 nfet_03v3 ad=0.56p pd=2.56u as=0.56p ps=2.56u w=2u l=1u
X551 vg.t27 a_6006_14# VSS.t140 VSS.t5 nfet_03v3 ad=0.336p pd=1.76u as=0.336p ps=1.76u w=1.2u l=5.335u
X552 a_36978_3547# vbn.t872 a_36688_2967# VSS.t88 nfet_03v3 ad=0.56p pd=2.56u as=0.56p ps=2.56u w=2u l=1u
X553 a_36978_4707# vbn.t515 a_36688_4127# VSS.t97 nfet_03v3 ad=0.56p pd=2.56u as=0.56p ps=2.56u w=2u l=1u
X554 a_41364_2967# vbn.t260 a_41654_3547# VSS.t99 nfet_03v3 ad=0.56p pd=2.56u as=0.56p ps=2.56u w=2u l=1u
X555 a_36666_9481# vbn.t706 a_36978_8187# VSS.t90 nfet_03v3 ad=0.56p pd=2.56u as=0.56p ps=2.56u w=2u l=1u
X556 a_36978_3547# vbn.t112 a_36688_4127# VSS.t98 nfet_03v3 ad=0.56p pd=2.56u as=0.56p ps=2.56u w=2u l=1u
X557 a_36978_4707# vbn.t136 a_36688_5287# VSS.t96 nfet_03v3 ad=0.56p pd=2.56u as=0.56p ps=2.56u w=2u l=1u
X558 a_36688_1807# vbn.t354 a_36978_1227# VSS.t102 nfet_03v3 ad=0.56p pd=2.56u as=0.56p ps=2.56u w=2u l=1u
X559 a_36978_5867# vbn.t920 a_36688_5287# VSS.t95 nfet_03v3 ad=0.56p pd=2.56u as=0.56p ps=2.56u w=2u l=1u
X560 a_6156_6633# bitb0.t0 VSS.t76 VSS.t75 nfet_03v3 ad=0.45p pd=2.9u as=0.45p ps=2.9u w=1u l=0.28u
X561 a_36688_7607# vbn.t959 a_36978_7027# VSS.t92 nfet_03v3 ad=0.9p pd=4.9u as=0.56p ps=2.56u w=2u l=1u
X562 a_36978_1227# vbn.t50 a_36688_1807# VSS.t102 nfet_03v3 ad=0.56p pd=2.56u as=0.56p ps=2.56u w=2u l=1u
X563 a_36978_4707# vbn.t896 a_36688_4127# VSS.t97 nfet_03v3 ad=0.56p pd=2.56u as=0.56p ps=2.56u w=2u l=1u
X564 a_36978_7027# vbn.t956 a_36688_6447# VSS.t88 nfet_03v3 ad=0.56p pd=2.56u as=0.56p ps=2.56u w=2u l=1u
X565 a_36978_7027# vbn.t641 a_36688_7607# VSS.t92 nfet_03v3 ad=0.56p pd=2.56u as=0.56p ps=2.56u w=2u l=1u
X566 a_41654_3547# vbn.t265 a_41364_2967# VSS.t99 nfet_03v3 ad=0.56p pd=2.56u as=0.9p ps=4.9u w=2u l=1u
X567 a_41364_6447# vbn.t302 a_41654_7027# VSS.t93 nfet_03v3 ad=0.56p pd=2.56u as=0.56p ps=2.56u w=2u l=1u
X568 a_36978_8187# vbn.t711 a_36666_9481# VSS.t90 nfet_03v3 ad=0.56p pd=2.56u as=0.56p ps=2.56u w=2u l=1u
X569 a_36688_4127# vbn.t117 a_36978_3547# VSS.t98 nfet_03v3 ad=0.56p pd=2.56u as=0.56p ps=2.56u w=2u l=1u
X570 a_36688_1807# vbn.t394 a_36978_2387# VSS.t101 nfet_03v3 ad=0.56p pd=2.56u as=0.56p ps=2.56u w=2u l=1u
X571 vg.t7 a_6006_896# VSS.t49 VSS.t5 nfet_03v3 ad=0.336p pd=1.76u as=0.336p ps=1.76u w=1.2u l=5.335u
X572 VDD.t16 a_36666_9481# a_36666_9481# VDD.t15 pfet_03v3 ad=3.92p pd=14.56u as=3.92p ps=14.56u w=14u l=14u
X573 a_36978_8187# vbn.t210 a_36688_7607# VSS.t91 nfet_03v3 ad=0.56p pd=2.56u as=0.56p ps=2.56u w=2u l=1u
X574 a_36688_5287# vbn.t550 a_36978_5867# VSS.t95 nfet_03v3 ad=0.56p pd=2.56u as=0.56p ps=2.56u w=2u l=1u
X575 a_36978_2387# vbn.t411 a_36688_2967# VSS.t100 nfet_03v3 ad=0.56p pd=2.56u as=0.56p ps=2.56u w=2u l=1u
X576 a_36688_1807# vbn.t55 a_36978_1227# VSS.t102 nfet_03v3 ad=0.56p pd=2.56u as=0.56p ps=2.56u w=2u l=1u
X577 a_41654_3547# vbn.t263 a_41364_2967# VSS.t99 nfet_03v3 ad=0.56p pd=2.56u as=0.56p ps=2.56u w=2u l=1u
X578 w_36626_300# vbn.t342 a_36978_1227# VSS.t103 nfet_03v3 ad=0.56p pd=2.56u as=0.56p ps=2.56u w=2u l=1u
X579 a_n7872_8894# ls.t0 VSS.t41 ppolyf_u_1k r_width=1u r_length=0.15912m
X580 a_36688_4127# vbn.t115 a_36978_3547# VSS.t98 nfet_03v3 ad=0.56p pd=2.56u as=0.56p ps=2.56u w=2u l=1u
X581 VSS.t18 vbnf.t18 VSS.t18 VSS.t17 nfet_03v3 ad=13.7592p pd=49.7u as=0 ps=0 w=49.14u l=10u
X582 a_36688_2967# vbn.t79 a_36978_2387# VSS.t100 nfet_03v3 ad=0.56p pd=2.56u as=0.56p ps=2.56u w=2u l=1u
X583 a_36978_5867# vbn.t148 a_36688_5287# VSS.t95 nfet_03v3 ad=0.56p pd=2.56u as=0.56p ps=2.56u w=2u l=1u
X584 a_41654_7027# vbn.t307 a_41364_6447# VSS.t93 nfet_03v3 ad=0.56p pd=2.56u as=0.9p ps=4.9u w=2u l=1u
X585 a_36978_8187# vbn.t994 a_36666_9481# VSS.t90 nfet_03v3 ad=0.56p pd=2.56u as=0.56p ps=2.56u w=2u l=1u
X586 a_36688_4127# vbn.t470 a_36978_3547# VSS.t98 nfet_03v3 ad=0.56p pd=2.56u as=0.56p ps=2.56u w=2u l=1u
X587 a_36688_7607# vbn.t215 a_36978_8187# VSS.t91 nfet_03v3 ad=0.56p pd=2.56u as=0.56p ps=2.56u w=2u l=1u
X588 a_36688_4127# vbn.t899 a_36978_4707# VSS.t89 nfet_03v3 ad=0.56p pd=2.56u as=0.56p ps=2.56u w=2u l=1u
X589 a_36978_5867# vbn.t579 a_36688_6447# VSS.t94 nfet_03v3 ad=0.56p pd=2.56u as=0.56p ps=2.56u w=2u l=1u
X590 a_36978_1227# vbn.t347 w_36626_300# VSS.t103 nfet_03v3 ad=0.56p pd=2.56u as=0.56p ps=2.56u w=2u l=1u
X591 VDD.t1 a_996_6587# a0.t0 VDD.t0 pfet_03v3 ad=2.25p pd=10.9u as=2.25p ps=10.9u w=5u l=0.28u
X592 a_36978_7027# vbn.t968 a_36688_7607# VSS.t92 nfet_03v3 ad=0.56p pd=2.56u as=0.56p ps=2.56u w=2u l=1u
X593 a_41654_4707# vbn.t273 a_41364_4127# VSS.t97 nfet_03v3 ad=0.9p pd=4.9u as=0.56p ps=2.56u w=2u l=1u
X594 a_41654_7027# vbn.t305 a_41364_6447# VSS.t93 nfet_03v3 ad=0.56p pd=2.56u as=0.56p ps=2.56u w=2u l=1u
X595 ck.t0 a_n8217_6703# VDD_LS.t1 VDD_LS.t0 pfet_03v3 ad=2.5p pd=7u as=1.125p ps=5.9u w=2.5u l=0.28u
X596 a_n5549_6703# a_n5234_7514# VDD_LS.t19 VDD_LS.t18 pfet_03v3 ad=2p pd=6u as=0.9p ps=4.9u w=2u l=0.28u
X597 a_36688_5287# vbn.t538 a_36978_4707# VSS.t96 nfet_03v3 ad=0.56p pd=2.56u as=0.56p ps=2.56u w=2u l=1u
X598 a_36688_5287# vbn.t153 a_36978_5867# VSS.t95 nfet_03v3 ad=0.56p pd=2.56u as=0.56p ps=2.56u w=2u l=1u
X599 a_36688_6447# vbn.t163 a_36978_5867# VSS.t94 nfet_03v3 ad=0.56p pd=2.56u as=0.56p ps=2.56u w=2u l=1u
X600 a_36688_7607# vbn.t213 a_36978_8187# VSS.t91 nfet_03v3 ad=0.56p pd=2.56u as=0.56p ps=2.56u w=2u l=1u
X601 a_36978_2387# vbn.t836 a_36688_1807# VSS.t101 nfet_03v3 ad=0.56p pd=2.56u as=0.56p ps=2.56u w=2u l=1u
X602 a_36688_4127# vbn.t875 a_36978_3547# VSS.t98 nfet_03v3 ad=0.9p pd=4.9u as=0.56p ps=2.56u w=2u l=1u
X603 a_36688_7607# vbn.t666 a_36978_8187# VSS.t91 nfet_03v3 ad=0.56p pd=2.56u as=0.56p ps=2.56u w=2u l=1u
X604 a_36688_2967# vbn.t420 a_36978_2387# VSS.t100 nfet_03v3 ad=0.56p pd=2.56u as=0.56p ps=2.56u w=2u l=1u
X605 a_36978_1227# vbn.t812 w_36626_300# VSS.t103 nfet_03v3 ad=0.56p pd=2.56u as=0.56p ps=2.56u w=2u l=1u
X606 a_36666_9481# vbn.t997 a_36978_8187# VSS.t89 nfet_03v3 ad=0.56p pd=2.56u as=0.56p ps=2.56u w=2u l=1u
X607 a_36978_4707# vbn.t543 a_36688_5287# VSS.t96 nfet_03v3 ad=0.56p pd=2.56u as=0.56p ps=2.56u w=2u l=1u
X608 a_36978_3547# vbn.t473 a_36688_4127# VSS.t98 nfet_03v3 ad=0.56p pd=2.56u as=0.56p ps=2.56u w=2u l=1u
X609 a_41654_8187# vbn.t32 vbn.t33 VSS.t90 nfet_03v3 ad=0.9p pd=4.9u as=0.56p ps=2.56u w=2u l=1u
X610 a_41364_4127# vbn.t276 a_41654_4707# VSS.t97 nfet_03v3 ad=0.56p pd=2.56u as=0.56p ps=2.56u w=2u l=1u
X611 a_41654_7027# vbn.t310 a_41364_7607# VSS.t92 nfet_03v3 ad=0.56p pd=2.56u as=0.56p ps=2.56u w=2u l=1u
X612 a_36978_1227# vbn.t373 a_36688_1807# VSS.t102 nfet_03v3 ad=0.56p pd=2.56u as=0.56p ps=2.56u w=2u l=1u
X613 a_36688_1807# vbn.t382 a_36978_2387# VSS.t101 nfet_03v3 ad=0.56p pd=2.56u as=0.56p ps=2.56u w=2u l=1u
X614 a_36688_6447# vbn.t588 a_36978_5867# VSS.t94 nfet_03v3 ad=0.56p pd=2.56u as=0.56p ps=2.56u w=2u l=1u
X615 a_36978_2387# vbn.t425 a_36688_2967# VSS.t100 nfet_03v3 ad=0.56p pd=2.56u as=0.56p ps=2.56u w=2u l=1u
X616 VSS.t24 vbnf.t15 VSS.t24 VSS.t23 nfet_03v3 ad=13.7592p pd=49.7u as=0 ps=0 w=49.14u l=10u
X617 a_36688_7607# vbn.t973 a_36978_8187# VSS.t91 nfet_03v3 ad=0.9p pd=4.9u as=0.56p ps=2.56u w=2u l=1u
X618 vbnf.t6 bitb2.t1 a_6006_4704# VDD.t32 pfet_03v3 ad=2.25p pd=10.9u as=2.25p ps=10.9u w=5u l=0.28u
X619 a_36978_2387# vbn.t64 a_36688_1807# VSS.t101 nfet_03v3 ad=0.56p pd=2.56u as=0.56p ps=2.56u w=2u l=1u
X620 a_36978_4707# vbn.t910 a_36688_5287# VSS.t96 nfet_03v3 ad=0.56p pd=2.56u as=0.56p ps=2.56u w=2u l=1u
X621 a_36978_8187# vbn.t669 a_36688_7607# VSS.t91 nfet_03v3 ad=0.56p pd=2.56u as=0.56p ps=2.56u w=2u l=1u
X622 a_41364_4127# vbn.t759 a_41654_4707# VSS.t97 nfet_03v3 ad=0.56p pd=2.56u as=0.56p ps=2.56u w=2u l=1u
X623 a_36688_2967# vbn.t434 a_36978_3547# VSS.t99 nfet_03v3 ad=0.9p pd=4.9u as=0.56p ps=2.56u w=2u l=1u
X624 ls.t2 a_n3607_6703# VDD_LS.t23 VDD_LS.t22 pfet_03v3 ad=3p pd=8u as=1.35p ps=6.9u w=3u l=0.28u
X625 a_36978_3547# vbn.t884 a_36688_4127# VSS.t98 nfet_03v3 ad=0.56p pd=2.56u as=0.56p ps=2.56u w=2u l=1u
X626 a_36978_1227# vbn.t824 a_36688_1807# VSS.t102 nfet_03v3 ad=0.56p pd=2.56u as=0.56p ps=2.56u w=2u l=1u
X627 w_36626_300# vbn.t815 a_36978_1227# VSS.t89 nfet_03v3 ad=0.56p pd=2.56u as=0.56p ps=2.56u w=2u l=1u
X628 a_41654_1227# vbn.t231 VSS.t117 VSS.t103 nfet_03v3 ad=0.9p pd=4.9u as=0.56p ps=2.56u w=2u l=1u
X629 a_36688_7607# vbn.t640 a_36978_7027# VSS.t92 nfet_03v3 ad=0.56p pd=2.56u as=0.56p ps=2.56u w=2u l=1u
X630 a_36978_5867# vbn.t593 a_36688_6447# VSS.t94 nfet_03v3 ad=0.56p pd=2.56u as=0.56p ps=2.56u w=2u l=1u
X631 a_36978_5867# vbn.t569 a_36688_5287# VSS.t95 nfet_03v3 ad=0.56p pd=2.56u as=0.56p ps=2.56u w=2u l=1u
X632 a_36688_2967# vbn.t430 a_36978_2387# VSS.t100 nfet_03v3 ad=0.56p pd=2.56u as=0.56p ps=2.56u w=2u l=1u
X633 vbn.t27 vbn.t26 a_41654_8187# VSS.t90 nfet_03v3 ad=0.56p pd=2.56u as=0.56p ps=2.56u w=2u l=1u
X634 a_41654_1227# vbn.t723 a_41364_1807# VSS.t102 nfet_03v3 ad=0.56p pd=2.56u as=0.56p ps=2.56u w=2u l=1u
X635 a_36688_1807# vbn.t69 a_36978_2387# VSS.t101 nfet_03v3 ad=0.56p pd=2.56u as=0.56p ps=2.56u w=2u l=1u
X636 a_41364_4127# vbn.t757 a_41654_4707# VSS.t97 nfet_03v3 ad=0.56p pd=2.56u as=0.56p ps=2.56u w=2u l=1u
X637 a_36688_1807# vbn.t376 a_36978_1227# VSS.t102 nfet_03v3 ad=0.56p pd=2.56u as=0.56p ps=2.56u w=2u l=1u
X638 a_n5549_6703# ls.t4 a_n5128_6451# VSS.t62 nfet_03v3 ad=1p pd=4u as=0.28p ps=1.56u w=1u l=0.28u
X639 a_36688_2967# vbn.t428 a_36978_2387# VSS.t100 nfet_03v3 ad=0.56p pd=2.56u as=0.56p ps=2.56u w=2u l=1u
X640 vbn.t13 vbn.t12 a_41654_8187# VSS.t90 nfet_03v3 ad=0.56p pd=2.56u as=0.56p ps=2.56u w=2u l=1u
X641 a_36688_6447# vbn.t602 a_36978_7027# VSS.t93 nfet_03v3 ad=0.9p pd=4.9u as=0.56p ps=2.56u w=2u l=1u
X642 a_36978_5867# vbn.t922 a_36688_5287# VSS.t95 nfet_03v3 ad=0.56p pd=2.56u as=0.56p ps=2.56u w=2u l=1u
X643 a_36688_5287# vbn.t913 a_36978_4707# VSS.t89 nfet_03v3 ad=0.56p pd=2.56u as=0.56p ps=2.56u w=2u l=1u
X644 a_36688_2967# vbn.t853 a_36978_2387# VSS.t100 nfet_03v3 ad=0.56p pd=2.56u as=0.56p ps=2.56u w=2u l=1u
X645 a_36978_7027# vbn.t645 a_36688_7607# VSS.t92 nfet_03v3 ad=0.56p pd=2.56u as=0.56p ps=2.56u w=2u l=1u
X646 a_36688_6447# vbn.t598 a_36978_5867# VSS.t94 nfet_03v3 ad=0.56p pd=2.56u as=0.56p ps=2.56u w=2u l=1u
X647 a_41654_4707# vbn.t280 a_41364_5287# VSS.t96 nfet_03v3 ad=0.9p pd=4.9u as=0.56p ps=2.56u w=2u l=1u
X648 a_36978_8187# vbn.t982 a_36688_7607# VSS.t91 nfet_03v3 ad=0.56p pd=2.56u as=0.56p ps=2.56u w=2u l=1u
X649 a_36688_7607# vbn.t961 a_36978_7027# VSS.t92 nfet_03v3 ad=0.56p pd=2.56u as=0.56p ps=2.56u w=2u l=1u
X650 a_41654_4707# vbn.t762 a_41364_4127# VSS.t97 nfet_03v3 ad=0.56p pd=2.56u as=0.9p ps=4.9u w=2u l=1u
X651 a_36978_3547# vbn.t437 a_36688_2967# VSS.t99 nfet_03v3 ad=0.56p pd=2.56u as=0.56p ps=2.56u w=2u l=1u
X652 a_36978_2387# vbn.t413 a_36688_2967# VSS.t100 nfet_03v3 ad=0.56p pd=2.56u as=0.56p ps=2.56u w=2u l=1u
X653 VSS.t125 VDD_LS.t29 VSS.t125 VSS.t124 nfet_03v3 ad=13.7592p pd=49.7u as=0 ps=0 w=49.14u l=10u
X654 a_36688_1807# vbn.t827 a_36978_1227# VSS.t102 nfet_03v3 ad=0.56p pd=2.56u as=0.56p ps=2.56u w=2u l=1u
X655 vbn.t17 vbn.t16 a_41654_8187# VSS.t90 nfet_03v3 ad=0.56p pd=2.56u as=0.56p ps=2.56u w=2u l=1u
X656 a_41654_5867# vbn.t772 a_41364_5287# VSS.t95 nfet_03v3 ad=0.56p pd=2.56u as=0.56p ps=2.56u w=2u l=1u
X657 VSS.t114 vbn.t234 a_41654_1227# VSS.t103 nfet_03v3 ad=0.56p pd=2.56u as=0.56p ps=2.56u w=2u l=1u
X658 a_41654_3547# vbn.t268 a_41364_4127# VSS.t98 nfet_03v3 ad=0.56p pd=2.56u as=0.56p ps=2.56u w=2u l=1u
X659 a_36978_7027# vbn.t643 a_36688_7607# VSS.t92 nfet_03v3 ad=0.56p pd=2.56u as=0.56p ps=2.56u w=2u l=1u
X660 a_36688_6447# vbn.t596 a_36978_5867# VSS.t94 nfet_03v3 ad=0.56p pd=2.56u as=0.56p ps=2.56u w=2u l=1u
X661 a_36688_5287# vbn.t572 a_36978_5867# VSS.t95 nfet_03v3 ad=0.56p pd=2.56u as=0.56p ps=2.56u w=2u l=1u
X662 a_36978_2387# vbn.t433 a_36688_2967# VSS.t100 nfet_03v3 ad=0.56p pd=2.56u as=0.9p ps=4.9u w=2u l=1u
X663 a_36688_2967# vbn.t91 a_36978_3547# VSS.t99 nfet_03v3 ad=0.9p pd=4.9u as=0.56p ps=2.56u w=2u l=1u
X664 a_36688_6447# vbn.t937 a_36978_5867# VSS.t94 nfet_03v3 ad=0.56p pd=2.56u as=0.56p ps=2.56u w=2u l=1u
X665 a_36688_1807# vbn.t57 a_36978_1227# VSS.t102 nfet_03v3 ad=0.56p pd=2.56u as=0.56p ps=2.56u w=2u l=1u
X666 a_36978_1227# vbn.t832 a_36688_1807# VSS.t86 nfet_03v3 ad=0.56p pd=2.56u as=0.9p ps=4.9u w=2u l=1u
X667 VSS.t107 vbn.t717 a_41654_1227# VSS.t103 nfet_03v3 ad=0.56p pd=2.56u as=0.56p ps=2.56u w=2u l=1u
X668 a_36978_5867# vbn.t581 a_36688_6447# VSS.t94 nfet_03v3 ad=0.56p pd=2.56u as=0.56p ps=2.56u w=2u l=1u
X669 a_41654_8187# vbn.t6 vbn.t7 VSS.t90 nfet_03v3 ad=0.56p pd=2.56u as=0.9p ps=4.9u w=2u l=1u
X670 a_36978_7027# vbn.t605 a_36688_6447# VSS.t93 nfet_03v3 ad=0.56p pd=2.56u as=0.56p ps=2.56u w=2u l=1u
X671 ck.t1 a_n8217_6703# VSS.t40 VSS.t39 nfet_03v3 ad=1p pd=4u as=0.45p ps=2.9u w=1u l=0.28u
X672 a_36688_5287# vbn.t925 a_36978_5867# VSS.t95 nfet_03v3 ad=0.56p pd=2.56u as=0.56p ps=2.56u w=2u l=1u
X673 a_36688_7607# vbn.t648 a_36978_7027# VSS.t92 nfet_03v3 ad=0.56p pd=2.56u as=0.56p ps=2.56u w=2u l=1u
X674 a_36978_5867# vbn.t601 a_36688_6447# VSS.t94 nfet_03v3 ad=0.56p pd=2.56u as=0.9p ps=4.9u w=2u l=1u
X675 a_41364_5287# vbn.t283 a_41654_4707# VSS.t96 nfet_03v3 ad=0.56p pd=2.56u as=0.56p ps=2.56u w=2u l=1u
X676 a_36978_2387# vbn.t401 a_36688_1807# VSS.t101 nfet_03v3 ad=0.56p pd=2.56u as=0.56p ps=2.56u w=2u l=1u
X677 a_6896_6633# bitb1.t0 VSS.t74 VSS.t73 nfet_03v3 ad=0.45p pd=2.9u as=0.45p ps=2.9u w=1u l=0.28u
X678 a_36666_9481# a_36666_9481# VDD.t14 VDD.t13 pfet_03v3 ad=3.92p pd=14.56u as=3.92p ps=14.56u w=14u l=14u
X679 a_36688_4127# vbn.t472 a_36978_3547# VSS.t98 nfet_03v3 ad=0.56p pd=2.56u as=0.56p ps=2.56u w=2u l=1u
X680 a_36978_3547# vbn.t96 a_36688_2967# VSS.t99 nfet_03v3 ad=0.56p pd=2.56u as=0.56p ps=2.56u w=2u l=1u
X681 a_41654_8187# vbn.t317 a_41364_7607# VSS.t91 nfet_03v3 ad=0.56p pd=2.56u as=0.56p ps=2.56u w=2u l=1u
X682 VSS.t109 vbn.t715 a_41654_1227# VSS.t103 nfet_03v3 ad=0.56p pd=2.56u as=0.56p ps=2.56u w=2u l=1u
X683 a_36688_6447# vbn.t175 a_36978_7027# VSS.t93 nfet_03v3 ad=0.9p pd=4.9u as=0.56p ps=2.56u w=2u l=1u
X684 a_36978_1227# vbn.t62 a_36688_1807# VSS.t102 nfet_03v3 ad=0.56p pd=2.56u as=0.9p ps=4.9u w=2u l=1u
X685 a_n7180_6531# a_n7286_7514# VSS.t85 VSS.t84 nfet_03v3 ad=0.168p pd=1.16u as=0.27p ps=2.1u w=0.6u l=0.28u
X686 a_36978_2387# vbn.t86 a_36688_2967# VSS.t100 nfet_03v3 ad=0.56p pd=2.56u as=0.56p ps=2.56u w=2u l=1u
X687 VSS.t119 vbn.t34 a_60350_8387# VSS.t118 nfet_03v3 ad=0.9p pd=4.9u as=2.36p ps=6.36u w=2u l=0.28u
X688 a_36688_5287# vbn.t155 a_36978_5867# VSS.t95 nfet_03v3 ad=0.56p pd=2.56u as=0.56p ps=2.56u w=2u l=1u
X689 VSS.t56 a_6006_896# vg.t11 VSS.t50 nfet_03v3 ad=0.54p pd=3.3u as=0.336p ps=1.76u w=1.2u l=5.335u
X690 a_36978_5867# vbn.t930 a_36688_5287# VSS.t86 nfet_03v3 ad=0.56p pd=2.56u as=0.9p ps=4.9u w=2u l=1u
X691 a_41364_5287# vbn.t766 a_41654_4707# VSS.t96 nfet_03v3 ad=0.56p pd=2.56u as=0.56p ps=2.56u w=2u l=1u
X692 a_36978_3547# vbn.t477 a_36688_4127# VSS.t98 nfet_03v3 ad=0.56p pd=2.56u as=0.56p ps=2.56u w=2u l=1u
X693 a_36688_4127# vbn.t877 a_36978_3547# VSS.t98 nfet_03v3 ad=0.56p pd=2.56u as=0.56p ps=2.56u w=2u l=1u
X694 a_36978_2387# vbn.t838 a_36688_1807# VSS.t101 nfet_03v3 ad=0.56p pd=2.56u as=0.56p ps=2.56u w=2u l=1u
X695 a_36978_1227# vbn.t60 a_36688_1807# VSS.t102 nfet_03v3 ad=0.56p pd=2.56u as=0.56p ps=2.56u w=2u l=1u
X696 a_36978_7027# vbn.t180 a_36688_6447# VSS.t93 nfet_03v3 ad=0.56p pd=2.56u as=0.56p ps=2.56u w=2u l=1u
X697 a_41654_1227# vbn.t720 VSS.t104 VSS.t103 nfet_03v3 ad=0.56p pd=2.56u as=0.9p ps=4.9u w=2u l=1u
X698 a_36688_7607# vbn.t668 a_36978_8187# VSS.t91 nfet_03v3 ad=0.56p pd=2.56u as=0.56p ps=2.56u w=2u l=1u
X699 a_36688_4127# vbn.t492 a_36978_4707# VSS.t97 nfet_03v3 ad=0.56p pd=2.56u as=0.56p ps=2.56u w=2u l=1u
X700 a_41654_2387# vbn.t730 a_41364_1807# VSS.t101 nfet_03v3 ad=0.56p pd=2.56u as=0.56p ps=2.56u w=2u l=1u
X701 a_36978_7027# vbn.t631 a_36688_7607# VSS.t92 nfet_03v3 ad=0.56p pd=2.56u as=0.56p ps=2.56u w=2u l=1u
X702 a_41364_5287# vbn.t764 a_41654_4707# VSS.t96 nfet_03v3 ad=0.56p pd=2.56u as=0.56p ps=2.56u w=2u l=1u
X703 a_36978_7027# vbn.t651 a_36688_7607# VSS.t92 nfet_03v3 ad=0.56p pd=2.56u as=0.56p ps=2.56u w=2u l=1u
X704 a_36978_3547# vbn.t475 a_36688_4127# VSS.t98 nfet_03v3 ad=0.56p pd=2.56u as=0.56p ps=2.56u w=2u l=1u
X705 a_36978_3547# vbn.t451 a_36688_2967# VSS.t99 nfet_03v3 ad=0.56p pd=2.56u as=0.56p ps=2.56u w=2u l=1u
X706 a_36978_1227# vbn.t359 a_36688_1807# VSS.t102 nfet_03v3 ad=0.56p pd=2.56u as=0.56p ps=2.56u w=2u l=1u
X707 a_36688_1807# vbn.t404 a_36978_2387# VSS.t101 nfet_03v3 ad=0.56p pd=2.56u as=0.56p ps=2.56u w=2u l=1u
X708 a_36978_5867# vbn.t160 a_36688_5287# VSS.t95 nfet_03v3 ad=0.56p pd=2.56u as=0.9p ps=4.9u w=2u l=1u
X709 a_36978_5867# vbn.t170 a_36688_6447# VSS.t94 nfet_03v3 ad=0.56p pd=2.56u as=0.56p ps=2.56u w=2u l=1u
X710 a_41364_4127# vbn.t278 a_41654_4707# VSS.t97 nfet_03v3 ad=0.56p pd=2.56u as=0.56p ps=2.56u w=2u l=1u
X711 a_36978_8187# vbn.t673 a_36688_7607# VSS.t91 nfet_03v3 ad=0.56p pd=2.56u as=0.56p ps=2.56u w=2u l=1u
X712 a_36688_7607# vbn.t636 a_36978_7027# VSS.t92 nfet_03v3 ad=0.56p pd=2.56u as=0.56p ps=2.56u w=2u l=1u
X713 a_36688_7607# vbn.t975 a_36978_8187# VSS.t91 nfet_03v3 ad=0.56p pd=2.56u as=0.56p ps=2.56u w=2u l=1u
X714 a_36978_5867# vbn.t158 a_36688_5287# VSS.t95 nfet_03v3 ad=0.56p pd=2.56u as=0.56p ps=2.56u w=2u l=1u
X715 a_36688_1807# vbn.t841 a_36978_2387# VSS.t101 nfet_03v3 ad=0.56p pd=2.56u as=0.56p ps=2.56u w=2u l=1u
X716 a_41654_4707# vbn.t769 a_41364_5287# VSS.t96 nfet_03v3 ad=0.56p pd=2.56u as=0.9p ps=4.9u w=2u l=1u
X717 a_36666_9481# vbn.t688 a_36978_8187# VSS.t90 nfet_03v3 ad=0.56p pd=2.56u as=0.56p ps=2.56u w=2u l=1u
X718 a_36688_4127# vbn.t480 a_36978_3547# VSS.t98 nfet_03v3 ad=0.56p pd=2.56u as=0.56p ps=2.56u w=2u l=1u
X719 a_36978_1227# vbn.t820 a_36688_1807# VSS.t102 nfet_03v3 ad=0.56p pd=2.56u as=0.56p ps=2.56u w=2u l=1u
X720 a_36978_7027# vbn.t619 a_36688_6447# VSS.t93 nfet_03v3 ad=0.56p pd=2.56u as=0.56p ps=2.56u w=2u l=1u
X721 a_41654_1227# vbn.t725 a_41364_1807# VSS.t102 nfet_03v3 ad=0.56p pd=2.56u as=0.56p ps=2.56u w=2u l=1u
X722 a_36978_8187# vbn.t671 a_36688_7607# VSS.t91 nfet_03v3 ad=0.56p pd=2.56u as=0.56p ps=2.56u w=2u l=1u
X723 a_36978_5867# vbn.t555 a_36688_5287# VSS.t95 nfet_03v3 ad=0.56p pd=2.56u as=0.56p ps=2.56u w=2u l=1u
X724 a_1632_6633# a_452_6633# VDD.t26 VDD.t25 pfet_03v3 ad=2.25p pd=10.9u as=2.25p ps=10.9u w=5u l=0.28u
X725 a_41654_2387# vbn.t735 a_41364_2967# VSS.t100 nfet_03v3 ad=0.9p pd=4.9u as=0.56p ps=2.56u w=2u l=1u
X726 a_36688_1807# vbn.t362 a_36978_1227# VSS.t102 nfet_03v3 ad=0.56p pd=2.56u as=0.56p ps=2.56u w=2u l=1u
X727 vbn.t23 vbn.t22 a_41654_8187# VSS.t90 nfet_03v3 ad=0.56p pd=2.56u as=0.56p ps=2.56u w=2u l=1u
X728 a_36688_1807# vbn.t71 a_36978_2387# VSS.t101 nfet_03v3 ad=0.56p pd=2.56u as=0.56p ps=2.56u w=2u l=1u
X729 a_36978_7027# vbn.t192 a_36688_7607# VSS.t92 nfet_03v3 ad=0.56p pd=2.56u as=0.56p ps=2.56u w=2u l=1u
X730 a_36688_2967# vbn.t865 a_36978_3547# VSS.t99 nfet_03v3 ad=0.56p pd=2.56u as=0.56p ps=2.56u w=2u l=1u
X731 a_36978_2387# vbn.t846 a_36688_1807# VSS.t86 nfet_03v3 ad=0.56p pd=2.56u as=0.9p ps=4.9u w=2u l=1u
X732 VSS.t147 a_6006_14# vg.t22 VSS.t50 nfet_03v3 ad=0.54p pd=3.3u as=0.336p ps=1.76u w=1.2u l=5.335u
X733 a_36688_7607# vbn.t676 a_36978_8187# VSS.t91 nfet_03v3 ad=0.56p pd=2.56u as=0.56p ps=2.56u w=2u l=1u
X734 w_36626_300# vbn.t324 a_36978_1227# VSS.t103 nfet_03v3 ad=0.56p pd=2.56u as=0.56p ps=2.56u w=2u l=1u
X735 a_36978_5867# vbn.t918 a_36688_5287# VSS.t95 nfet_03v3 ad=0.56p pd=2.56u as=0.56p ps=2.56u w=2u l=1u
X736 a_36688_1807# vbn.t831 a_36978_1227# VSS.t87 nfet_03v3 ad=0.56p pd=2.56u as=0.56p ps=2.56u w=2u l=1u
X737 a_41364_2967# vbn.t740 a_41654_2387# VSS.t100 nfet_03v3 ad=0.56p pd=2.56u as=0.56p ps=2.56u w=2u l=1u
X738 a_36978_3547# vbn.t463 a_36688_4127# VSS.t98 nfet_03v3 ad=0.56p pd=2.56u as=0.56p ps=2.56u w=2u l=1u
X739 a_41654_5867# vbn.t777 a_41364_6447# VSS.t94 nfet_03v3 ad=0.9p pd=4.9u as=0.56p ps=2.56u w=2u l=1u
X740 a_41654_5867# vbn.t774 a_41364_5287# VSS.t95 nfet_03v3 ad=0.56p pd=2.56u as=0.56p ps=2.56u w=2u l=1u
X741 a_36688_4127# vbn.t506 a_36978_4707# VSS.t97 nfet_03v3 ad=0.56p pd=2.56u as=0.56p ps=2.56u w=2u l=1u
X742 a_36978_3547# vbn.t483 a_36688_4127# VSS.t98 nfet_03v3 ad=0.56p pd=2.56u as=0.56p ps=2.56u w=2u l=1u
X743 VSS.t142 a_6006_14# vg.t25 VSS.t50 nfet_03v3 ad=0.54p pd=3.3u as=0.336p ps=1.76u w=1.2u l=5.335u
X744 a_36688_5287# vbn.t558 a_36978_5867# VSS.t95 nfet_03v3 ad=0.56p pd=2.56u as=0.56p ps=2.56u w=2u l=1u
X745 a_36688_2967# vbn.t95 a_36978_3547# VSS.t99 nfet_03v3 ad=0.56p pd=2.56u as=0.56p ps=2.56u w=2u l=1u
X746 a_36978_2387# vbn.t76 a_36688_1807# VSS.t101 nfet_03v3 ad=0.56p pd=2.56u as=0.9p ps=4.9u w=2u l=1u
X747 a_36688_6447# vbn.t949 a_36978_7027# VSS.t93 nfet_03v3 ad=0.56p pd=2.56u as=0.56p ps=2.56u w=2u l=1u
X748 VSS.t112 vbn.t236 a_41654_1227# VSS.t103 nfet_03v3 ad=0.56p pd=2.56u as=0.56p ps=2.56u w=2u l=1u
X749 a_41364_6447# vbn.t782 a_41654_5867# VSS.t94 nfet_03v3 ad=0.56p pd=2.56u as=0.56p ps=2.56u w=2u l=1u
X750 a_36688_4127# vbn.t468 a_36978_3547# VSS.t98 nfet_03v3 ad=0.56p pd=2.56u as=0.56p ps=2.56u w=2u l=1u
X751 a_36978_2387# vbn.t74 a_36688_1807# VSS.t101 nfet_03v3 ad=0.56p pd=2.56u as=0.56p ps=2.56u w=2u l=1u
X752 a_36666_9481# a_36666_9481# VDD.t18 VDD.t17 pfet_03v3 ad=3.92p pd=14.56u as=3.92p ps=14.56u w=14u l=14u
X753 a_36978_8187# vbn.t659 a_36688_7607# VSS.t91 nfet_03v3 ad=0.56p pd=2.56u as=0.56p ps=2.56u w=2u l=1u
X754 a_36688_5287# vbn.t520 a_36978_4707# VSS.t96 nfet_03v3 ad=0.56p pd=2.56u as=0.56p ps=2.56u w=2u l=1u
X755 a_36688_5287# vbn.t929 a_36978_5867# VSS.t87 nfet_03v3 ad=0.56p pd=2.56u as=0.56p ps=2.56u w=2u l=1u
X756 a_6006_14# bitb4.t0 VSS.t66 VSS.t65 nfet_03v3 ad=0.45p pd=2.9u as=0.45p ps=2.9u w=1u l=0.28u
X757 a_36666_9481# vbn.t702 a_36978_8187# VSS.t90 nfet_03v3 ad=0.56p pd=2.56u as=0.56p ps=2.56u w=2u l=1u
X758 a_36978_8187# vbn.t679 a_36688_7607# VSS.t91 nfet_03v3 ad=0.56p pd=2.56u as=0.56p ps=2.56u w=2u l=1u
X759 a_36688_6447# vbn.t179 a_36978_7027# VSS.t93 nfet_03v3 ad=0.56p pd=2.56u as=0.56p ps=2.56u w=2u l=1u
X760 a_36978_2387# vbn.t387 a_36688_1807# VSS.t101 nfet_03v3 ad=0.56p pd=2.56u as=0.56p ps=2.56u w=2u l=1u
X761 a_36978_2387# vbn.t858 a_36688_2967# VSS.t88 nfet_03v3 ad=0.56p pd=2.56u as=0.56p ps=2.56u w=2u l=1u
X762 a_36688_7607# vbn.t650 a_36978_7027# VSS.t92 nfet_03v3 ad=0.56p pd=2.56u as=0.56p ps=2.56u w=2u l=1u
X763 a_41364_2967# vbn.t253 a_41654_2387# VSS.t100 nfet_03v3 ad=0.56p pd=2.56u as=0.56p ps=2.56u w=2u l=1u
X764 a_41364_5287# vbn.t285 a_41654_4707# VSS.t96 nfet_03v3 ad=0.56p pd=2.56u as=0.56p ps=2.56u w=2u l=1u
X765 a_36978_3547# vbn.t108 a_36688_4127# VSS.t98 nfet_03v3 ad=0.56p pd=2.56u as=0.56p ps=2.56u w=2u l=1u
X766 a_36978_3547# vbn.t98 a_36688_2967# VSS.t99 nfet_03v3 ad=0.56p pd=2.56u as=0.56p ps=2.56u w=2u l=1u
X767 a_36978_4707# vbn.t892 a_36688_4127# VSS.t97 nfet_03v3 ad=0.56p pd=2.56u as=0.56p ps=2.56u w=2u l=1u
X768 a_36688_7607# vbn.t664 a_36978_8187# VSS.t91 nfet_03v3 ad=0.56p pd=2.56u as=0.56p ps=2.56u w=2u l=1u
X769 a_n7601_6703# q1 a_n7180_6531# VSS.t42 nfet_03v3 ad=0.6p pd=3.2u as=0.168p ps=1.16u w=0.6u l=0.28u
X770 VDD_LS.t21 a_n2245_6719# a_n3101_6703# VDD_LS.t20 pfet_03v3 ad=0.225p pd=1.9u as=1.1p ps=5.4u w=0.5u l=0.28u
X771 a_n3607_6703# a_n3101_6703# VSS.t60 VSS.t59 nfet_03v3 ad=0.6p pd=3.2u as=0.27p ps=2.1u w=0.6u l=0.28u
X772 a_36978_2387# vbn.t834 a_36688_1807# VSS.t101 nfet_03v3 ad=0.56p pd=2.56u as=0.56p ps=2.56u w=2u l=1u
X773 a_41654_2387# vbn.t732 a_41364_1807# VSS.t101 nfet_03v3 ad=0.56p pd=2.56u as=0.56p ps=2.56u w=2u l=1u
X774 a_36978_7027# vbn.t655 a_36688_7607# VSS.t92 nfet_03v3 ad=0.56p pd=2.56u as=0.56p ps=2.56u w=2u l=1u
X775 VSS.t7 vbnf.t23 vg.t16 VSS.t3 nfet_03v3 ad=0.336p pd=1.76u as=0.336p ps=1.76u w=1.2u l=5.335u
X776 a_36978_5867# vbn.t942 a_36688_6447# VSS.t88 nfet_03v3 ad=0.56p pd=2.56u as=0.56p ps=2.56u w=2u l=1u
X777 a_41654_2387# vbn.t258 a_41364_2967# VSS.t100 nfet_03v3 ad=0.56p pd=2.56u as=0.9p ps=4.9u w=2u l=1u
X778 a_41364_6447# vbn.t295 a_41654_5867# VSS.t94 nfet_03v3 ad=0.56p pd=2.56u as=0.56p ps=2.56u w=2u l=1u
X779 w_36626_300# vbn.t338 a_36978_1227# VSS.t103 nfet_03v3 ad=0.56p pd=2.56u as=0.56p ps=2.56u w=2u l=1u
X780 a_36688_2967# vbn.t103 a_36978_3547# VSS.t99 nfet_03v3 ad=0.56p pd=2.56u as=0.56p ps=2.56u w=2u l=1u
X781 a_36978_7027# vbn.t182 a_36688_6447# VSS.t93 nfet_03v3 ad=0.56p pd=2.56u as=0.56p ps=2.56u w=2u l=1u
X782 a_36688_1807# vbn.t390 a_36978_2387# VSS.t101 nfet_03v3 ad=0.56p pd=2.56u as=0.56p ps=2.56u w=2u l=1u
X783 a_452_6633# a0.t2 vg.t38 VSS.t134 nfet_03v3 ad=0.9p pd=4.9u as=0.9p ps=4.9u w=2u l=0.28u
X784 a_36688_4127# vbn.t494 a_36978_4707# VSS.t97 nfet_03v3 ad=0.56p pd=2.56u as=0.56p ps=2.56u w=2u l=1u
X785 a_36978_8187# vbn.t206 a_36688_7607# VSS.t91 nfet_03v3 ad=0.56p pd=2.56u as=0.56p ps=2.56u w=2u l=1u
X786 a_36978_1227# vbn.t355 a_36688_1807# VSS.t102 nfet_03v3 ad=0.56p pd=2.56u as=0.56p ps=2.56u w=2u l=1u
X787 a_36978_8187# vbn.t990 a_36666_9481# VSS.t90 nfet_03v3 ad=0.56p pd=2.56u as=0.56p ps=2.56u w=2u l=1u
X788 a_41654_2387# vbn.t256 a_41364_2967# VSS.t100 nfet_03v3 ad=0.56p pd=2.56u as=0.56p ps=2.56u w=2u l=1u
X789 a_36978_4707# vbn.t120 a_36688_4127# VSS.t97 nfet_03v3 ad=0.56p pd=2.56u as=0.56p ps=2.56u w=2u l=1u
X790 a_36688_2967# vbn.t101 a_36978_3547# VSS.t99 nfet_03v3 ad=0.56p pd=2.56u as=0.56p ps=2.56u w=2u l=1u
X791 a_36688_1807# vbn.t51 a_36978_1227# VSS.t102 nfet_03v3 ad=0.56p pd=2.56u as=0.56p ps=2.56u w=2u l=1u
X792 a_36978_7027# vbn.t966 a_36688_7607# VSS.t92 nfet_03v3 ad=0.56p pd=2.56u as=0.56p ps=2.56u w=2u l=1u
X793 a_36688_1807# vbn.t845 a_36978_2387# VSS.t87 nfet_03v3 ad=0.56p pd=2.56u as=0.56p ps=2.56u w=2u l=1u
X794 a_41654_5867# vbn.t300 a_41364_6447# VSS.t94 nfet_03v3 ad=0.56p pd=2.56u as=0.9p ps=4.9u w=2u l=1u
X795 a_36688_5287# vbn.t534 a_36978_4707# VSS.t96 nfet_03v3 ad=0.56p pd=2.56u as=0.56p ps=2.56u w=2u l=1u
X796 a_36688_2967# vbn.t442 a_36978_3547# VSS.t99 nfet_03v3 ad=0.56p pd=2.56u as=0.56p ps=2.56u w=2u l=1u
X797 a_36688_6447# vbn.t187 a_36978_7027# VSS.t93 nfet_03v3 ad=0.56p pd=2.56u as=0.56p ps=2.56u w=2u l=1u
X798 a_n6862_7514# a_n7601_6703# VDD_LS.t8 VDD_LS.t7 pfet_03v3 ad=0.336p pd=1.76u as=0.336p ps=1.76u w=1.2u l=0.28u
X799 VSS.t80 a_n2245_6719# a_n3101_6703# VSS.t79 nfet_03v3 ad=0.1686p pd=1.74u as=0.5448p ps=5.16u w=0.22u l=0.28u
X800 a_36666_9481# vbn.t690 a_36978_8187# VSS.t90 nfet_03v3 ad=0.56p pd=2.56u as=0.56p ps=2.56u w=2u l=1u
X801 a_36978_5867# vbn.t551 a_36688_5287# VSS.t95 nfet_03v3 ad=0.56p pd=2.56u as=0.56p ps=2.56u w=2u l=1u
X802 VDD.t20 a_36666_9481# a_36666_9481# VDD.t19 pfet_03v3 ad=3.92p pd=14.56u as=3.92p ps=14.56u w=14u l=14u
X803 a_36688_4127# vbn.t482 a_36978_3547# VSS.t98 nfet_03v3 ad=0.56p pd=2.56u as=0.56p ps=2.56u w=2u l=1u
X804 a_41654_5867# vbn.t298 a_41364_6447# VSS.t94 nfet_03v3 ad=0.56p pd=2.56u as=0.56p ps=2.56u w=2u l=1u
X805 a_36688_4127# vbn.t125 a_36978_4707# VSS.t97 nfet_03v3 ad=0.56p pd=2.56u as=0.56p ps=2.56u w=2u l=1u
X806 a_36688_6447# vbn.t185 a_36978_7027# VSS.t93 nfet_03v3 ad=0.56p pd=2.56u as=0.56p ps=2.56u w=2u l=1u
X807 a_36688_5287# vbn.t149 a_36978_5867# VSS.t95 nfet_03v3 ad=0.56p pd=2.56u as=0.56p ps=2.56u w=2u l=1u
X808 a_36978_8187# vbn.t218 a_36666_9481# VSS.t90 nfet_03v3 ad=0.56p pd=2.56u as=0.56p ps=2.56u w=2u l=1u
X809 a_36978_1227# vbn.t808 w_36626_300# VSS.t103 nfet_03v3 ad=0.56p pd=2.56u as=0.56p ps=2.56u w=2u l=1u
X810 a_36688_6447# vbn.t610 a_36978_7027# VSS.t93 nfet_03v3 ad=0.56p pd=2.56u as=0.56p ps=2.56u w=2u l=1u
X811 a_36688_1807# vbn.t364 a_36978_1227# VSS.t102 nfet_03v3 ad=0.56p pd=2.56u as=0.56p ps=2.56u w=2u l=1u
X812 vbnf.t9 bit0.t0 a_6156_6633# VSS.t174 nfet_03v3 ad=0.9p pd=4.9u as=0.9p ps=4.9u w=2u l=0.28u
X813 a_36688_2967# vbn.t861 a_36978_3547# VSS.t99 nfet_03v3 ad=0.9p pd=4.9u as=0.56p ps=2.56u w=2u l=1u
X814 a_36688_7607# vbn.t969 a_36978_7027# VSS.t89 nfet_03v3 ad=0.56p pd=2.56u as=0.56p ps=2.56u w=2u l=1u
X815 a_36978_3547# vbn.t487 a_36688_4127# VSS.t98 nfet_03v3 ad=0.56p pd=2.56u as=0.56p ps=2.56u w=2u l=1u
X816 a_41654_7027# vbn.t308 a_41364_7607# VSS.t92 nfet_03v3 ad=0.9p pd=4.9u as=0.56p ps=2.56u w=2u l=1u
X817 a_36978_3547# vbn.t445 a_36688_2967# VSS.t99 nfet_03v3 ad=0.56p pd=2.56u as=0.56p ps=2.56u w=2u l=1u
X818 VSS.t145 a_6006_14# vg.t24 VSS.t3 nfet_03v3 ad=0.336p pd=1.76u as=0.336p ps=1.76u w=1.2u l=5.335u
X819 a_36688_7607# vbn.t678 a_36978_8187# VSS.t91 nfet_03v3 ad=0.56p pd=2.56u as=0.56p ps=2.56u w=2u l=1u
X820 a_36666_9481# vbn.t223 a_36978_8187# VSS.t90 nfet_03v3 ad=0.56p pd=2.56u as=0.56p ps=2.56u w=2u l=1u
X821 w_36626_300# vbn.t326 a_36978_1227# VSS.t103 nfet_03v3 ad=0.56p pd=2.56u as=0.56p ps=2.56u w=2u l=1u
X822 VSS.t141 a_6006_14# vg.t28 VSS.t3 nfet_03v3 ad=0.336p pd=1.76u as=0.336p ps=1.76u w=1.2u l=5.335u
X823 a_36978_4707# vbn.t906 a_36688_5287# VSS.t96 nfet_03v3 ad=0.56p pd=2.56u as=0.56p ps=2.56u w=2u l=1u
X824 a_36978_1227# vbn.t369 a_36688_1807# VSS.t102 nfet_03v3 ad=0.56p pd=2.56u as=0.56p ps=2.56u w=2u l=1u
X825 a_36688_6447# vbn.t945 a_36978_7027# VSS.t93 nfet_03v3 ad=0.9p pd=4.9u as=0.56p ps=2.56u w=2u l=1u
X826 a_36688_5287# vbn.t560 a_36978_5867# VSS.t95 nfet_03v3 ad=0.56p pd=2.56u as=0.56p ps=2.56u w=2u l=1u
X827 a_36978_1227# vbn.t36 w_36626_300# VSS.t103 nfet_03v3 ad=0.56p pd=2.56u as=0.56p ps=2.56u w=2u l=1u
X828 a_36978_3547# vbn.t882 a_36688_4127# VSS.t98 nfet_03v3 ad=0.56p pd=2.56u as=0.56p ps=2.56u w=2u l=1u
X829 a_n5128_6451# a_n5234_7514# VSS.t72 VSS.t71 nfet_03v3 ad=0.28p pd=1.56u as=0.45p ps=2.9u w=1u l=0.28u
X830 a_36978_8187# vbn.t683 a_36688_7607# VSS.t91 nfet_03v3 ad=0.56p pd=2.56u as=0.56p ps=2.56u w=2u l=1u
X831 a_36978_7027# vbn.t613 a_36688_6447# VSS.t93 nfet_03v3 ad=0.56p pd=2.56u as=0.56p ps=2.56u w=2u l=1u
X832 vbnf.t5 bitb3.t1 a_6006_896# VDD.t27 pfet_03v3 ad=2.25p pd=10.9u as=2.25p ps=10.9u w=5u l=0.28u
X833 a_36688_1807# vbn.t374 a_36978_1227# VSS.t102 nfet_03v3 ad=0.56p pd=2.56u as=0.56p ps=2.56u w=2u l=1u
X834 a_36978_2387# vbn.t383 a_36688_1807# VSS.t101 nfet_03v3 ad=0.56p pd=2.56u as=0.56p ps=2.56u w=2u l=1u
X835 a_36688_2967# vbn.t406 a_36978_2387# VSS.t100 nfet_03v3 ad=0.9p pd=4.9u as=0.56p ps=2.56u w=2u l=1u
X836 a_36978_3547# vbn.t870 a_36688_2967# VSS.t99 nfet_03v3 ad=0.56p pd=2.56u as=0.56p ps=2.56u w=2u l=1u
X837 a_36688_5287# vbn.t522 a_36978_4707# VSS.t96 nfet_03v3 ad=0.56p pd=2.56u as=0.56p ps=2.56u w=2u l=1u
X838 a_36978_4707# vbn.t513 a_36688_4127# VSS.t97 nfet_03v3 ad=0.56p pd=2.56u as=0.56p ps=2.56u w=2u l=1u
X839 a_41364_7607# vbn.t311 a_41654_7027# VSS.t92 nfet_03v3 ad=0.56p pd=2.56u as=0.56p ps=2.56u w=2u l=1u
X840 a_36978_5867# vbn.t565 a_36688_5287# VSS.t95 nfet_03v3 ad=0.56p pd=2.56u as=0.56p ps=2.56u w=2u l=1u
X841 w_36626_300# vbn.t41 a_36978_1227# VSS.t103 nfet_03v3 ad=0.56p pd=2.56u as=0.56p ps=2.56u w=2u l=1u
X842 a_36688_1807# vbn.t65 a_36978_2387# VSS.t101 nfet_03v3 ad=0.56p pd=2.56u as=0.56p ps=2.56u w=2u l=1u
X843 a_36978_4707# vbn.t134 a_36688_5287# VSS.t96 nfet_03v3 ad=0.56p pd=2.56u as=0.56p ps=2.56u w=2u l=1u
X844 a_36978_8187# vbn.t980 a_36688_7607# VSS.t91 nfet_03v3 ad=0.56p pd=2.56u as=0.56p ps=2.56u w=2u l=1u
X845 a_36688_1807# vbn.t372 a_36978_1227# VSS.t102 nfet_03v3 ad=0.56p pd=2.56u as=0.56p ps=2.56u w=2u l=1u
X846 a_41364_7607# vbn.t794 a_41654_7027# VSS.t92 nfet_03v3 ad=0.56p pd=2.56u as=0.56p ps=2.56u w=2u l=1u
X847 a_36978_7027# vbn.t954 a_36688_6447# VSS.t93 nfet_03v3 ad=0.56p pd=2.56u as=0.56p ps=2.56u w=2u l=1u
X848 a_36978_4707# vbn.t894 a_36688_4127# VSS.t97 nfet_03v3 ad=0.56p pd=2.56u as=0.56p ps=2.56u w=2u l=1u
X849 a_36688_4127# vbn.t885 a_36978_3547# VSS.t89 nfet_03v3 ad=0.56p pd=2.56u as=0.56p ps=2.56u w=2u l=1u
X850 a_36688_1807# vbn.t825 a_36978_1227# VSS.t102 nfet_03v3 ad=0.56p pd=2.56u as=0.56p ps=2.56u w=2u l=1u
X851 a_36688_6447# vbn.t574 a_36978_5867# VSS.t94 nfet_03v3 ad=0.9p pd=4.9u as=0.56p ps=2.56u w=2u l=1u
X852 a_41654_3547# vbn.t266 a_41364_4127# VSS.t98 nfet_03v3 ad=0.9p pd=4.9u as=0.56p ps=2.56u w=2u l=1u
X853 a_36978_8187# vbn.t709 a_36666_9481# VSS.t90 nfet_03v3 ad=0.56p pd=2.56u as=0.56p ps=2.56u w=2u l=1u
X854 a_36688_5287# vbn.t570 a_36978_5867# VSS.t95 nfet_03v3 ad=0.56p pd=2.56u as=0.56p ps=2.56u w=2u l=1u
X855 VSS.t51 a_6006_896# vg.t6 VSS.t50 nfet_03v3 ad=0.54p pd=3.3u as=0.336p ps=1.76u w=1.2u l=5.335u
X856 a_36978_1227# vbn.t357 a_36688_1807# VSS.t102 nfet_03v3 ad=0.56p pd=2.56u as=0.56p ps=2.56u w=2u l=1u
X857 a_41364_7607# vbn.t792 a_41654_7027# VSS.t92 nfet_03v3 ad=0.56p pd=2.56u as=0.56p ps=2.56u w=2u l=1u
X858 a_41654_4707# vbn.t758 a_41364_4127# VSS.t97 nfet_03v3 ad=0.56p pd=2.56u as=0.56p ps=2.56u w=2u l=1u
X859 a_36978_2387# vbn.t409 a_36688_2967# VSS.t100 nfet_03v3 ad=0.56p pd=2.56u as=0.56p ps=2.56u w=2u l=1u
X860 a_36688_5287# vbn.t139 a_36978_4707# VSS.t96 nfet_03v3 ad=0.56p pd=2.56u as=0.56p ps=2.56u w=2u l=1u
X861 a_36978_1227# vbn.t377 a_36688_1807# VSS.t102 nfet_03v3 ad=0.56p pd=2.56u as=0.9p ps=4.9u w=2u l=1u
X862 a_36688_4127# vbn.t516 a_36978_4707# VSS.t97 nfet_03v3 ad=0.56p pd=2.56u as=0.56p ps=2.56u w=2u l=1u
X863 a_41654_3547# vbn.t261 a_41364_2967# VSS.t99 nfet_03v3 ad=0.56p pd=2.56u as=0.56p ps=2.56u w=2u l=1u
X864 a_36688_5287# vbn.t568 a_36978_5867# VSS.t95 nfet_03v3 ad=0.56p pd=2.56u as=0.56p ps=2.56u w=2u l=1u
X865 a_36688_2967# vbn.t77 a_36978_2387# VSS.t100 nfet_03v3 ad=0.9p pd=4.9u as=0.56p ps=2.56u w=2u l=1u
X866 a_36688_1807# vbn.t392 a_36978_2387# VSS.t101 nfet_03v3 ad=0.56p pd=2.56u as=0.56p ps=2.56u w=2u l=1u
X867 a_36978_8187# vbn.t992 a_36666_9481# VSS.t90 nfet_03v3 ad=0.56p pd=2.56u as=0.56p ps=2.56u w=2u l=1u
X868 a_36688_7607# vbn.t983 a_36978_8187# VSS.t89 nfet_03v3 ad=0.56p pd=2.56u as=0.56p ps=2.56u w=2u l=1u
X869 a_36688_5287# vbn.t923 a_36978_5867# VSS.t95 nfet_03v3 ad=0.56p pd=2.56u as=0.56p ps=2.56u w=2u l=1u
X870 a_41654_8187# vbn.t315 a_41364_7607# VSS.t91 nfet_03v3 ad=0.9p pd=4.9u as=0.56p ps=2.56u w=2u l=1u
X871 a_41654_7027# vbn.t797 a_41364_7607# VSS.t92 nfet_03v3 ad=0.56p pd=2.56u as=0.9p ps=4.9u w=2u l=1u
X872 a_36688_4127# vbn.t897 a_36978_4707# VSS.t97 nfet_03v3 ad=0.56p pd=2.56u as=0.56p ps=2.56u w=2u l=1u
X873 a_41654_8187# vbn.t14 vbn.t15 VSS.t90 nfet_03v3 ad=0.56p pd=2.56u as=0.56p ps=2.56u w=2u l=1u
X874 a_36978_5867# vbn.t577 a_36688_6447# VSS.t94 nfet_03v3 ad=0.56p pd=2.56u as=0.56p ps=2.56u w=2u l=1u
X875 a_36978_5867# vbn.t553 a_36688_5287# VSS.t95 nfet_03v3 ad=0.56p pd=2.56u as=0.56p ps=2.56u w=2u l=1u
X876 a_41364_4127# vbn.t269 a_41654_3547# VSS.t98 nfet_03v3 ad=0.56p pd=2.56u as=0.56p ps=2.56u w=2u l=1u
X877 a_36978_1227# vbn.t345 w_36626_300# VSS.t103 nfet_03v3 ad=0.56p pd=2.56u as=0.56p ps=2.56u w=2u l=1u
X878 a_n6694_7514# q1 a_n6862_7514# VDD_LS.t4 pfet_03v3 ad=1.2p pd=4.4u as=0.336p ps=1.76u w=1.2u l=0.28u
X879 VSS.t137 a_6006_14# vg.t32 VSS.t50 nfet_03v3 ad=0.54p pd=3.3u as=0.336p ps=1.76u w=1.2u l=5.335u
X880 a_36666_9481# vbn.t712 a_36978_8187# VSS.t90 nfet_03v3 ad=0.56p pd=2.56u as=0.56p ps=2.56u w=2u l=1u
X881 a_36978_5867# vbn.t573 a_36688_5287# VSS.t95 nfet_03v3 ad=0.56p pd=2.56u as=0.9p ps=4.9u w=2u l=1u
X882 a_41654_7027# vbn.t303 a_41364_6447# VSS.t93 nfet_03v3 ad=0.56p pd=2.56u as=0.56p ps=2.56u w=2u l=1u
X883 a_36688_2967# vbn.t444 a_36978_3547# VSS.t99 nfet_03v3 ad=0.56p pd=2.56u as=0.56p ps=2.56u w=2u l=1u
X884 a_36978_2387# vbn.t82 a_36688_2967# VSS.t100 nfet_03v3 ad=0.56p pd=2.56u as=0.56p ps=2.56u w=2u l=1u
X885 a_36978_2387# vbn.t397 a_36688_1807# VSS.t101 nfet_03v3 ad=0.56p pd=2.56u as=0.56p ps=2.56u w=2u l=1u
X886 a_36688_6447# vbn.t161 a_36978_5867# VSS.t94 nfet_03v3 ad=0.9p pd=4.9u as=0.56p ps=2.56u w=2u l=1u
X887 a_36978_1227# vbn.t58 a_36688_1807# VSS.t102 nfet_03v3 ad=0.56p pd=2.56u as=0.56p ps=2.56u w=2u l=1u
X888 a_41364_4127# vbn.t752 a_41654_3547# VSS.t98 nfet_03v3 ad=0.56p pd=2.56u as=0.56p ps=2.56u w=2u l=1u
X889 a_36688_4127# vbn.t127 a_36978_4707# VSS.t97 nfet_03v3 ad=0.56p pd=2.56u as=0.56p ps=2.56u w=2u l=1u
X890 a_36978_4707# vbn.t902 a_36688_4127# VSS.t86 nfet_03v3 ad=0.56p pd=2.56u as=0.9p ps=4.9u w=2u l=1u
X891 a_36978_1227# vbn.t810 w_36626_300# VSS.t103 nfet_03v3 ad=0.56p pd=2.56u as=0.56p ps=2.56u w=2u l=1u
X892 a_36666_9481# vbn.t995 a_36978_8187# VSS.t90 nfet_03v3 ad=0.56p pd=2.56u as=0.56p ps=2.56u w=2u l=1u
X893 a_36978_3547# vbn.t449 a_36688_2967# VSS.t99 nfet_03v3 ad=0.56p pd=2.56u as=0.56p ps=2.56u w=2u l=1u
X894 a_36688_1807# vbn.t402 a_36978_2387# VSS.t101 nfet_03v3 ad=0.56p pd=2.56u as=0.56p ps=2.56u w=2u l=1u
X895 a_36688_6447# vbn.t612 a_36978_7027# VSS.t93 nfet_03v3 ad=0.56p pd=2.56u as=0.56p ps=2.56u w=2u l=1u
X896 a_36978_4707# vbn.t541 a_36688_5287# VSS.t96 nfet_03v3 ad=0.56p pd=2.56u as=0.56p ps=2.56u w=2u l=1u
X897 a_36978_5867# vbn.t166 a_36688_6447# VSS.t94 nfet_03v3 ad=0.56p pd=2.56u as=0.56p ps=2.56u w=2u l=1u
X898 a_41364_7607# vbn.t318 a_41654_8187# VSS.t91 nfet_03v3 ad=0.56p pd=2.56u as=0.56p ps=2.56u w=2u l=1u
X899 a_36688_2967# vbn.t863 a_36978_3547# VSS.t99 nfet_03v3 ad=0.56p pd=2.56u as=0.56p ps=2.56u w=2u l=1u
X900 a_41654_1227# vbn.t716 VSS.t108 VSS.t103 nfet_03v3 ad=0.56p pd=2.56u as=0.56p ps=2.56u w=2u l=1u
X901 a_41364_4127# vbn.t750 a_41654_3547# VSS.t98 nfet_03v3 ad=0.56p pd=2.56u as=0.56p ps=2.56u w=2u l=1u
X902 w_36626_300# vbn.t348 a_36978_1227# VSS.t103 nfet_03v3 ad=0.56p pd=2.56u as=0.56p ps=2.56u w=2u l=1u
X903 a_36978_4707# vbn.t132 a_36688_4127# VSS.t97 nfet_03v3 ad=0.56p pd=2.56u as=0.9p ps=4.9u w=2u l=1u
X904 a_36688_1807# vbn.t400 a_36978_2387# VSS.t101 nfet_03v3 ad=0.56p pd=2.56u as=0.56p ps=2.56u w=2u l=1u
X905 a_36978_3547# vbn.t447 a_36688_2967# VSS.t99 nfet_03v3 ad=0.56p pd=2.56u as=0.56p ps=2.56u w=2u l=1u
X906 a_36978_2387# vbn.t423 a_36688_2967# VSS.t100 nfet_03v3 ad=0.56p pd=2.56u as=0.56p ps=2.56u w=2u l=1u
X907 a_36978_5867# vbn.t156 a_36688_5287# VSS.t95 nfet_03v3 ad=0.56p pd=2.56u as=0.56p ps=2.56u w=2u l=1u
X908 a_36666_9481# vbn.t225 a_36978_8187# VSS.t90 nfet_03v3 ad=0.56p pd=2.56u as=0.56p ps=2.56u w=2u l=1u
X909 a_1867_7085# a_1632_6633# vg.t13 VSS.t78 nfet_03v3 ad=0.9p pd=4.9u as=0.9p ps=4.9u w=2u l=0.28u
X910 a_36978_8187# vbn.t1000 a_36666_9481# VSS.t86 nfet_03v3 ad=0.56p pd=2.56u as=0.9p ps=4.9u w=2u l=1u
X911 a_36688_1807# vbn.t839 a_36978_2387# VSS.t101 nfet_03v3 ad=0.56p pd=2.56u as=0.56p ps=2.56u w=2u l=1u
X912 a_41364_7607# vbn.t801 a_41654_8187# VSS.t91 nfet_03v3 ad=0.56p pd=2.56u as=0.56p ps=2.56u w=2u l=1u
X913 a_36978_4707# vbn.t908 a_36688_5287# VSS.t96 nfet_03v3 ad=0.56p pd=2.56u as=0.56p ps=2.56u w=2u l=1u
X914 a_36978_7027# vbn.t617 a_36688_6447# VSS.t93 nfet_03v3 ad=0.56p pd=2.56u as=0.56p ps=2.56u w=2u l=1u
X915 a_36978_4707# vbn.t130 a_36688_4127# VSS.t97 nfet_03v3 ad=0.56p pd=2.56u as=0.56p ps=2.56u w=2u l=1u
X916 a_36688_6447# vbn.t947 a_36978_7027# VSS.t93 nfet_03v3 ad=0.56p pd=2.56u as=0.56p ps=2.56u w=2u l=1u
X917 a_41654_3547# vbn.t755 a_41364_4127# VSS.t98 nfet_03v3 ad=0.56p pd=2.56u as=0.9p ps=4.9u w=2u l=1u
X918 a_36688_7607# vbn.t632 a_36978_7027# VSS.t92 nfet_03v3 ad=0.56p pd=2.56u as=0.56p ps=2.56u w=2u l=1u
X919 w_36626_300# vbn.t813 a_36978_1227# VSS.t103 nfet_03v3 ad=0.56p pd=2.56u as=0.56p ps=2.56u w=2u l=1u
X920 a_36978_2387# vbn.t385 a_36688_1807# VSS.t101 nfet_03v3 ad=0.56p pd=2.56u as=0.56p ps=2.56u w=2u l=1u
X921 a_41364_7607# vbn.t799 a_41654_8187# VSS.t91 nfet_03v3 ad=0.56p pd=2.56u as=0.56p ps=2.56u w=2u l=1u
X922 a_41654_4707# vbn.t765 a_41364_5287# VSS.t96 nfet_03v3 ad=0.56p pd=2.56u as=0.56p ps=2.56u w=2u l=1u
X923 a_36978_4707# vbn.t499 a_36688_4127# VSS.t97 nfet_03v3 ad=0.56p pd=2.56u as=0.56p ps=2.56u w=2u l=1u
X924 a_36688_2967# vbn.t452 a_36978_3547# VSS.t99 nfet_03v3 ad=0.56p pd=2.56u as=0.56p ps=2.56u w=2u l=1u
X925 a_36978_2387# vbn.t405 a_36688_1807# VSS.t101 nfet_03v3 ad=0.56p pd=2.56u as=0.9p ps=4.9u w=2u l=1u
X926 a_36978_7027# vbn.t615 a_36688_6447# VSS.t93 nfet_03v3 ad=0.56p pd=2.56u as=0.56p ps=2.56u w=2u l=1u
X927 a_36978_5867# vbn.t591 a_36688_6447# VSS.t94 nfet_03v3 ad=0.56p pd=2.56u as=0.56p ps=2.56u w=2u l=1u
X928 a_36688_5287# vbn.t544 a_36978_4707# VSS.t96 nfet_03v3 ad=0.56p pd=2.56u as=0.56p ps=2.56u w=2u l=1u
X929 a_41654_1227# vbn.t721 a_41364_1807# VSS.t102 nfet_03v3 ad=0.9p pd=4.9u as=0.56p ps=2.56u w=2u l=1u
X930 a_36978_8187# vbn.t230 a_36666_9481# VSS.t90 nfet_03v3 ad=0.56p pd=2.56u as=0.9p ps=4.9u w=2u l=1u
X931 a_41364_7607# vbn.t313 a_41654_7027# VSS.t92 nfet_03v3 ad=0.56p pd=2.56u as=0.56p ps=2.56u w=2u l=1u
X932 w_36626_300# vbn.t43 a_36978_1227# VSS.t103 nfet_03v3 ad=0.56p pd=2.56u as=0.56p ps=2.56u w=2u l=1u
X933 a_36978_1227# vbn.t818 w_36626_300# VSS.t86 nfet_03v3 ad=0.56p pd=2.56u as=0.9p ps=4.9u w=2u l=1u
X934 a_36978_8187# vbn.t228 a_36666_9481# VSS.t90 nfet_03v3 ad=0.56p pd=2.56u as=0.56p ps=2.56u w=2u l=1u
X935 a_36688_2967# vbn.t851 a_36978_2387# VSS.t100 nfet_03v3 ad=0.56p pd=2.56u as=0.56p ps=2.56u w=2u l=1u
X936 a_41654_8187# vbn.t804 a_41364_7607# VSS.t91 nfet_03v3 ad=0.56p pd=2.56u as=0.9p ps=4.9u w=2u l=1u
X937 a_36688_5287# vbn.t911 a_36978_4707# VSS.t96 nfet_03v3 ad=0.56p pd=2.56u as=0.56p ps=2.56u w=2u l=1u
X938 a_36978_4707# vbn.t890 a_36688_4127# VSS.t97 nfet_03v3 ad=0.56p pd=2.56u as=0.56p ps=2.56u w=2u l=1u
X939 a_36688_6447# vbn.t620 a_36978_7027# VSS.t93 nfet_03v3 ad=0.56p pd=2.56u as=0.56p ps=2.56u w=2u l=1u
X940 VSS.t154 a_6006_4704# vg.t34 VSS.t50 nfet_03v3 ad=0.54p pd=3.3u as=0.336p ps=1.76u w=1.2u l=5.335u
X941 a_41654_4707# vbn.t760 a_41364_4127# VSS.t97 nfet_03v3 ad=0.56p pd=2.56u as=0.56p ps=2.56u w=2u l=1u
X942 a_41364_1807# vbn.t726 a_41654_1227# VSS.t102 nfet_03v3 ad=0.56p pd=2.56u as=0.56p ps=2.56u w=2u l=1u
X943 a_36978_8187# vbn.t695 a_36666_9481# VSS.t90 nfet_03v3 ad=0.56p pd=2.56u as=0.56p ps=2.56u w=2u l=1u
X944 a_36978_3547# vbn.t435 a_36688_2967# VSS.t99 nfet_03v3 ad=0.56p pd=2.56u as=0.56p ps=2.56u w=2u l=1u
X945 a_41654_5867# vbn.t770 a_41364_5287# VSS.t95 nfet_03v3 ad=0.9p pd=4.9u as=0.56p ps=2.56u w=2u l=1u
X946 a_36688_4127# vbn.t502 a_36978_4707# VSS.t97 nfet_03v3 ad=0.56p pd=2.56u as=0.56p ps=2.56u w=2u l=1u
X947 a_36978_3547# vbn.t455 a_36688_2967# VSS.t99 nfet_03v3 ad=0.56p pd=2.56u as=0.56p ps=2.56u w=2u l=1u
X948 a_36978_1227# vbn.t48 w_36626_300# VSS.t103 nfet_03v3 ad=0.56p pd=2.56u as=0.9p ps=4.9u w=2u l=1u
X949 VSS.t4 vbnf.t25 vg.t17 VSS.t3 nfet_03v3 ad=0.336p pd=1.76u as=0.336p ps=1.76u w=1.2u l=5.335u
X950 a_36688_2967# vbn.t81 a_36978_2387# VSS.t100 nfet_03v3 ad=0.56p pd=2.56u as=0.56p ps=2.56u w=2u l=1u
X951 a_36978_2387# vbn.t72 a_36688_1807# VSS.t101 nfet_03v3 ad=0.56p pd=2.56u as=0.56p ps=2.56u w=2u l=1u
X952 a_36688_5287# vbn.t141 a_36978_4707# VSS.t96 nfet_03v3 ad=0.56p pd=2.56u as=0.56p ps=2.56u w=2u l=1u
X953 a_36688_6447# vbn.t935 a_36978_5867# VSS.t94 nfet_03v3 ad=0.56p pd=2.56u as=0.56p ps=2.56u w=2u l=1u
X954 a_36978_4707# vbn.t916 a_36688_5287# VSS.t86 nfet_03v3 ad=0.56p pd=2.56u as=0.9p ps=4.9u w=2u l=1u
X955 vbn.t1 vbnf.t1 VSS.t61 ppolyf_u_1k r_width=1u r_length=0.97023m
X956 a_36978_1227# vbn.t46 w_36626_300# VSS.t103 nfet_03v3 ad=0.56p pd=2.56u as=0.56p ps=2.56u w=2u l=1u
X957 a_36978_8187# vbn.t988 a_36666_9481# VSS.t90 nfet_03v3 ad=0.56p pd=2.56u as=0.56p ps=2.56u w=2u l=1u
X958 a_41364_5287# vbn.t775 a_41654_5867# VSS.t95 nfet_03v3 ad=0.56p pd=2.56u as=0.56p ps=2.56u w=2u l=1u
X959 a_36978_7027# vbn.t603 a_36688_6447# VSS.t93 nfet_03v3 ad=0.56p pd=2.56u as=0.56p ps=2.56u w=2u l=1u
X960 a_36688_4127# vbn.t464 a_36978_3547# VSS.t98 nfet_03v3 ad=0.56p pd=2.56u as=0.56p ps=2.56u w=2u l=1u
X961 a_36688_2967# vbn.t440 a_36978_3547# VSS.t99 nfet_03v3 ad=0.56p pd=2.56u as=0.56p ps=2.56u w=2u l=1u
X962 a_36688_4127# vbn.t901 a_36978_4707# VSS.t87 nfet_03v3 ad=0.56p pd=2.56u as=0.56p ps=2.56u w=2u l=1u
X963 a_41654_8187# vbn.t10 vbn.t11 VSS.t90 nfet_03v3 ad=0.56p pd=2.56u as=0.56p ps=2.56u w=2u l=1u
X964 a_36978_7027# vbn.t623 a_36688_6447# VSS.t93 nfet_03v3 ad=0.56p pd=2.56u as=0.56p ps=2.56u w=2u l=1u
X965 ls.t1 a_n3607_6703# VSS.t83 VSS.t82 nfet_03v3 ad=1.2p pd=4.4u as=0.54p ps=3.3u w=1.2u l=0.28u
X966 a_36688_7607# vbn.t646 a_36978_7027# VSS.t92 nfet_03v3 ad=0.56p pd=2.56u as=0.56p ps=2.56u w=2u l=1u
X967 a_36978_1227# vbn.t331 w_36626_300# VSS.t103 nfet_03v3 ad=0.56p pd=2.56u as=0.56p ps=2.56u w=2u l=1u
X968 a_36666_9481# vbn.t698 a_36978_8187# VSS.t90 nfet_03v3 ad=0.56p pd=2.56u as=0.56p ps=2.56u w=2u l=1u
X969 a_36978_4707# vbn.t146 a_36688_5287# VSS.t96 nfet_03v3 ad=0.56p pd=2.56u as=0.9p ps=4.9u w=2u l=1u
X970 a_36688_6447# vbn.t165 a_36978_5867# VSS.t94 nfet_03v3 ad=0.56p pd=2.56u as=0.56p ps=2.56u w=2u l=1u
X971 a_36978_1227# vbn.t830 a_36688_1807# VSS.t88 nfet_03v3 ad=0.56p pd=2.56u as=0.56p ps=2.56u w=2u l=1u
X972 VSS.t135 a_6006_14# vg.t33 VSS.t3 nfet_03v3 ad=0.336p pd=1.76u as=0.336p ps=1.76u w=1.2u l=5.335u
X973 a_41364_1807# vbn.t239 a_41654_1227# VSS.t102 nfet_03v3 ad=0.56p pd=2.56u as=0.56p ps=2.56u w=2u l=1u
X974 a_41364_4127# vbn.t271 a_41654_3547# VSS.t98 nfet_03v3 ad=0.56p pd=2.56u as=0.56p ps=2.56u w=2u l=1u
X975 a_36688_6447# vbn.t608 a_36978_7027# VSS.t93 nfet_03v3 ad=0.56p pd=2.56u as=0.56p ps=2.56u w=2u l=1u
X976 a_36978_3547# vbn.t94 a_36688_2967# VSS.t99 nfet_03v3 ad=0.56p pd=2.56u as=0.56p ps=2.56u w=2u l=1u
X977 a_36978_2387# vbn.t84 a_36688_2967# VSS.t100 nfet_03v3 ad=0.56p pd=2.56u as=0.56p ps=2.56u w=2u l=1u
X978 a_36978_4707# vbn.t144 a_36688_5287# VSS.t96 nfet_03v3 ad=0.56p pd=2.56u as=0.56p ps=2.56u w=2u l=1u
X979 a_36688_7607# vbn.t660 a_36978_8187# VSS.t91 nfet_03v3 ad=0.56p pd=2.56u as=0.56p ps=2.56u w=2u l=1u
X980 a_36666_9481# vbn.t999 a_36978_8187# VSS.t87 nfet_03v3 ad=0.56p pd=2.56u as=0.56p ps=2.56u w=2u l=1u
X981 vbn.t4 a_36666_9481# VDD.t22 VDD.t21 pfet_03v3 ad=3.92p pd=14.56u as=3.92p ps=14.56u w=14u l=14u
X982 a_36978_1227# vbn.t806 w_36626_300# VSS.t103 nfet_03v3 ad=0.56p pd=2.56u as=0.56p ps=2.56u w=2u l=1u
X983 a_36978_4707# vbn.t527 a_36688_5287# VSS.t96 nfet_03v3 ad=0.56p pd=2.56u as=0.56p ps=2.56u w=2u l=1u
X984 a_41654_1227# vbn.t718 VSS.t106 VSS.t103 nfet_03v3 ad=0.56p pd=2.56u as=0.56p ps=2.56u w=2u l=1u
X985 a_41654_1227# vbn.t244 a_41364_1807# VSS.t102 nfet_03v3 ad=0.56p pd=2.56u as=0.9p ps=4.9u w=2u l=1u
X986 a_996_6587# a_1867_7085# vg.t3 VSS.t38 nfet_03v3 ad=0.9p pd=4.9u as=0.9p ps=4.9u w=2u l=0.28u
X987 a_41654_2387# vbn.t728 a_41364_1807# VSS.t101 nfet_03v3 ad=0.9p pd=4.9u as=0.56p ps=2.56u w=2u l=1u
X988 a_36978_5867# vbn.t928 a_36688_5287# VSS.t88 nfet_03v3 ad=0.56p pd=2.56u as=0.56p ps=2.56u w=2u l=1u
X989 a_41364_5287# vbn.t288 a_41654_5867# VSS.t95 nfet_03v3 ad=0.56p pd=2.56u as=0.56p ps=2.56u w=2u l=1u
X990 w_36626_300# vbn.t334 a_36978_1227# VSS.t103 nfet_03v3 ad=0.56p pd=2.56u as=0.56p ps=2.56u w=2u l=1u
X991 a_36688_2967# vbn.t89 a_36978_2387# VSS.t100 nfet_03v3 ad=0.56p pd=2.56u as=0.56p ps=2.56u w=2u l=1u
X992 a_36978_5867# vbn.t168 a_36688_6447# VSS.t94 nfet_03v3 ad=0.56p pd=2.56u as=0.56p ps=2.56u w=2u l=1u
X993 a_36978_7027# vbn.t178 a_36688_6447# VSS.t93 nfet_03v3 ad=0.56p pd=2.56u as=0.56p ps=2.56u w=2u l=1u
X994 a_41364_7607# vbn.t320 a_41654_8187# VSS.t91 nfet_03v3 ad=0.56p pd=2.56u as=0.56p ps=2.56u w=2u l=1u
X995 a_36978_7027# vbn.t962 a_36688_7607# VSS.t92 nfet_03v3 ad=0.56p pd=2.56u as=0.56p ps=2.56u w=2u l=1u
X996 a_n7872_8894# VSS.t177 a_n2245_6719# VDD_LS.t26 pfet_03v3 ad=0.2808p pd=2.76u as=0.2808p ps=2.76u w=0.22u l=2u
X997 a_41654_1227# vbn.t242 a_41364_1807# VSS.t102 nfet_03v3 ad=0.56p pd=2.56u as=0.56p ps=2.56u w=2u l=1u
X998 a_36978_4707# vbn.t904 a_36688_5287# VSS.t96 nfet_03v3 ad=0.56p pd=2.56u as=0.56p ps=2.56u w=2u l=1u
X999 a_36688_2967# vbn.t87 a_36978_2387# VSS.t100 nfet_03v3 ad=0.56p pd=2.56u as=0.56p ps=2.56u w=2u l=1u
X1000 w_36626_300# vbn.t817 a_36978_1227# VSS.t87 nfet_03v3 ad=0.56p pd=2.56u as=0.56p ps=2.56u w=2u l=1u
X1001 a_41654_4707# vbn.t767 a_41364_5287# VSS.t96 nfet_03v3 ad=0.56p pd=2.56u as=0.56p ps=2.56u w=2u l=1u
X1002 a_41364_1807# vbn.t733 a_41654_2387# VSS.t101 nfet_03v3 ad=0.56p pd=2.56u as=0.56p ps=2.56u w=2u l=1u
X1003 a_36688_4127# vbn.t478 a_36978_3547# VSS.t98 nfet_03v3 ad=0.56p pd=2.56u as=0.56p ps=2.56u w=2u l=1u
X1004 a_41654_5867# vbn.t293 a_41364_5287# VSS.t95 nfet_03v3 ad=0.56p pd=2.56u as=0.9p ps=4.9u w=2u l=1u
X1005 a_36688_5287# vbn.t530 a_36978_4707# VSS.t96 nfet_03v3 ad=0.56p pd=2.56u as=0.56p ps=2.56u w=2u l=1u
X1006 a_36688_2967# vbn.t414 a_36978_2387# VSS.t100 nfet_03v3 ad=0.56p pd=2.56u as=0.56p ps=2.56u w=2u l=1u
X1007 a_36688_6447# vbn.t173 a_36978_5867# VSS.t94 nfet_03v3 ad=0.56p pd=2.56u as=0.56p ps=2.56u w=2u l=1u
X1008 VSS.t123 VDD_LS.t30 VSS.t123 VSS.t122 nfet_03v3 ad=13.7592p pd=49.7u as=0 ps=0 w=49.14u l=10u
X1009 vbnf.t10 bit4.t0 a_6006_14# VSS.t175 nfet_03v3 ad=0.9p pd=4.9u as=0.9p ps=4.9u w=2u l=0.28u
X1010 a_36688_7607# vbn.t634 a_36978_7027# VSS.t92 nfet_03v3 ad=0.56p pd=2.56u as=0.56p ps=2.56u w=2u l=1u
X1011 a_36978_4707# vbn.t495 a_36688_4127# VSS.t97 nfet_03v3 ad=0.56p pd=2.56u as=0.56p ps=2.56u w=2u l=1u
X1012 a_36688_2967# vbn.t454 a_36978_3547# VSS.t99 nfet_03v3 ad=0.56p pd=2.56u as=0.56p ps=2.56u w=2u l=1u
X1013 a_41654_5867# vbn.t291 a_41364_5287# VSS.t95 nfet_03v3 ad=0.56p pd=2.56u as=0.56p ps=2.56u w=2u l=1u
X1014 a_36688_4127# vbn.t121 a_36978_4707# VSS.t97 nfet_03v3 ad=0.56p pd=2.56u as=0.56p ps=2.56u w=2u l=1u
X1015 a_36688_6447# vbn.t171 a_36978_5867# VSS.t94 nfet_03v3 ad=0.56p pd=2.56u as=0.56p ps=2.56u w=2u l=1u
X1016 a_36978_7027# vbn.t190 a_36688_7607# VSS.t92 nfet_03v3 ad=0.56p pd=2.56u as=0.56p ps=2.56u w=2u l=1u
X1017 a_36688_5287# vbn.t915 a_36978_4707# VSS.t87 nfet_03v3 ad=0.56p pd=2.56u as=0.56p ps=2.56u w=2u l=1u
X1018 a_36688_7607# vbn.t674 a_36978_8187# VSS.t91 nfet_03v3 ad=0.56p pd=2.56u as=0.56p ps=2.56u w=2u l=1u
X1019 a_36688_6447# vbn.t582 a_36978_5867# VSS.t94 nfet_03v3 ad=0.56p pd=2.56u as=0.56p ps=2.56u w=2u l=1u
X1020 a_36688_2967# vbn.t847 a_36978_2387# VSS.t100 nfet_03v3 ad=0.9p pd=4.9u as=0.56p ps=2.56u w=2u l=1u
X1021 a_36978_8187# vbn.t691 a_36666_9481# VSS.t90 nfet_03v3 ad=0.56p pd=2.56u as=0.56p ps=2.56u w=2u l=1u
X1022 a_36978_2387# vbn.t844 a_36688_1807# VSS.t88 nfet_03v3 ad=0.56p pd=2.56u as=0.56p ps=2.56u w=2u l=1u
X1023 a_36688_6447# vbn.t622 a_36978_7027# VSS.t93 nfet_03v3 ad=0.56p pd=2.56u as=0.56p ps=2.56u w=2u l=1u
X1024 a_36978_3547# vbn.t459 a_36688_2967# VSS.t99 nfet_03v3 ad=0.56p pd=2.56u as=0.56p ps=2.56u w=2u l=1u
X1025 a_36978_2387# vbn.t417 a_36688_2967# VSS.t100 nfet_03v3 ad=0.56p pd=2.56u as=0.56p ps=2.56u w=2u l=1u
X1026 a_36688_7607# vbn.t195 a_36978_7027# VSS.t92 nfet_03v3 ad=0.56p pd=2.56u as=0.56p ps=2.56u w=2u l=1u
X1027 a_41364_1807# vbn.t246 a_41654_2387# VSS.t101 nfet_03v3 ad=0.56p pd=2.56u as=0.56p ps=2.56u w=2u l=1u
X1028 a_36666_9481# vbn.t219 a_36978_8187# VSS.t90 nfet_03v3 ad=0.56p pd=2.56u as=0.56p ps=2.56u w=2u l=1u
X1029 VSS.t20 vbnf.t17 VSS.t20 VSS.t19 nfet_03v3 ad=13.7592p pd=49.7u as=0 ps=0 w=49.14u l=10u
X1030 a_36978_3547# vbn.t878 a_36688_4127# VSS.t98 nfet_03v3 ad=0.56p pd=2.56u as=0.56p ps=2.56u w=2u l=1u
X1031 a_36688_4127# vbn.t504 a_36978_4707# VSS.t97 nfet_03v3 ad=0.56p pd=2.56u as=0.56p ps=2.56u w=2u l=1u
X1032 VSS.t10 vbnf.t20 VSS.t10 VSS.t9 nfet_03v3 ad=22.113p pd=99.18u as=0 ps=0 w=49.14u l=10u
X1033 a_36688_6447# vbn.t931 a_36978_5867# VSS.t94 nfet_03v3 ad=0.9p pd=4.9u as=0.56p ps=2.56u w=2u l=1u
X1034 VDD_LS.t6 a_n7601_6703# a_n8217_6703# VDD_LS.t5 pfet_03v3 ad=0.675p pd=3.9u as=1.5p ps=5u w=1.5u l=0.28u
X1035 VSS.t166 vg.t43 VSS.t166 VSS.t165 nfet_03v3 ad=8.5988p pd=31.27u as=0 ps=0 w=30.71u l=4u
X1036 a_36978_3547# vbn.t868 a_36688_2967# VSS.t99 nfet_03v3 ad=0.56p pd=2.56u as=0.56p ps=2.56u w=2u l=1u
X1037 a_36978_7027# vbn.t627 a_36688_6447# VSS.t93 nfet_03v3 ad=0.56p pd=2.56u as=0.56p ps=2.56u w=2u l=1u
X1038 a_41654_2387# vbn.t251 a_41364_1807# VSS.t101 nfet_03v3 ad=0.56p pd=2.56u as=0.9p ps=4.9u w=2u l=1u
X1039 a_36978_5867# vbn.t585 a_36688_6447# VSS.t94 nfet_03v3 ad=0.56p pd=2.56u as=0.56p ps=2.56u w=2u l=1u
X1040 a_36978_1227# vbn.t327 w_36626_300# VSS.t103 nfet_03v3 ad=0.56p pd=2.56u as=0.56p ps=2.56u w=2u l=1u
X1041 a_36688_1807# vbn.t350 a_36978_1227# VSS.t102 nfet_03v3 ad=0.9p pd=4.9u as=0.56p ps=2.56u w=2u l=1u
X1042 a_36688_4127# vbn.t466 a_36978_3547# VSS.t98 nfet_03v3 ad=0.56p pd=2.56u as=0.56p ps=2.56u w=2u l=1u
X1043 a_36978_8187# vbn.t976 a_36688_7607# VSS.t91 nfet_03v3 ad=0.56p pd=2.56u as=0.56p ps=2.56u w=2u l=1u
X1044 a_36978_2387# vbn.t856 a_36688_2967# VSS.t100 nfet_03v3 ad=0.56p pd=2.56u as=0.56p ps=2.56u w=2u l=1u
X1045 a_36978_4707# vbn.t509 a_36688_4127# VSS.t97 nfet_03v3 ad=0.56p pd=2.56u as=0.56p ps=2.56u w=2u l=1u
X1046 w_36626_300# vbn.t37 a_36978_1227# VSS.t103 nfet_03v3 ad=0.56p pd=2.56u as=0.56p ps=2.56u w=2u l=1u
X1047 a_41654_2387# vbn.t249 a_41364_1807# VSS.t101 nfet_03v3 ad=0.56p pd=2.56u as=0.56p ps=2.56u w=2u l=1u
X1048 a_36666_9481# vbn.t700 a_36978_8187# VSS.t90 nfet_03v3 ad=0.56p pd=2.56u as=0.56p ps=2.56u w=2u l=1u
X1049 a_36978_3547# vbn.t106 a_36688_4127# VSS.t98 nfet_03v3 ad=0.56p pd=2.56u as=0.56p ps=2.56u w=2u l=1u
X1050 a_36978_7027# vbn.t952 a_36688_6447# VSS.t93 nfet_03v3 ad=0.56p pd=2.56u as=0.56p ps=2.56u w=2u l=1u
X1051 a_36978_5867# vbn.t940 a_36688_6447# VSS.t94 nfet_03v3 ad=0.56p pd=2.56u as=0.56p ps=2.56u w=2u l=1u
X1052 a_36688_2967# vbn.t871 a_36978_3547# VSS.t89 nfet_03v3 ad=0.56p pd=2.56u as=0.56p ps=2.56u w=2u l=1u
X1053 a_36688_7607# vbn.t662 a_36978_8187# VSS.t91 nfet_03v3 ad=0.56p pd=2.56u as=0.56p ps=2.56u w=2u l=1u
X1054 a_36978_7027# vbn.t653 a_36688_7607# VSS.t92 nfet_03v3 ad=0.56p pd=2.56u as=0.56p ps=2.56u w=2u l=1u
X1055 a_36688_5287# vbn.t546 a_36978_5867# VSS.t95 nfet_03v3 ad=0.9p pd=4.9u as=0.56p ps=2.56u w=2u l=1u
X1056 a_36978_4707# vbn.t523 a_36688_5287# VSS.t96 nfet_03v3 ad=0.56p pd=2.56u as=0.56p ps=2.56u w=2u l=1u
X1057 a_36688_4127# vbn.t514 a_36978_4707# VSS.t97 nfet_03v3 ad=0.56p pd=2.56u as=0.56p ps=2.56u w=2u l=1u
X1058 a_41654_3547# vbn.t259 a_41364_2967# VSS.t99 nfet_03v3 ad=0.9p pd=4.9u as=0.56p ps=2.56u w=2u l=1u
X1059 a_36978_8187# vbn.t705 a_36666_9481# VSS.t90 nfet_03v3 ad=0.56p pd=2.56u as=0.56p ps=2.56u w=2u l=1u
X1060 a_36688_4127# vbn.t111 a_36978_3547# VSS.t98 nfet_03v3 ad=0.56p pd=2.56u as=0.56p ps=2.56u w=2u l=1u
X1061 a_36978_1227# vbn.t353 a_36688_1807# VSS.t102 nfet_03v3 ad=0.56p pd=2.56u as=0.56p ps=2.56u w=2u l=1u
X1062 a_36688_5287# vbn.t135 a_36978_4707# VSS.t96 nfet_03v3 ad=0.56p pd=2.56u as=0.56p ps=2.56u w=2u l=1u
X1063 a_36978_8187# vbn.t204 a_36688_7607# VSS.t91 nfet_03v3 ad=0.56p pd=2.56u as=0.56p ps=2.56u w=2u l=1u
X1064 a_36688_4127# vbn.t512 a_36978_4707# VSS.t97 nfet_03v3 ad=0.56p pd=2.56u as=0.56p ps=2.56u w=2u l=1u
X1065 a_36688_1807# vbn.t49 a_36978_1227# VSS.t102 nfet_03v3 ad=0.9p pd=4.9u as=0.56p ps=2.56u w=2u l=1u
X1066 a_41654_2387# vbn.t254 a_41364_2967# VSS.t100 nfet_03v3 ad=0.56p pd=2.56u as=0.56p ps=2.56u w=2u l=1u
X1067 w_36626_300# vbn.t336 a_36978_1227# VSS.t103 nfet_03v3 ad=0.56p pd=2.56u as=0.56p ps=2.56u w=2u l=1u
X1068 a_36978_7027# vbn.t964 a_36688_7607# VSS.t92 nfet_03v3 ad=0.56p pd=2.56u as=0.56p ps=2.56u w=2u l=1u
X1069 a_36688_6447# vbn.t955 a_36978_7027# VSS.t89 nfet_03v3 ad=0.56p pd=2.56u as=0.56p ps=2.56u w=2u l=1u
X1070 a_36688_4127# vbn.t895 a_36978_4707# VSS.t97 nfet_03v3 ad=0.56p pd=2.56u as=0.56p ps=2.56u w=2u l=1u
X1071 a_36666_9481# vbn.t710 a_36978_8187# VSS.t90 nfet_03v3 ad=0.56p pd=2.56u as=0.56p ps=2.56u w=2u l=1u
X1072 a_41654_7027# vbn.t301 a_41364_6447# VSS.t93 nfet_03v3 ad=0.9p pd=4.9u as=0.56p ps=2.56u w=2u l=1u
X1073 a_36978_4707# vbn.t497 a_36688_4127# VSS.t97 nfet_03v3 ad=0.56p pd=2.56u as=0.56p ps=2.56u w=2u l=1u
X1074 vg.t36 a_6006_4704# VSS.t153 VSS.t1 nfet_03v3 ad=0.336p pd=1.76u as=0.336p ps=1.76u w=1.2u l=5.335u
X1075 vg.t18 a_6006_14# VSS.t150 VSS.t5 nfet_03v3 ad=0.336p pd=1.76u as=0.336p ps=1.76u w=1.2u l=5.335u
X1076 a_41654_7027# vbn.t793 a_41364_7607# VSS.t92 nfet_03v3 ad=0.56p pd=2.56u as=0.56p ps=2.56u w=2u l=1u
X1077 a_36688_7607# vbn.t209 a_36978_8187# VSS.t91 nfet_03v3 ad=0.56p pd=2.56u as=0.56p ps=2.56u w=2u l=1u
X1078 a_36688_7607# vbn.t656 a_36978_7027# VSS.t92 nfet_03v3 ad=0.56p pd=2.56u as=0.56p ps=2.56u w=2u l=1u
X1079 a_36978_5867# vbn.t549 a_36688_5287# VSS.t95 nfet_03v3 ad=0.56p pd=2.56u as=0.56p ps=2.56u w=2u l=1u
X1080 a_36978_4707# vbn.t517 a_36688_4127# VSS.t97 nfet_03v3 ad=0.56p pd=2.56u as=0.9p ps=4.9u w=2u l=1u
X1081 a_41364_2967# vbn.t262 a_41654_3547# VSS.t99 nfet_03v3 ad=0.56p pd=2.56u as=0.56p ps=2.56u w=2u l=1u
X1082 a_36978_1227# vbn.t341 w_36626_300# VSS.t103 nfet_03v3 ad=0.56p pd=2.56u as=0.56p ps=2.56u w=2u l=1u
X1083 a_36666_9481# vbn.t708 a_36978_8187# VSS.t90 nfet_03v3 ad=0.56p pd=2.56u as=0.56p ps=2.56u w=2u l=1u
X1084 a_36978_1227# vbn.t54 a_36688_1807# VSS.t102 nfet_03v3 ad=0.56p pd=2.56u as=0.56p ps=2.56u w=2u l=1u
X1085 a_41654_5867# vbn.t296 a_41364_6447# VSS.t94 nfet_03v3 ad=0.56p pd=2.56u as=0.56p ps=2.56u w=2u l=1u
X1086 a_36688_5287# vbn.t532 a_36978_4707# VSS.t96 nfet_03v3 ad=0.56p pd=2.56u as=0.56p ps=2.56u w=2u l=1u
X1087 a_36688_2967# vbn.t416 a_36978_2387# VSS.t100 nfet_03v3 ad=0.56p pd=2.56u as=0.56p ps=2.56u w=2u l=1u
X1088 a_36688_5287# vbn.t147 a_36978_5867# VSS.t95 nfet_03v3 ad=0.9p pd=4.9u as=0.56p ps=2.56u w=2u l=1u
X1089 a_36666_9481# vbn.t993 a_36978_8187# VSS.t90 nfet_03v3 ad=0.56p pd=2.56u as=0.56p ps=2.56u w=2u l=1u
X1090 a_41364_2967# vbn.t745 a_41654_3547# VSS.t99 nfet_03v3 ad=0.56p pd=2.56u as=0.56p ps=2.56u w=2u l=1u
X1091 a_452_6633# a0.t3 VDD.t29 VDD.t28 pfet_03v3 ad=2.25p pd=10.9u as=2.25p ps=10.9u w=5u l=0.28u
X1092 a_36688_7607# vbn.t967 a_36978_7027# VSS.t92 nfet_03v3 ad=0.56p pd=2.56u as=0.56p ps=2.56u w=2u l=1u
X1093 a_36978_8187# vbn.t693 a_36666_9481# VSS.t90 nfet_03v3 ad=0.56p pd=2.56u as=0.56p ps=2.56u w=2u l=1u
X1094 w_36626_300# vbn.t346 a_36978_1227# VSS.t103 nfet_03v3 ad=0.56p pd=2.56u as=0.56p ps=2.56u w=2u l=1u
X1095 a_36688_1807# vbn.t378 a_36978_2387# VSS.t101 nfet_03v3 ad=0.9p pd=4.9u as=0.56p ps=2.56u w=2u l=1u
X1096 a_36978_8187# vbn.t713 a_36666_9481# VSS.t90 nfet_03v3 ad=0.56p pd=2.56u as=0.9p ps=4.9u w=2u l=1u
X1097 a_36978_3547# vbn.t485 a_36688_4127# VSS.t98 nfet_03v3 ad=0.56p pd=2.56u as=0.56p ps=2.56u w=2u l=1u
X1098 a_36978_2387# vbn.t421 a_36688_2967# VSS.t100 nfet_03v3 ad=0.56p pd=2.56u as=0.56p ps=2.56u w=2u l=1u
X1099 a_41364_6447# vbn.t304 a_41654_7027# VSS.t93 nfet_03v3 ad=0.56p pd=2.56u as=0.56p ps=2.56u w=2u l=1u
X1100 a_36688_6447# vbn.t584 a_36978_5867# VSS.t94 nfet_03v3 ad=0.56p pd=2.56u as=0.56p ps=2.56u w=2u l=1u
X1101 a_36978_4707# vbn.t537 a_36688_5287# VSS.t96 nfet_03v3 ad=0.56p pd=2.56u as=0.56p ps=2.56u w=2u l=1u
X1102 a_36978_5867# vbn.t152 a_36688_5287# VSS.t95 nfet_03v3 ad=0.56p pd=2.56u as=0.56p ps=2.56u w=2u l=1u
X1103 VSS.t129 VDD_LS.t27 VSS.t129 VSS.t128 nfet_03v3 ad=13.7592p pd=49.7u as=0 ps=0 w=49.14u l=10u
X1104 a_36688_2967# vbn.t849 a_36978_2387# VSS.t100 nfet_03v3 ad=0.56p pd=2.56u as=0.56p ps=2.56u w=2u l=1u
X1105 a_41364_2967# vbn.t743 a_41654_3547# VSS.t99 nfet_03v3 ad=0.56p pd=2.56u as=0.56p ps=2.56u w=2u l=1u
X1106 w_36626_300# vbn.t344 a_36978_1227# VSS.t103 nfet_03v3 ad=0.56p pd=2.56u as=0.56p ps=2.56u w=2u l=1u
X1107 a_36978_1227# vbn.t367 a_36688_1807# VSS.t102 nfet_03v3 ad=0.56p pd=2.56u as=0.56p ps=2.56u w=2u l=1u
X1108 a_36978_4707# vbn.t128 a_36688_4127# VSS.t97 nfet_03v3 ad=0.56p pd=2.56u as=0.56p ps=2.56u w=2u l=1u
X1109 a_36978_2387# vbn.t419 a_36688_2967# VSS.t100 nfet_03v3 ad=0.56p pd=2.56u as=0.56p ps=2.56u w=2u l=1u
X1110 a_36688_7607# vbn.t197 a_36978_7027# VSS.t92 nfet_03v3 ad=0.56p pd=2.56u as=0.56p ps=2.56u w=2u l=1u
R0 vctrl vctrl.t0 90.2352
R1 vg.n56 vg.t48 28.0234
R2 vg.n60 vg.t47 28.0234
R3 vg.n68 vg.t46 28.0234
R4 vg.n75 vg.t45 28.0234
R5 vg.n78 vg.t44 28.0234
R6 vg.n85 vg.t43 28.0234
R7 vg.n56 vg.n55 21.9053
R8 vg.n60 vg.n48 21.9053
R9 vg.n61 vg.n60 21.9053
R10 vg.n68 vg.n46 21.9053
R11 vg.n68 vg.n67 21.9053
R12 vg.n76 vg.n75 21.9053
R13 vg.n79 vg.n78 21.9053
R14 vg.n85 vg.n84 21.9053
R15 vg.n19 vg.n18 14.5769
R16 vg.n34 vg.n32 10.4429
R17 vg.n28 vg.n26 10.4429
R18 vg.n22 vg.n20 10.4429
R19 vg.n14 vg.n12 10.4429
R20 vg.n8 vg.n6 10.4429
R21 vg.n2 vg.n0 10.4429
R22 vg vg.n88 8.16682
R23 vg.n69 vg.n68 8.0005
R24 vg.n60 vg.n51 8.0005
R25 vg.n36 vg.n35 7.6505
R26 vg.n34 vg.n33 7.6505
R27 vg.n30 vg.n29 7.6505
R28 vg.n28 vg.n27 7.6505
R29 vg.n24 vg.n23 7.6505
R30 vg.n22 vg.n21 7.6505
R31 vg.n16 vg.n15 7.6505
R32 vg.n14 vg.n13 7.6505
R33 vg.n10 vg.n9 7.6505
R34 vg.n8 vg.n7 7.6505
R35 vg.n4 vg.n3 7.6505
R36 vg.n2 vg.n1 7.6505
R37 vg.n37 vg.n36 6.02932
R38 vg.n31 vg.n30 6.02932
R39 vg.n25 vg.n24 6.02932
R40 vg.n17 vg.n16 6.02932
R41 vg.n11 vg.n10 6.02932
R42 vg.n5 vg.n4 6.02932
R43 vg.n86 vg.n85 5.8476
R44 vg.n57 vg.n56 5.8468
R45 vg.n78 vg.n40 5.8468
R46 vg.n75 vg.n74 5.8468
R47 vg.n88 vg.n87 4.6679
R48 vg.n36 vg.n34 2.79287
R49 vg.n30 vg.n28 2.79287
R50 vg.n24 vg.n22 2.79287
R51 vg.n16 vg.n14 2.79287
R52 vg.n10 vg.n8 2.79287
R53 vg.n4 vg.n2 2.79287
R54 vg.n43 vg.t13 2.71814
R55 vg.n66 vg.t3 2.71814
R56 vg.n50 vg.t14 2.71814
R57 vg.n59 vg.t2 2.71814
R58 vg.n53 vg.t38 2.71814
R59 vg.n55 vg.n54 2.4215
R60 vg.n87 vg.n86 2.30143
R61 vg.n54 vg.n52 2.2505
R62 vg.n58 vg.n49 2.2505
R63 vg.n63 vg.n62 2.2505
R64 vg.n65 vg.n64 2.2505
R65 vg.n47 vg.n45 2.2505
R66 vg.n71 vg.n70 2.2505
R67 vg.n73 vg.n72 2.2505
R68 vg.n44 vg.n42 2.2505
R69 vg.n77 vg.n41 2.2505
R70 vg.n81 vg.n80 2.2505
R71 vg.n83 vg.n82 2.2505
R72 vg.n39 vg.n38 2.2505
R73 vg.n88 vg.n37 1.83958
R74 vg.n35 vg.t33 1.4705
R75 vg.n35 vg.t37 1.4705
R76 vg.n33 vg.t31 1.4705
R77 vg.n33 vg.t39 1.4705
R78 vg.n32 vg.t32 1.4705
R79 vg.n32 vg.t7 1.4705
R80 vg.n29 vg.t17 1.4705
R81 vg.n29 vg.t29 1.4705
R82 vg.n27 vg.t1 1.4705
R83 vg.n27 vg.t30 1.4705
R84 vg.n26 vg.t6 1.4705
R85 vg.n26 vg.t27 1.4705
R86 vg.n23 vg.t28 1.4705
R87 vg.n23 vg.t10 1.4705
R88 vg.n21 vg.t35 1.4705
R89 vg.n21 vg.t4 1.4705
R90 vg.n20 vg.t25 1.4705
R91 vg.n20 vg.t42 1.4705
R92 vg.n18 vg.t12 1.4705
R93 vg.n18 vg.t40 1.4705
R94 vg.n15 vg.t16 1.4705
R95 vg.n15 vg.t26 1.4705
R96 vg.n13 vg.t9 1.4705
R97 vg.n13 vg.t36 1.4705
R98 vg.n12 vg.t11 1.4705
R99 vg.n12 vg.t23 1.4705
R100 vg.n9 vg.t24 1.4705
R101 vg.n9 vg.t8 1.4705
R102 vg.n7 vg.t21 1.4705
R103 vg.n7 vg.t0 1.4705
R104 vg.n6 vg.t22 1.4705
R105 vg.n6 vg.t41 1.4705
R106 vg.n3 vg.t5 1.4705
R107 vg.n3 vg.t19 1.4705
R108 vg.n1 vg.t15 1.4705
R109 vg.n1 vg.t20 1.4705
R110 vg.n0 vg.t34 1.4705
R111 vg.n0 vg.t18 1.4705
R112 vg.n19 vg.n17 1.30076
R113 vg.n31 vg.n25 1.13971
R114 vg.n11 vg.n5 1.13971
R115 vg.n5 vg 1.08997
R116 vg.n37 vg.n31 0.658921
R117 vg.n25 vg.n19 0.658921
R118 vg.n17 vg.n11 0.658921
R119 vg.n87 vg.n38 0.1205
R120 vg.n82 vg.n38 0.1205
R121 vg.n82 vg.n81 0.1205
R122 vg.n81 vg.n41 0.1205
R123 vg.n44 vg.n41 0.1205
R124 vg.n72 vg.n44 0.1205
R125 vg.n72 vg.n71 0.1205
R126 vg.n71 vg.n45 0.1205
R127 vg.n64 vg.n45 0.1205
R128 vg.n64 vg.n63 0.1205
R129 vg.n63 vg.n49 0.1205
R130 vg.n54 vg.n49 0.1205
R131 vg.n66 vg.n65 0.1094
R132 vg.n84 vg.n83 0.0995
R133 vg.n58 vg.n57 0.0986122
R134 vg.n73 vg.n43 0.0956
R135 vg.n74 vg.n73 0.0854122
R136 vg.n83 vg.n40 0.0842122
R137 vg.n69 vg.n47 0.0707
R138 vg.n86 vg.n39 0.0704143
R139 vg.n59 vg.n58 0.068
R140 vg.n79 vg.n77 0.0659
R141 vg.n77 vg.n76 0.0647
R142 vg.n76 vg.n42 0.0563
R143 vg.n80 vg.n79 0.0551
R144 vg.n70 vg.n69 0.0503
R145 vg.n53 vg.n52 0.0416
R146 vg.n80 vg.n40 0.0376149
R147 vg.n62 vg.n51 0.0371
R148 vg.n51 vg.n50 0.0368
R149 vg.n74 vg.n42 0.0364149
R150 vg.n50 vg.n48 0.0362
R151 vg.n62 vg.n61 0.0359
R152 vg.n55 vg.n53 0.0284
R153 vg.n57 vg.n52 0.0232149
R154 vg.n70 vg.n46 0.0227
R155 vg.n84 vg.n39 0.0215
R156 vg.n61 vg.n59 0.0176
R157 vg.n65 vg.n48 0.0119
R158 vg.n67 vg.n66 0.0098
R159 vg.n46 vg.n43 0.0032
R160 vg.n67 vg.n47 0.0023
R161 bit4 bit4.t0 78.8918
R162 bit3 bit3.t0 78.8918
R163 bit2 bit2.t0 78.8918
R164 bit1 bit1.t0 78.8918
R165 bit0 bit0.t0 78.8918
R166 bitb4.n0 bitb4.t1 110.341
R167 bitb4.n0 bitb4.t0 57.8015
R168 bitb4 bitb4.n0 16.0738
R169 bitb3.n0 bitb3.t1 110.341
R170 bitb3.n0 bitb3.t0 57.8015
R171 bitb3 bitb3.n0 16.0738
R172 bitb2.n0 bitb2.t1 110.341
R173 bitb2.n0 bitb2.t0 57.8015
R174 bitb2 bitb2.n0 16.0738
R175 bitb1.n0 bitb1.t1 110.341
R176 bitb1.n0 bitb1.t0 57.8015
R177 bitb1 bitb1.n0 16.0738
R178 bitb0.n0 bitb0.t1 110.341
R179 bitb0.n0 bitb0.t0 57.8015
R180 bitb0 bitb0.n0 16.0738
R181 a0.n1 a0.t3 101.793
R182 a0.n1 a0.t2 62.6858
R183 a0.n2 a0.n0 5.37563
R184 a0.n2 a0.n1 4.5005
R185 a0.n0 a0.t1 2.88512
R186 a0.n0 a0.t0 1.72163
R187 a0 a0.n2 0.692079
R188 ck ck.n0 17.56
R189 ck.n0 ck.t1 6.68892
R190 ck.n0 ck.t0 3.48853
R191 vbnf.n20 vbnf.t23 38.1796
R192 vbnf.n23 vbnf.t26 36.9444
R193 vbnf.n19 vbnf.t22 33.1076
R194 vbnf.n21 vbnf.t25 32.969
R195 vbnf.n21 vbnf.t24 32.5581
R196 vbnf.n19 vbnf.t21 31.0482
R197 vbnf.n0 vbnf.t11 23.4616
R198 vbnf.n8 vbnf.t20 22.2744
R199 vbnf.n7 vbnf.t19 22.2744
R200 vbnf.n6 vbnf.t18 22.2744
R201 vbnf.n5 vbnf.t17 22.2744
R202 vbnf.n4 vbnf.t16 22.2744
R203 vbnf.n3 vbnf.t15 22.2744
R204 vbnf.n2 vbnf.t14 22.2744
R205 vbnf.n1 vbnf.t13 22.2744
R206 vbnf.n0 vbnf.t12 22.2744
R207 vbnf vbnf.n25 10.1681
R208 vbnf.n24 vbnf.n23 8.26866
R209 vbnf.n9 vbnf.t1 7.56062
R210 vbnf vbnf.n9 6.54445
R211 vbnf.n20 vbnf.n19 6.13708
R212 vbnf.n12 vbnf.n10 6.08497
R213 vbnf.n12 vbnf.n11 5.20866
R214 vbnf.n14 vbnf.n13 5.20866
R215 vbnf.n16 vbnf.n15 5.20866
R216 vbnf.n18 vbnf.n17 5.20866
R217 vbnf.n22 vbnf.n21 4.5005
R218 vbnf.n10 vbnf.t9 3.71525
R219 vbnf.n11 vbnf.t8 3.71525
R220 vbnf.n13 vbnf.t7 3.71525
R221 vbnf.n15 vbnf.t0 3.71525
R222 vbnf.n17 vbnf.t10 3.71525
R223 vbnf.n25 vbnf 3.62182
R224 vbnf.n22 vbnf.n20 2.28129
R225 vbnf.n23 vbnf.n22 1.63708
R226 vbnf.n1 vbnf.n0 1.18772
R227 vbnf.n2 vbnf.n1 1.18772
R228 vbnf.n3 vbnf.n2 1.18772
R229 vbnf.n4 vbnf.n3 1.18772
R230 vbnf.n5 vbnf.n4 1.18772
R231 vbnf.n6 vbnf.n5 1.18772
R232 vbnf.n7 vbnf.n6 1.18772
R233 vbnf.n8 vbnf.n7 1.18772
R234 vbnf.n10 vbnf.t4 0.8915
R235 vbnf.n11 vbnf.t3 0.8915
R236 vbnf.n13 vbnf.t6 0.8915
R237 vbnf.n15 vbnf.t5 0.8915
R238 vbnf.n17 vbnf.t2 0.8915
R239 vbnf.n18 vbnf.n16 0.876816
R240 vbnf.n16 vbnf.n14 0.876816
R241 vbnf.n14 vbnf.n12 0.876816
R242 vbnf.n25 vbnf.n24 0.715763
R243 vbnf.n9 vbnf.n8 0.591977
R244 vbnf.n24 vbnf.n18 0.378263
R245 ls.n2 ls.t5 49.486
R246 ls.n1 ls.t6 44.9774
R247 ls.n5 ls.t3 31.7904
R248 ls.n1 ls.t4 31.7818
R249 ls.n3 ls.t0 16.1395
R250 ls.n4 ls.n3 6.95774
R251 ls.n0 ls.t1 6.34866
R252 ls ls.n0 5.42655
R253 ls.n2 ls.n1 4.89839
R254 ls.n3 ls 4.76339
R255 ls.n6 ls.n5 4.5005
R256 ls.n0 ls.t2 2.98002
R257 ls.n4 ls.n2 0.459974
R258 ls.n6 ls.n4 0.0455
R259 ls ls.n6 0.0241842
R260 vbn.n159 vbn.t34 49.3877
R261 vbn.n143 vbn.n142 41.4329
R262 vbn.n136 vbn.n135 41.4329
R263 vbn.n108 vbn.n107 41.4329
R264 vbn.n101 vbn.n100 41.4329
R265 vbn.n86 vbn.t1 21.6952
R266 vbn.t49 vbn.t35 21.1705
R267 vbn.t63 vbn.t49 21.1705
R268 vbn.t77 vbn.t63 21.1705
R269 vbn.t91 vbn.t77 21.1705
R270 vbn.t105 vbn.t91 21.1705
R271 vbn.t119 vbn.t105 21.1705
R272 vbn.t133 vbn.t119 21.1705
R273 vbn.t147 vbn.t133 21.1705
R274 vbn.t161 vbn.t147 21.1705
R275 vbn.t175 vbn.t161 21.1705
R276 vbn.t189 vbn.t175 21.1705
R277 vbn.t203 vbn.t189 21.1705
R278 vbn.t217 vbn.t203 21.1705
R279 vbn.t50 vbn.t36 21.1705
R280 vbn.t64 vbn.t50 21.1705
R281 vbn.t78 vbn.t64 21.1705
R282 vbn.t92 vbn.t78 21.1705
R283 vbn.t106 vbn.t92 21.1705
R284 vbn.t120 vbn.t106 21.1705
R285 vbn.t134 vbn.t120 21.1705
R286 vbn.t148 vbn.t134 21.1705
R287 vbn.t162 vbn.t148 21.1705
R288 vbn.t176 vbn.t162 21.1705
R289 vbn.t190 vbn.t176 21.1705
R290 vbn.t204 vbn.t190 21.1705
R291 vbn.t218 vbn.t204 21.1705
R292 vbn.t51 vbn.t37 21.1705
R293 vbn.t65 vbn.t51 21.1705
R294 vbn.t79 vbn.t65 21.1705
R295 vbn.t93 vbn.t79 21.1705
R296 vbn.t107 vbn.t93 21.1705
R297 vbn.t121 vbn.t107 21.1705
R298 vbn.t135 vbn.t121 21.1705
R299 vbn.t149 vbn.t135 21.1705
R300 vbn.t163 vbn.t149 21.1705
R301 vbn.t177 vbn.t163 21.1705
R302 vbn.t191 vbn.t177 21.1705
R303 vbn.t205 vbn.t191 21.1705
R304 vbn.t219 vbn.t205 21.1705
R305 vbn.t52 vbn.t38 21.1705
R306 vbn.t66 vbn.t52 21.1705
R307 vbn.t80 vbn.t66 21.1705
R308 vbn.t94 vbn.t80 21.1705
R309 vbn.t108 vbn.t94 21.1705
R310 vbn.t122 vbn.t108 21.1705
R311 vbn.t136 vbn.t122 21.1705
R312 vbn.t150 vbn.t136 21.1705
R313 vbn.t164 vbn.t150 21.1705
R314 vbn.t178 vbn.t164 21.1705
R315 vbn.t192 vbn.t178 21.1705
R316 vbn.t206 vbn.t192 21.1705
R317 vbn.t220 vbn.t206 21.1705
R318 vbn.t53 vbn.t39 21.1705
R319 vbn.t67 vbn.t53 21.1705
R320 vbn.t81 vbn.t67 21.1705
R321 vbn.t95 vbn.t81 21.1705
R322 vbn.t109 vbn.t95 21.1705
R323 vbn.t123 vbn.t109 21.1705
R324 vbn.t137 vbn.t123 21.1705
R325 vbn.t151 vbn.t137 21.1705
R326 vbn.t165 vbn.t151 21.1705
R327 vbn.t179 vbn.t165 21.1705
R328 vbn.t193 vbn.t179 21.1705
R329 vbn.t207 vbn.t193 21.1705
R330 vbn.t221 vbn.t207 21.1705
R331 vbn.t54 vbn.t40 21.1705
R332 vbn.t68 vbn.t54 21.1705
R333 vbn.t82 vbn.t68 21.1705
R334 vbn.t96 vbn.t82 21.1705
R335 vbn.t110 vbn.t96 21.1705
R336 vbn.t124 vbn.t110 21.1705
R337 vbn.t138 vbn.t124 21.1705
R338 vbn.t152 vbn.t138 21.1705
R339 vbn.t166 vbn.t152 21.1705
R340 vbn.t180 vbn.t166 21.1705
R341 vbn.t194 vbn.t180 21.1705
R342 vbn.t208 vbn.t194 21.1705
R343 vbn.t222 vbn.t208 21.1705
R344 vbn.t55 vbn.t41 21.1705
R345 vbn.t69 vbn.t55 21.1705
R346 vbn.t83 vbn.t69 21.1705
R347 vbn.t97 vbn.t83 21.1705
R348 vbn.t111 vbn.t97 21.1705
R349 vbn.t125 vbn.t111 21.1705
R350 vbn.t139 vbn.t125 21.1705
R351 vbn.t153 vbn.t139 21.1705
R352 vbn.t167 vbn.t153 21.1705
R353 vbn.t181 vbn.t167 21.1705
R354 vbn.t195 vbn.t181 21.1705
R355 vbn.t209 vbn.t195 21.1705
R356 vbn.t223 vbn.t209 21.1705
R357 vbn.t56 vbn.t42 21.1705
R358 vbn.t70 vbn.t56 21.1705
R359 vbn.t84 vbn.t70 21.1705
R360 vbn.t98 vbn.t84 21.1705
R361 vbn.t112 vbn.t98 21.1705
R362 vbn.t126 vbn.t112 21.1705
R363 vbn.t140 vbn.t126 21.1705
R364 vbn.t154 vbn.t140 21.1705
R365 vbn.t168 vbn.t154 21.1705
R366 vbn.t182 vbn.t168 21.1705
R367 vbn.t196 vbn.t182 21.1705
R368 vbn.t210 vbn.t196 21.1705
R369 vbn.t224 vbn.t210 21.1705
R370 vbn.t57 vbn.t43 21.1705
R371 vbn.t71 vbn.t57 21.1705
R372 vbn.t85 vbn.t71 21.1705
R373 vbn.t99 vbn.t85 21.1705
R374 vbn.t113 vbn.t99 21.1705
R375 vbn.t127 vbn.t113 21.1705
R376 vbn.t141 vbn.t127 21.1705
R377 vbn.t155 vbn.t141 21.1705
R378 vbn.t169 vbn.t155 21.1705
R379 vbn.t183 vbn.t169 21.1705
R380 vbn.t197 vbn.t183 21.1705
R381 vbn.t211 vbn.t197 21.1705
R382 vbn.t225 vbn.t211 21.1705
R383 vbn.t58 vbn.t44 21.1705
R384 vbn.t72 vbn.t58 21.1705
R385 vbn.t86 vbn.t72 21.1705
R386 vbn.t100 vbn.t86 21.1705
R387 vbn.t114 vbn.t100 21.1705
R388 vbn.t128 vbn.t114 21.1705
R389 vbn.t142 vbn.t128 21.1705
R390 vbn.t156 vbn.t142 21.1705
R391 vbn.t170 vbn.t156 21.1705
R392 vbn.t184 vbn.t170 21.1705
R393 vbn.t198 vbn.t184 21.1705
R394 vbn.t212 vbn.t198 21.1705
R395 vbn.t226 vbn.t212 21.1705
R396 vbn.t59 vbn.t45 21.1705
R397 vbn.t73 vbn.t59 21.1705
R398 vbn.t87 vbn.t73 21.1705
R399 vbn.t101 vbn.t87 21.1705
R400 vbn.t115 vbn.t101 21.1705
R401 vbn.t129 vbn.t115 21.1705
R402 vbn.t143 vbn.t129 21.1705
R403 vbn.t157 vbn.t143 21.1705
R404 vbn.t171 vbn.t157 21.1705
R405 vbn.t185 vbn.t171 21.1705
R406 vbn.t199 vbn.t185 21.1705
R407 vbn.t213 vbn.t199 21.1705
R408 vbn.t227 vbn.t213 21.1705
R409 vbn.t60 vbn.t46 21.1705
R410 vbn.t74 vbn.t60 21.1705
R411 vbn.t88 vbn.t74 21.1705
R412 vbn.t102 vbn.t88 21.1705
R413 vbn.t116 vbn.t102 21.1705
R414 vbn.t130 vbn.t116 21.1705
R415 vbn.t144 vbn.t130 21.1705
R416 vbn.t158 vbn.t144 21.1705
R417 vbn.t172 vbn.t158 21.1705
R418 vbn.t186 vbn.t172 21.1705
R419 vbn.t200 vbn.t186 21.1705
R420 vbn.t214 vbn.t200 21.1705
R421 vbn.t228 vbn.t214 21.1705
R422 vbn.t61 vbn.t47 21.1705
R423 vbn.t75 vbn.t61 21.1705
R424 vbn.t89 vbn.t75 21.1705
R425 vbn.t103 vbn.t89 21.1705
R426 vbn.t117 vbn.t103 21.1705
R427 vbn.t131 vbn.t117 21.1705
R428 vbn.t145 vbn.t131 21.1705
R429 vbn.t159 vbn.t145 21.1705
R430 vbn.t173 vbn.t159 21.1705
R431 vbn.t187 vbn.t173 21.1705
R432 vbn.t201 vbn.t187 21.1705
R433 vbn.t215 vbn.t201 21.1705
R434 vbn.t229 vbn.t215 21.1705
R435 vbn.t62 vbn.t48 21.1705
R436 vbn.t76 vbn.t62 21.1705
R437 vbn.t90 vbn.t76 21.1705
R438 vbn.t104 vbn.t90 21.1705
R439 vbn.t118 vbn.t104 21.1705
R440 vbn.t132 vbn.t118 21.1705
R441 vbn.t146 vbn.t132 21.1705
R442 vbn.t160 vbn.t146 21.1705
R443 vbn.t174 vbn.t160 21.1705
R444 vbn.t188 vbn.t174 21.1705
R445 vbn.t202 vbn.t188 21.1705
R446 vbn.t216 vbn.t202 21.1705
R447 vbn.t230 vbn.t216 21.1705
R448 vbn.t238 vbn.t231 21.1705
R449 vbn.t245 vbn.t238 21.1705
R450 vbn.t252 vbn.t245 21.1705
R451 vbn.t259 vbn.t252 21.1705
R452 vbn.t266 vbn.t259 21.1705
R453 vbn.t273 vbn.t266 21.1705
R454 vbn.t280 vbn.t273 21.1705
R455 vbn.t287 vbn.t280 21.1705
R456 vbn.t294 vbn.t287 21.1705
R457 vbn.t301 vbn.t294 21.1705
R458 vbn.t308 vbn.t301 21.1705
R459 vbn.t315 vbn.t308 21.1705
R460 vbn.t32 vbn.t315 21.1705
R461 vbn.t239 vbn.t232 21.1705
R462 vbn.t246 vbn.t239 21.1705
R463 vbn.t253 vbn.t246 21.1705
R464 vbn.t260 vbn.t253 21.1705
R465 vbn.t267 vbn.t260 21.1705
R466 vbn.t274 vbn.t267 21.1705
R467 vbn.t281 vbn.t274 21.1705
R468 vbn.t288 vbn.t281 21.1705
R469 vbn.t295 vbn.t288 21.1705
R470 vbn.t302 vbn.t295 21.1705
R471 vbn.t309 vbn.t302 21.1705
R472 vbn.t316 vbn.t309 21.1705
R473 vbn.t30 vbn.t316 21.1705
R474 vbn.t240 vbn.t233 21.1705
R475 vbn.t247 vbn.t240 21.1705
R476 vbn.t254 vbn.t247 21.1705
R477 vbn.t261 vbn.t254 21.1705
R478 vbn.t268 vbn.t261 21.1705
R479 vbn.t275 vbn.t268 21.1705
R480 vbn.t282 vbn.t275 21.1705
R481 vbn.t289 vbn.t282 21.1705
R482 vbn.t296 vbn.t289 21.1705
R483 vbn.t303 vbn.t296 21.1705
R484 vbn.t310 vbn.t303 21.1705
R485 vbn.t317 vbn.t310 21.1705
R486 vbn.t28 vbn.t317 21.1705
R487 vbn.t241 vbn.t234 21.1705
R488 vbn.t248 vbn.t241 21.1705
R489 vbn.t255 vbn.t248 21.1705
R490 vbn.t262 vbn.t255 21.1705
R491 vbn.t269 vbn.t262 21.1705
R492 vbn.t276 vbn.t269 21.1705
R493 vbn.t283 vbn.t276 21.1705
R494 vbn.t290 vbn.t283 21.1705
R495 vbn.t297 vbn.t290 21.1705
R496 vbn.t304 vbn.t297 21.1705
R497 vbn.t311 vbn.t304 21.1705
R498 vbn.t318 vbn.t311 21.1705
R499 vbn.t26 vbn.t318 21.1705
R500 vbn.t242 vbn.t235 21.1705
R501 vbn.t249 vbn.t242 21.1705
R502 vbn.t256 vbn.t249 21.1705
R503 vbn.t263 vbn.t256 21.1705
R504 vbn.t270 vbn.t263 21.1705
R505 vbn.t277 vbn.t270 21.1705
R506 vbn.t284 vbn.t277 21.1705
R507 vbn.t291 vbn.t284 21.1705
R508 vbn.t298 vbn.t291 21.1705
R509 vbn.t305 vbn.t298 21.1705
R510 vbn.t312 vbn.t305 21.1705
R511 vbn.t319 vbn.t312 21.1705
R512 vbn.t24 vbn.t319 21.1705
R513 vbn.t243 vbn.t236 21.1705
R514 vbn.t250 vbn.t243 21.1705
R515 vbn.t257 vbn.t250 21.1705
R516 vbn.t264 vbn.t257 21.1705
R517 vbn.t271 vbn.t264 21.1705
R518 vbn.t278 vbn.t271 21.1705
R519 vbn.t285 vbn.t278 21.1705
R520 vbn.t292 vbn.t285 21.1705
R521 vbn.t299 vbn.t292 21.1705
R522 vbn.t306 vbn.t299 21.1705
R523 vbn.t313 vbn.t306 21.1705
R524 vbn.t320 vbn.t313 21.1705
R525 vbn.t22 vbn.t320 21.1705
R526 vbn.t244 vbn.t237 21.1705
R527 vbn.t251 vbn.t244 21.1705
R528 vbn.t258 vbn.t251 21.1705
R529 vbn.t265 vbn.t258 21.1705
R530 vbn.t272 vbn.t265 21.1705
R531 vbn.t279 vbn.t272 21.1705
R532 vbn.t286 vbn.t279 21.1705
R533 vbn.t293 vbn.t286 21.1705
R534 vbn.t300 vbn.t293 21.1705
R535 vbn.t307 vbn.t300 21.1705
R536 vbn.t314 vbn.t307 21.1705
R537 vbn.t321 vbn.t314 21.1705
R538 vbn.t20 vbn.t321 21.1705
R539 vbn.t350 vbn.t322 21.1705
R540 vbn.t378 vbn.t350 21.1705
R541 vbn.t406 vbn.t378 21.1705
R542 vbn.t434 vbn.t406 21.1705
R543 vbn.t462 vbn.t434 21.1705
R544 vbn.t490 vbn.t462 21.1705
R545 vbn.t518 vbn.t490 21.1705
R546 vbn.t546 vbn.t518 21.1705
R547 vbn.t574 vbn.t546 21.1705
R548 vbn.t602 vbn.t574 21.1705
R549 vbn.t630 vbn.t602 21.1705
R550 vbn.t658 vbn.t630 21.1705
R551 vbn.t686 vbn.t658 21.1705
R552 vbn.t351 vbn.t323 21.1705
R553 vbn.t379 vbn.t351 21.1705
R554 vbn.t407 vbn.t379 21.1705
R555 vbn.t435 vbn.t407 21.1705
R556 vbn.t463 vbn.t435 21.1705
R557 vbn.t491 vbn.t463 21.1705
R558 vbn.t519 vbn.t491 21.1705
R559 vbn.t547 vbn.t519 21.1705
R560 vbn.t575 vbn.t547 21.1705
R561 vbn.t603 vbn.t575 21.1705
R562 vbn.t631 vbn.t603 21.1705
R563 vbn.t659 vbn.t631 21.1705
R564 vbn.t687 vbn.t659 21.1705
R565 vbn.t352 vbn.t324 21.1705
R566 vbn.t380 vbn.t352 21.1705
R567 vbn.t408 vbn.t380 21.1705
R568 vbn.t436 vbn.t408 21.1705
R569 vbn.t464 vbn.t436 21.1705
R570 vbn.t492 vbn.t464 21.1705
R571 vbn.t520 vbn.t492 21.1705
R572 vbn.t548 vbn.t520 21.1705
R573 vbn.t576 vbn.t548 21.1705
R574 vbn.t604 vbn.t576 21.1705
R575 vbn.t632 vbn.t604 21.1705
R576 vbn.t660 vbn.t632 21.1705
R577 vbn.t688 vbn.t660 21.1705
R578 vbn.t353 vbn.t325 21.1705
R579 vbn.t381 vbn.t353 21.1705
R580 vbn.t409 vbn.t381 21.1705
R581 vbn.t437 vbn.t409 21.1705
R582 vbn.t465 vbn.t437 21.1705
R583 vbn.t493 vbn.t465 21.1705
R584 vbn.t521 vbn.t493 21.1705
R585 vbn.t549 vbn.t521 21.1705
R586 vbn.t577 vbn.t549 21.1705
R587 vbn.t605 vbn.t577 21.1705
R588 vbn.t633 vbn.t605 21.1705
R589 vbn.t661 vbn.t633 21.1705
R590 vbn.t689 vbn.t661 21.1705
R591 vbn.t354 vbn.t326 21.1705
R592 vbn.t382 vbn.t354 21.1705
R593 vbn.t410 vbn.t382 21.1705
R594 vbn.t438 vbn.t410 21.1705
R595 vbn.t466 vbn.t438 21.1705
R596 vbn.t494 vbn.t466 21.1705
R597 vbn.t522 vbn.t494 21.1705
R598 vbn.t550 vbn.t522 21.1705
R599 vbn.t578 vbn.t550 21.1705
R600 vbn.t606 vbn.t578 21.1705
R601 vbn.t634 vbn.t606 21.1705
R602 vbn.t662 vbn.t634 21.1705
R603 vbn.t690 vbn.t662 21.1705
R604 vbn.t355 vbn.t327 21.1705
R605 vbn.t383 vbn.t355 21.1705
R606 vbn.t411 vbn.t383 21.1705
R607 vbn.t439 vbn.t411 21.1705
R608 vbn.t467 vbn.t439 21.1705
R609 vbn.t495 vbn.t467 21.1705
R610 vbn.t523 vbn.t495 21.1705
R611 vbn.t551 vbn.t523 21.1705
R612 vbn.t579 vbn.t551 21.1705
R613 vbn.t607 vbn.t579 21.1705
R614 vbn.t635 vbn.t607 21.1705
R615 vbn.t663 vbn.t635 21.1705
R616 vbn.t691 vbn.t663 21.1705
R617 vbn.t356 vbn.t328 21.1705
R618 vbn.t384 vbn.t356 21.1705
R619 vbn.t412 vbn.t384 21.1705
R620 vbn.t440 vbn.t412 21.1705
R621 vbn.t468 vbn.t440 21.1705
R622 vbn.t496 vbn.t468 21.1705
R623 vbn.t524 vbn.t496 21.1705
R624 vbn.t552 vbn.t524 21.1705
R625 vbn.t580 vbn.t552 21.1705
R626 vbn.t608 vbn.t580 21.1705
R627 vbn.t636 vbn.t608 21.1705
R628 vbn.t664 vbn.t636 21.1705
R629 vbn.t692 vbn.t664 21.1705
R630 vbn.t357 vbn.t329 21.1705
R631 vbn.t385 vbn.t357 21.1705
R632 vbn.t413 vbn.t385 21.1705
R633 vbn.t441 vbn.t413 21.1705
R634 vbn.t469 vbn.t441 21.1705
R635 vbn.t497 vbn.t469 21.1705
R636 vbn.t525 vbn.t497 21.1705
R637 vbn.t553 vbn.t525 21.1705
R638 vbn.t581 vbn.t553 21.1705
R639 vbn.t609 vbn.t581 21.1705
R640 vbn.t637 vbn.t609 21.1705
R641 vbn.t665 vbn.t637 21.1705
R642 vbn.t693 vbn.t665 21.1705
R643 vbn.t358 vbn.t330 21.1705
R644 vbn.t386 vbn.t358 21.1705
R645 vbn.t414 vbn.t386 21.1705
R646 vbn.t442 vbn.t414 21.1705
R647 vbn.t470 vbn.t442 21.1705
R648 vbn.t498 vbn.t470 21.1705
R649 vbn.t526 vbn.t498 21.1705
R650 vbn.t554 vbn.t526 21.1705
R651 vbn.t582 vbn.t554 21.1705
R652 vbn.t610 vbn.t582 21.1705
R653 vbn.t638 vbn.t610 21.1705
R654 vbn.t666 vbn.t638 21.1705
R655 vbn.t694 vbn.t666 21.1705
R656 vbn.t359 vbn.t331 21.1705
R657 vbn.t387 vbn.t359 21.1705
R658 vbn.t415 vbn.t387 21.1705
R659 vbn.t443 vbn.t415 21.1705
R660 vbn.t471 vbn.t443 21.1705
R661 vbn.t499 vbn.t471 21.1705
R662 vbn.t527 vbn.t499 21.1705
R663 vbn.t555 vbn.t527 21.1705
R664 vbn.t583 vbn.t555 21.1705
R665 vbn.t611 vbn.t583 21.1705
R666 vbn.t639 vbn.t611 21.1705
R667 vbn.t667 vbn.t639 21.1705
R668 vbn.t695 vbn.t667 21.1705
R669 vbn.t360 vbn.t332 21.1705
R670 vbn.t388 vbn.t360 21.1705
R671 vbn.t416 vbn.t388 21.1705
R672 vbn.t444 vbn.t416 21.1705
R673 vbn.t472 vbn.t444 21.1705
R674 vbn.t500 vbn.t472 21.1705
R675 vbn.t528 vbn.t500 21.1705
R676 vbn.t556 vbn.t528 21.1705
R677 vbn.t584 vbn.t556 21.1705
R678 vbn.t612 vbn.t584 21.1705
R679 vbn.t640 vbn.t612 21.1705
R680 vbn.t668 vbn.t640 21.1705
R681 vbn.t696 vbn.t668 21.1705
R682 vbn.t361 vbn.t333 21.1705
R683 vbn.t389 vbn.t361 21.1705
R684 vbn.t417 vbn.t389 21.1705
R685 vbn.t445 vbn.t417 21.1705
R686 vbn.t473 vbn.t445 21.1705
R687 vbn.t501 vbn.t473 21.1705
R688 vbn.t529 vbn.t501 21.1705
R689 vbn.t557 vbn.t529 21.1705
R690 vbn.t585 vbn.t557 21.1705
R691 vbn.t613 vbn.t585 21.1705
R692 vbn.t641 vbn.t613 21.1705
R693 vbn.t669 vbn.t641 21.1705
R694 vbn.t697 vbn.t669 21.1705
R695 vbn.t362 vbn.t334 21.1705
R696 vbn.t390 vbn.t362 21.1705
R697 vbn.t418 vbn.t390 21.1705
R698 vbn.t446 vbn.t418 21.1705
R699 vbn.t474 vbn.t446 21.1705
R700 vbn.t502 vbn.t474 21.1705
R701 vbn.t530 vbn.t502 21.1705
R702 vbn.t558 vbn.t530 21.1705
R703 vbn.t586 vbn.t558 21.1705
R704 vbn.t614 vbn.t586 21.1705
R705 vbn.t642 vbn.t614 21.1705
R706 vbn.t670 vbn.t642 21.1705
R707 vbn.t698 vbn.t670 21.1705
R708 vbn.t363 vbn.t335 21.1705
R709 vbn.t391 vbn.t363 21.1705
R710 vbn.t419 vbn.t391 21.1705
R711 vbn.t447 vbn.t419 21.1705
R712 vbn.t475 vbn.t447 21.1705
R713 vbn.t503 vbn.t475 21.1705
R714 vbn.t531 vbn.t503 21.1705
R715 vbn.t559 vbn.t531 21.1705
R716 vbn.t587 vbn.t559 21.1705
R717 vbn.t615 vbn.t587 21.1705
R718 vbn.t643 vbn.t615 21.1705
R719 vbn.t671 vbn.t643 21.1705
R720 vbn.t699 vbn.t671 21.1705
R721 vbn.t364 vbn.t336 21.1705
R722 vbn.t392 vbn.t364 21.1705
R723 vbn.t420 vbn.t392 21.1705
R724 vbn.t448 vbn.t420 21.1705
R725 vbn.t476 vbn.t448 21.1705
R726 vbn.t504 vbn.t476 21.1705
R727 vbn.t532 vbn.t504 21.1705
R728 vbn.t560 vbn.t532 21.1705
R729 vbn.t588 vbn.t560 21.1705
R730 vbn.t616 vbn.t588 21.1705
R731 vbn.t644 vbn.t616 21.1705
R732 vbn.t672 vbn.t644 21.1705
R733 vbn.t700 vbn.t672 21.1705
R734 vbn.t365 vbn.t337 21.1705
R735 vbn.t393 vbn.t365 21.1705
R736 vbn.t421 vbn.t393 21.1705
R737 vbn.t449 vbn.t421 21.1705
R738 vbn.t477 vbn.t449 21.1705
R739 vbn.t505 vbn.t477 21.1705
R740 vbn.t533 vbn.t505 21.1705
R741 vbn.t561 vbn.t533 21.1705
R742 vbn.t589 vbn.t561 21.1705
R743 vbn.t617 vbn.t589 21.1705
R744 vbn.t645 vbn.t617 21.1705
R745 vbn.t673 vbn.t645 21.1705
R746 vbn.t701 vbn.t673 21.1705
R747 vbn.t366 vbn.t338 21.1705
R748 vbn.t394 vbn.t366 21.1705
R749 vbn.t422 vbn.t394 21.1705
R750 vbn.t450 vbn.t422 21.1705
R751 vbn.t478 vbn.t450 21.1705
R752 vbn.t506 vbn.t478 21.1705
R753 vbn.t534 vbn.t506 21.1705
R754 vbn.t562 vbn.t534 21.1705
R755 vbn.t590 vbn.t562 21.1705
R756 vbn.t618 vbn.t590 21.1705
R757 vbn.t646 vbn.t618 21.1705
R758 vbn.t674 vbn.t646 21.1705
R759 vbn.t702 vbn.t674 21.1705
R760 vbn.t367 vbn.t339 21.1705
R761 vbn.t395 vbn.t367 21.1705
R762 vbn.t423 vbn.t395 21.1705
R763 vbn.t451 vbn.t423 21.1705
R764 vbn.t479 vbn.t451 21.1705
R765 vbn.t507 vbn.t479 21.1705
R766 vbn.t535 vbn.t507 21.1705
R767 vbn.t563 vbn.t535 21.1705
R768 vbn.t591 vbn.t563 21.1705
R769 vbn.t619 vbn.t591 21.1705
R770 vbn.t647 vbn.t619 21.1705
R771 vbn.t675 vbn.t647 21.1705
R772 vbn.t703 vbn.t675 21.1705
R773 vbn.t368 vbn.t340 21.1705
R774 vbn.t396 vbn.t368 21.1705
R775 vbn.t424 vbn.t396 21.1705
R776 vbn.t452 vbn.t424 21.1705
R777 vbn.t480 vbn.t452 21.1705
R778 vbn.t508 vbn.t480 21.1705
R779 vbn.t536 vbn.t508 21.1705
R780 vbn.t564 vbn.t536 21.1705
R781 vbn.t592 vbn.t564 21.1705
R782 vbn.t620 vbn.t592 21.1705
R783 vbn.t648 vbn.t620 21.1705
R784 vbn.t676 vbn.t648 21.1705
R785 vbn.t704 vbn.t676 21.1705
R786 vbn.t369 vbn.t341 21.1705
R787 vbn.t397 vbn.t369 21.1705
R788 vbn.t425 vbn.t397 21.1705
R789 vbn.t453 vbn.t425 21.1705
R790 vbn.t481 vbn.t453 21.1705
R791 vbn.t509 vbn.t481 21.1705
R792 vbn.t537 vbn.t509 21.1705
R793 vbn.t565 vbn.t537 21.1705
R794 vbn.t593 vbn.t565 21.1705
R795 vbn.t621 vbn.t593 21.1705
R796 vbn.t649 vbn.t621 21.1705
R797 vbn.t677 vbn.t649 21.1705
R798 vbn.t705 vbn.t677 21.1705
R799 vbn.t370 vbn.t342 21.1705
R800 vbn.t398 vbn.t370 21.1705
R801 vbn.t426 vbn.t398 21.1705
R802 vbn.t454 vbn.t426 21.1705
R803 vbn.t482 vbn.t454 21.1705
R804 vbn.t510 vbn.t482 21.1705
R805 vbn.t538 vbn.t510 21.1705
R806 vbn.t566 vbn.t538 21.1705
R807 vbn.t594 vbn.t566 21.1705
R808 vbn.t622 vbn.t594 21.1705
R809 vbn.t650 vbn.t622 21.1705
R810 vbn.t678 vbn.t650 21.1705
R811 vbn.t706 vbn.t678 21.1705
R812 vbn.t371 vbn.t343 21.1705
R813 vbn.t399 vbn.t371 21.1705
R814 vbn.t427 vbn.t399 21.1705
R815 vbn.t455 vbn.t427 21.1705
R816 vbn.t483 vbn.t455 21.1705
R817 vbn.t511 vbn.t483 21.1705
R818 vbn.t539 vbn.t511 21.1705
R819 vbn.t567 vbn.t539 21.1705
R820 vbn.t595 vbn.t567 21.1705
R821 vbn.t623 vbn.t595 21.1705
R822 vbn.t651 vbn.t623 21.1705
R823 vbn.t679 vbn.t651 21.1705
R824 vbn.t707 vbn.t679 21.1705
R825 vbn.t372 vbn.t344 21.1705
R826 vbn.t400 vbn.t372 21.1705
R827 vbn.t428 vbn.t400 21.1705
R828 vbn.t456 vbn.t428 21.1705
R829 vbn.t484 vbn.t456 21.1705
R830 vbn.t512 vbn.t484 21.1705
R831 vbn.t540 vbn.t512 21.1705
R832 vbn.t568 vbn.t540 21.1705
R833 vbn.t596 vbn.t568 21.1705
R834 vbn.t624 vbn.t596 21.1705
R835 vbn.t652 vbn.t624 21.1705
R836 vbn.t680 vbn.t652 21.1705
R837 vbn.t708 vbn.t680 21.1705
R838 vbn.t373 vbn.t345 21.1705
R839 vbn.t401 vbn.t373 21.1705
R840 vbn.t429 vbn.t401 21.1705
R841 vbn.t457 vbn.t429 21.1705
R842 vbn.t485 vbn.t457 21.1705
R843 vbn.t513 vbn.t485 21.1705
R844 vbn.t541 vbn.t513 21.1705
R845 vbn.t569 vbn.t541 21.1705
R846 vbn.t597 vbn.t569 21.1705
R847 vbn.t625 vbn.t597 21.1705
R848 vbn.t653 vbn.t625 21.1705
R849 vbn.t681 vbn.t653 21.1705
R850 vbn.t709 vbn.t681 21.1705
R851 vbn.t374 vbn.t346 21.1705
R852 vbn.t402 vbn.t374 21.1705
R853 vbn.t430 vbn.t402 21.1705
R854 vbn.t458 vbn.t430 21.1705
R855 vbn.t486 vbn.t458 21.1705
R856 vbn.t514 vbn.t486 21.1705
R857 vbn.t542 vbn.t514 21.1705
R858 vbn.t570 vbn.t542 21.1705
R859 vbn.t598 vbn.t570 21.1705
R860 vbn.t626 vbn.t598 21.1705
R861 vbn.t654 vbn.t626 21.1705
R862 vbn.t682 vbn.t654 21.1705
R863 vbn.t710 vbn.t682 21.1705
R864 vbn.t375 vbn.t347 21.1705
R865 vbn.t403 vbn.t375 21.1705
R866 vbn.t431 vbn.t403 21.1705
R867 vbn.t459 vbn.t431 21.1705
R868 vbn.t487 vbn.t459 21.1705
R869 vbn.t515 vbn.t487 21.1705
R870 vbn.t543 vbn.t515 21.1705
R871 vbn.t571 vbn.t543 21.1705
R872 vbn.t599 vbn.t571 21.1705
R873 vbn.t627 vbn.t599 21.1705
R874 vbn.t655 vbn.t627 21.1705
R875 vbn.t683 vbn.t655 21.1705
R876 vbn.t711 vbn.t683 21.1705
R877 vbn.t376 vbn.t348 21.1705
R878 vbn.t404 vbn.t376 21.1705
R879 vbn.t432 vbn.t404 21.1705
R880 vbn.t460 vbn.t432 21.1705
R881 vbn.t488 vbn.t460 21.1705
R882 vbn.t516 vbn.t488 21.1705
R883 vbn.t544 vbn.t516 21.1705
R884 vbn.t572 vbn.t544 21.1705
R885 vbn.t600 vbn.t572 21.1705
R886 vbn.t628 vbn.t600 21.1705
R887 vbn.t656 vbn.t628 21.1705
R888 vbn.t684 vbn.t656 21.1705
R889 vbn.t712 vbn.t684 21.1705
R890 vbn.t377 vbn.t349 21.1705
R891 vbn.t405 vbn.t377 21.1705
R892 vbn.t433 vbn.t405 21.1705
R893 vbn.t461 vbn.t433 21.1705
R894 vbn.t489 vbn.t461 21.1705
R895 vbn.t517 vbn.t489 21.1705
R896 vbn.t545 vbn.t517 21.1705
R897 vbn.t573 vbn.t545 21.1705
R898 vbn.t601 vbn.t573 21.1705
R899 vbn.t629 vbn.t601 21.1705
R900 vbn.t657 vbn.t629 21.1705
R901 vbn.t685 vbn.t657 21.1705
R902 vbn.t713 vbn.t685 21.1705
R903 vbn.t721 vbn.t714 21.1705
R904 vbn.t728 vbn.t721 21.1705
R905 vbn.t735 vbn.t728 21.1705
R906 vbn.t742 vbn.t735 21.1705
R907 vbn.t749 vbn.t742 21.1705
R908 vbn.t756 vbn.t749 21.1705
R909 vbn.t763 vbn.t756 21.1705
R910 vbn.t770 vbn.t763 21.1705
R911 vbn.t777 vbn.t770 21.1705
R912 vbn.t784 vbn.t777 21.1705
R913 vbn.t791 vbn.t784 21.1705
R914 vbn.t798 vbn.t791 21.1705
R915 vbn.t18 vbn.t798 21.1705
R916 vbn.t722 vbn.t715 21.1705
R917 vbn.t729 vbn.t722 21.1705
R918 vbn.t736 vbn.t729 21.1705
R919 vbn.t743 vbn.t736 21.1705
R920 vbn.t750 vbn.t743 21.1705
R921 vbn.t757 vbn.t750 21.1705
R922 vbn.t764 vbn.t757 21.1705
R923 vbn.t771 vbn.t764 21.1705
R924 vbn.t778 vbn.t771 21.1705
R925 vbn.t785 vbn.t778 21.1705
R926 vbn.t792 vbn.t785 21.1705
R927 vbn.t799 vbn.t792 21.1705
R928 vbn.t16 vbn.t799 21.1705
R929 vbn.t723 vbn.t716 21.1705
R930 vbn.t730 vbn.t723 21.1705
R931 vbn.t737 vbn.t730 21.1705
R932 vbn.t744 vbn.t737 21.1705
R933 vbn.t751 vbn.t744 21.1705
R934 vbn.t758 vbn.t751 21.1705
R935 vbn.t765 vbn.t758 21.1705
R936 vbn.t772 vbn.t765 21.1705
R937 vbn.t779 vbn.t772 21.1705
R938 vbn.t786 vbn.t779 21.1705
R939 vbn.t793 vbn.t786 21.1705
R940 vbn.t800 vbn.t793 21.1705
R941 vbn.t14 vbn.t800 21.1705
R942 vbn.t724 vbn.t717 21.1705
R943 vbn.t731 vbn.t724 21.1705
R944 vbn.t738 vbn.t731 21.1705
R945 vbn.t745 vbn.t738 21.1705
R946 vbn.t752 vbn.t745 21.1705
R947 vbn.t759 vbn.t752 21.1705
R948 vbn.t766 vbn.t759 21.1705
R949 vbn.t773 vbn.t766 21.1705
R950 vbn.t780 vbn.t773 21.1705
R951 vbn.t787 vbn.t780 21.1705
R952 vbn.t794 vbn.t787 21.1705
R953 vbn.t801 vbn.t794 21.1705
R954 vbn.t12 vbn.t801 21.1705
R955 vbn.t725 vbn.t718 21.1705
R956 vbn.t732 vbn.t725 21.1705
R957 vbn.t739 vbn.t732 21.1705
R958 vbn.t746 vbn.t739 21.1705
R959 vbn.t753 vbn.t746 21.1705
R960 vbn.t760 vbn.t753 21.1705
R961 vbn.t767 vbn.t760 21.1705
R962 vbn.t774 vbn.t767 21.1705
R963 vbn.t781 vbn.t774 21.1705
R964 vbn.t788 vbn.t781 21.1705
R965 vbn.t795 vbn.t788 21.1705
R966 vbn.t802 vbn.t795 21.1705
R967 vbn.t10 vbn.t802 21.1705
R968 vbn.t726 vbn.t719 21.1705
R969 vbn.t733 vbn.t726 21.1705
R970 vbn.t740 vbn.t733 21.1705
R971 vbn.t747 vbn.t740 21.1705
R972 vbn.t754 vbn.t747 21.1705
R973 vbn.t761 vbn.t754 21.1705
R974 vbn.t768 vbn.t761 21.1705
R975 vbn.t775 vbn.t768 21.1705
R976 vbn.t782 vbn.t775 21.1705
R977 vbn.t789 vbn.t782 21.1705
R978 vbn.t796 vbn.t789 21.1705
R979 vbn.t803 vbn.t796 21.1705
R980 vbn.t8 vbn.t803 21.1705
R981 vbn.t727 vbn.t720 21.1705
R982 vbn.t734 vbn.t727 21.1705
R983 vbn.t741 vbn.t734 21.1705
R984 vbn.t748 vbn.t741 21.1705
R985 vbn.t755 vbn.t748 21.1705
R986 vbn.t762 vbn.t755 21.1705
R987 vbn.t769 vbn.t762 21.1705
R988 vbn.t776 vbn.t769 21.1705
R989 vbn.t783 vbn.t776 21.1705
R990 vbn.t790 vbn.t783 21.1705
R991 vbn.t797 vbn.t790 21.1705
R992 vbn.t804 vbn.t797 21.1705
R993 vbn.t6 vbn.t804 21.1705
R994 vbn.t819 vbn.t805 21.1705
R995 vbn.t833 vbn.t819 21.1705
R996 vbn.t847 vbn.t833 21.1705
R997 vbn.t861 vbn.t847 21.1705
R998 vbn.t875 vbn.t861 21.1705
R999 vbn.t889 vbn.t875 21.1705
R1000 vbn.t903 vbn.t889 21.1705
R1001 vbn.t917 vbn.t903 21.1705
R1002 vbn.t931 vbn.t917 21.1705
R1003 vbn.t945 vbn.t931 21.1705
R1004 vbn.t959 vbn.t945 21.1705
R1005 vbn.t973 vbn.t959 21.1705
R1006 vbn.t987 vbn.t973 21.1705
R1007 vbn.t820 vbn.t806 21.1705
R1008 vbn.t834 vbn.t820 21.1705
R1009 vbn.t848 vbn.t834 21.1705
R1010 vbn.t862 vbn.t848 21.1705
R1011 vbn.t876 vbn.t862 21.1705
R1012 vbn.t890 vbn.t876 21.1705
R1013 vbn.t904 vbn.t890 21.1705
R1014 vbn.t918 vbn.t904 21.1705
R1015 vbn.t932 vbn.t918 21.1705
R1016 vbn.t946 vbn.t932 21.1705
R1017 vbn.t960 vbn.t946 21.1705
R1018 vbn.t974 vbn.t960 21.1705
R1019 vbn.t988 vbn.t974 21.1705
R1020 vbn.t821 vbn.t807 21.1705
R1021 vbn.t835 vbn.t821 21.1705
R1022 vbn.t849 vbn.t835 21.1705
R1023 vbn.t863 vbn.t849 21.1705
R1024 vbn.t877 vbn.t863 21.1705
R1025 vbn.t891 vbn.t877 21.1705
R1026 vbn.t905 vbn.t891 21.1705
R1027 vbn.t919 vbn.t905 21.1705
R1028 vbn.t933 vbn.t919 21.1705
R1029 vbn.t947 vbn.t933 21.1705
R1030 vbn.t961 vbn.t947 21.1705
R1031 vbn.t975 vbn.t961 21.1705
R1032 vbn.t989 vbn.t975 21.1705
R1033 vbn.t822 vbn.t808 21.1705
R1034 vbn.t836 vbn.t822 21.1705
R1035 vbn.t850 vbn.t836 21.1705
R1036 vbn.t864 vbn.t850 21.1705
R1037 vbn.t878 vbn.t864 21.1705
R1038 vbn.t892 vbn.t878 21.1705
R1039 vbn.t906 vbn.t892 21.1705
R1040 vbn.t920 vbn.t906 21.1705
R1041 vbn.t934 vbn.t920 21.1705
R1042 vbn.t948 vbn.t934 21.1705
R1043 vbn.t962 vbn.t948 21.1705
R1044 vbn.t976 vbn.t962 21.1705
R1045 vbn.t990 vbn.t976 21.1705
R1046 vbn.t823 vbn.t809 21.1705
R1047 vbn.t837 vbn.t823 21.1705
R1048 vbn.t851 vbn.t837 21.1705
R1049 vbn.t865 vbn.t851 21.1705
R1050 vbn.t879 vbn.t865 21.1705
R1051 vbn.t893 vbn.t879 21.1705
R1052 vbn.t907 vbn.t893 21.1705
R1053 vbn.t921 vbn.t907 21.1705
R1054 vbn.t935 vbn.t921 21.1705
R1055 vbn.t949 vbn.t935 21.1705
R1056 vbn.t963 vbn.t949 21.1705
R1057 vbn.t977 vbn.t963 21.1705
R1058 vbn.t991 vbn.t977 21.1705
R1059 vbn.t824 vbn.t810 21.1705
R1060 vbn.t838 vbn.t824 21.1705
R1061 vbn.t852 vbn.t838 21.1705
R1062 vbn.t866 vbn.t852 21.1705
R1063 vbn.t880 vbn.t866 21.1705
R1064 vbn.t894 vbn.t880 21.1705
R1065 vbn.t908 vbn.t894 21.1705
R1066 vbn.t922 vbn.t908 21.1705
R1067 vbn.t936 vbn.t922 21.1705
R1068 vbn.t950 vbn.t936 21.1705
R1069 vbn.t964 vbn.t950 21.1705
R1070 vbn.t978 vbn.t964 21.1705
R1071 vbn.t992 vbn.t978 21.1705
R1072 vbn.t825 vbn.t811 21.1705
R1073 vbn.t839 vbn.t825 21.1705
R1074 vbn.t853 vbn.t839 21.1705
R1075 vbn.t867 vbn.t853 21.1705
R1076 vbn.t881 vbn.t867 21.1705
R1077 vbn.t895 vbn.t881 21.1705
R1078 vbn.t909 vbn.t895 21.1705
R1079 vbn.t923 vbn.t909 21.1705
R1080 vbn.t937 vbn.t923 21.1705
R1081 vbn.t951 vbn.t937 21.1705
R1082 vbn.t965 vbn.t951 21.1705
R1083 vbn.t979 vbn.t965 21.1705
R1084 vbn.t993 vbn.t979 21.1705
R1085 vbn.t826 vbn.t812 21.1705
R1086 vbn.t840 vbn.t826 21.1705
R1087 vbn.t854 vbn.t840 21.1705
R1088 vbn.t868 vbn.t854 21.1705
R1089 vbn.t882 vbn.t868 21.1705
R1090 vbn.t896 vbn.t882 21.1705
R1091 vbn.t910 vbn.t896 21.1705
R1092 vbn.t924 vbn.t910 21.1705
R1093 vbn.t938 vbn.t924 21.1705
R1094 vbn.t952 vbn.t938 21.1705
R1095 vbn.t966 vbn.t952 21.1705
R1096 vbn.t980 vbn.t966 21.1705
R1097 vbn.t994 vbn.t980 21.1705
R1098 vbn.t827 vbn.t813 21.1705
R1099 vbn.t841 vbn.t827 21.1705
R1100 vbn.t855 vbn.t841 21.1705
R1101 vbn.t869 vbn.t855 21.1705
R1102 vbn.t883 vbn.t869 21.1705
R1103 vbn.t897 vbn.t883 21.1705
R1104 vbn.t911 vbn.t897 21.1705
R1105 vbn.t925 vbn.t911 21.1705
R1106 vbn.t939 vbn.t925 21.1705
R1107 vbn.t953 vbn.t939 21.1705
R1108 vbn.t967 vbn.t953 21.1705
R1109 vbn.t981 vbn.t967 21.1705
R1110 vbn.t995 vbn.t981 21.1705
R1111 vbn.t828 vbn.t814 21.1705
R1112 vbn.t842 vbn.t828 21.1705
R1113 vbn.t856 vbn.t842 21.1705
R1114 vbn.t870 vbn.t856 21.1705
R1115 vbn.t884 vbn.t870 21.1705
R1116 vbn.t898 vbn.t884 21.1705
R1117 vbn.t912 vbn.t898 21.1705
R1118 vbn.t926 vbn.t912 21.1705
R1119 vbn.t940 vbn.t926 21.1705
R1120 vbn.t954 vbn.t940 21.1705
R1121 vbn.t968 vbn.t954 21.1705
R1122 vbn.t982 vbn.t968 21.1705
R1123 vbn.t996 vbn.t982 21.1705
R1124 vbn.t829 vbn.t815 21.1705
R1125 vbn.t843 vbn.t829 21.1705
R1126 vbn.t857 vbn.t843 21.1705
R1127 vbn.t871 vbn.t857 21.1705
R1128 vbn.t885 vbn.t871 21.1705
R1129 vbn.t899 vbn.t885 21.1705
R1130 vbn.t913 vbn.t899 21.1705
R1131 vbn.t927 vbn.t913 21.1705
R1132 vbn.t941 vbn.t927 21.1705
R1133 vbn.t955 vbn.t941 21.1705
R1134 vbn.t969 vbn.t955 21.1705
R1135 vbn.t983 vbn.t969 21.1705
R1136 vbn.t997 vbn.t983 21.1705
R1137 vbn.t830 vbn.t816 21.1705
R1138 vbn.t844 vbn.t830 21.1705
R1139 vbn.t858 vbn.t844 21.1705
R1140 vbn.t872 vbn.t858 21.1705
R1141 vbn.t886 vbn.t872 21.1705
R1142 vbn.t900 vbn.t886 21.1705
R1143 vbn.t914 vbn.t900 21.1705
R1144 vbn.t928 vbn.t914 21.1705
R1145 vbn.t942 vbn.t928 21.1705
R1146 vbn.t956 vbn.t942 21.1705
R1147 vbn.t970 vbn.t956 21.1705
R1148 vbn.t984 vbn.t970 21.1705
R1149 vbn.t998 vbn.t984 21.1705
R1150 vbn.t831 vbn.t817 21.1705
R1151 vbn.t845 vbn.t831 21.1705
R1152 vbn.t859 vbn.t845 21.1705
R1153 vbn.t873 vbn.t859 21.1705
R1154 vbn.t887 vbn.t873 21.1705
R1155 vbn.t901 vbn.t887 21.1705
R1156 vbn.t915 vbn.t901 21.1705
R1157 vbn.t929 vbn.t915 21.1705
R1158 vbn.t943 vbn.t929 21.1705
R1159 vbn.t957 vbn.t943 21.1705
R1160 vbn.t971 vbn.t957 21.1705
R1161 vbn.t985 vbn.t971 21.1705
R1162 vbn.t999 vbn.t985 21.1705
R1163 vbn.t832 vbn.t818 21.1705
R1164 vbn.t846 vbn.t832 21.1705
R1165 vbn.t860 vbn.t846 21.1705
R1166 vbn.t874 vbn.t860 21.1705
R1167 vbn.t888 vbn.t874 21.1705
R1168 vbn.t902 vbn.t888 21.1705
R1169 vbn.t916 vbn.t902 21.1705
R1170 vbn.t930 vbn.t916 21.1705
R1171 vbn.t944 vbn.t930 21.1705
R1172 vbn.t958 vbn.t944 21.1705
R1173 vbn.t972 vbn.t958 21.1705
R1174 vbn.t986 vbn.t972 21.1705
R1175 vbn.t1000 vbn.t986 21.1705
R1176 vbn.n156 vbn.t217 15.0385
R1177 vbn.n155 vbn.t218 15.0385
R1178 vbn.n154 vbn.t219 15.0385
R1179 vbn.n153 vbn.t220 15.0385
R1180 vbn.n152 vbn.t221 15.0385
R1181 vbn.n151 vbn.t222 15.0385
R1182 vbn.n150 vbn.t223 15.0385
R1183 vbn.n149 vbn.t224 15.0385
R1184 vbn.n148 vbn.t225 15.0385
R1185 vbn.n147 vbn.t226 15.0385
R1186 vbn.n146 vbn.t227 15.0385
R1187 vbn.n145 vbn.t228 15.0385
R1188 vbn.n144 vbn.t229 15.0385
R1189 vbn.n143 vbn.t230 15.0385
R1190 vbn.n142 vbn.t32 15.0385
R1191 vbn.n141 vbn.t30 15.0385
R1192 vbn.n140 vbn.t28 15.0385
R1193 vbn.n139 vbn.t26 15.0385
R1194 vbn.n138 vbn.t24 15.0385
R1195 vbn.n137 vbn.t22 15.0385
R1196 vbn.n136 vbn.t20 15.0385
R1197 vbn.n135 vbn.t686 15.0385
R1198 vbn.n134 vbn.t687 15.0385
R1199 vbn.n133 vbn.t688 15.0385
R1200 vbn.n132 vbn.t689 15.0385
R1201 vbn.n131 vbn.t690 15.0385
R1202 vbn.n130 vbn.t691 15.0385
R1203 vbn.n129 vbn.t692 15.0385
R1204 vbn.n128 vbn.t693 15.0385
R1205 vbn.n127 vbn.t694 15.0385
R1206 vbn.n126 vbn.t695 15.0385
R1207 vbn.n125 vbn.t696 15.0385
R1208 vbn.n124 vbn.t697 15.0385
R1209 vbn.n123 vbn.t698 15.0385
R1210 vbn.n122 vbn.t699 15.0385
R1211 vbn.n121 vbn.t700 15.0385
R1212 vbn.n120 vbn.t701 15.0385
R1213 vbn.n119 vbn.t702 15.0385
R1214 vbn.n118 vbn.t703 15.0385
R1215 vbn.n117 vbn.t704 15.0385
R1216 vbn.n116 vbn.t705 15.0385
R1217 vbn.n115 vbn.t706 15.0385
R1218 vbn.n114 vbn.t707 15.0385
R1219 vbn.n113 vbn.t708 15.0385
R1220 vbn.n112 vbn.t709 15.0385
R1221 vbn.n111 vbn.t710 15.0385
R1222 vbn.n110 vbn.t711 15.0385
R1223 vbn.n109 vbn.t712 15.0385
R1224 vbn.n108 vbn.t713 15.0385
R1225 vbn.n107 vbn.t18 15.0385
R1226 vbn.n106 vbn.t16 15.0385
R1227 vbn.n105 vbn.t14 15.0385
R1228 vbn.n104 vbn.t12 15.0385
R1229 vbn.n103 vbn.t10 15.0385
R1230 vbn.n102 vbn.t8 15.0385
R1231 vbn.n101 vbn.t6 15.0385
R1232 vbn.n100 vbn.t987 15.0385
R1233 vbn.n99 vbn.t988 15.0385
R1234 vbn.n98 vbn.t989 15.0385
R1235 vbn.n97 vbn.t990 15.0385
R1236 vbn.n96 vbn.t991 15.0385
R1237 vbn.n95 vbn.t992 15.0385
R1238 vbn.n94 vbn.t993 15.0385
R1239 vbn.n93 vbn.t994 15.0385
R1240 vbn.n92 vbn.t995 15.0385
R1241 vbn.n91 vbn.t996 15.0385
R1242 vbn.n90 vbn.t997 15.0385
R1243 vbn.n89 vbn.t998 15.0385
R1244 vbn.n88 vbn.t999 15.0385
R1245 vbn.n87 vbn.t1000 15.0385
R1246 vbn.n9 vbn.n8 11.1598
R1247 vbn.n77 vbn.n76 11.1598
R1248 vbn.n156 vbn.n155 11.0491
R1249 vbn.n155 vbn.n154 11.0491
R1250 vbn.n154 vbn.n153 11.0491
R1251 vbn.n153 vbn.n152 11.0491
R1252 vbn.n152 vbn.n151 11.0491
R1253 vbn.n151 vbn.n150 11.0491
R1254 vbn.n150 vbn.n149 11.0491
R1255 vbn.n149 vbn.n148 11.0491
R1256 vbn.n148 vbn.n147 11.0491
R1257 vbn.n147 vbn.n146 11.0491
R1258 vbn.n146 vbn.n145 11.0491
R1259 vbn.n145 vbn.n144 11.0491
R1260 vbn.n144 vbn.n143 11.0491
R1261 vbn.n142 vbn.n141 11.0491
R1262 vbn.n141 vbn.n140 11.0491
R1263 vbn.n140 vbn.n139 11.0491
R1264 vbn.n139 vbn.n138 11.0491
R1265 vbn.n138 vbn.n137 11.0491
R1266 vbn.n137 vbn.n136 11.0491
R1267 vbn.n135 vbn.n134 11.0491
R1268 vbn.n134 vbn.n133 11.0491
R1269 vbn.n133 vbn.n132 11.0491
R1270 vbn.n132 vbn.n131 11.0491
R1271 vbn.n131 vbn.n130 11.0491
R1272 vbn.n130 vbn.n129 11.0491
R1273 vbn.n129 vbn.n128 11.0491
R1274 vbn.n128 vbn.n127 11.0491
R1275 vbn.n127 vbn.n126 11.0491
R1276 vbn.n126 vbn.n125 11.0491
R1277 vbn.n125 vbn.n124 11.0491
R1278 vbn.n124 vbn.n123 11.0491
R1279 vbn.n123 vbn.n122 11.0491
R1280 vbn.n122 vbn.n121 11.0491
R1281 vbn.n121 vbn.n120 11.0491
R1282 vbn.n120 vbn.n119 11.0491
R1283 vbn.n119 vbn.n118 11.0491
R1284 vbn.n118 vbn.n117 11.0491
R1285 vbn.n117 vbn.n116 11.0491
R1286 vbn.n116 vbn.n115 11.0491
R1287 vbn.n115 vbn.n114 11.0491
R1288 vbn.n114 vbn.n113 11.0491
R1289 vbn.n113 vbn.n112 11.0491
R1290 vbn.n112 vbn.n111 11.0491
R1291 vbn.n111 vbn.n110 11.0491
R1292 vbn.n110 vbn.n109 11.0491
R1293 vbn.n109 vbn.n108 11.0491
R1294 vbn.n107 vbn.n106 11.0491
R1295 vbn.n106 vbn.n105 11.0491
R1296 vbn.n105 vbn.n104 11.0491
R1297 vbn.n104 vbn.n103 11.0491
R1298 vbn.n103 vbn.n102 11.0491
R1299 vbn.n102 vbn.n101 11.0491
R1300 vbn.n100 vbn.n99 11.0491
R1301 vbn.n99 vbn.n98 11.0491
R1302 vbn.n98 vbn.n97 11.0491
R1303 vbn.n97 vbn.n96 11.0491
R1304 vbn.n96 vbn.n95 11.0491
R1305 vbn.n95 vbn.n94 11.0491
R1306 vbn.n94 vbn.n93 11.0491
R1307 vbn.n93 vbn.n92 11.0491
R1308 vbn.n92 vbn.n91 11.0491
R1309 vbn.n91 vbn.n90 11.0491
R1310 vbn.n90 vbn.n89 11.0491
R1311 vbn.n89 vbn.n88 11.0491
R1312 vbn.n88 vbn.n87 11.0491
R1313 vbn.n88 vbn.n85 8.0005
R1314 vbn.n89 vbn.n84 8.0005
R1315 vbn.n90 vbn.n83 8.0005
R1316 vbn.n91 vbn.n82 8.0005
R1317 vbn.n92 vbn.n81 8.0005
R1318 vbn.n93 vbn.n80 8.0005
R1319 vbn.n94 vbn.n79 8.0005
R1320 vbn.n95 vbn.n78 8.0005
R1321 vbn.n96 vbn.n75 8.0005
R1322 vbn.n97 vbn.n74 8.0005
R1323 vbn.n98 vbn.n73 8.0005
R1324 vbn.n99 vbn.n72 8.0005
R1325 vbn.n100 vbn.n71 8.0005
R1326 vbn.n101 vbn.n69 8.0005
R1327 vbn.n102 vbn.n68 8.0005
R1328 vbn.n103 vbn.n65 8.0005
R1329 vbn.n104 vbn.n64 8.0005
R1330 vbn.n105 vbn.n61 8.0005
R1331 vbn.n106 vbn.n60 8.0005
R1332 vbn.n107 vbn.n57 8.0005
R1333 vbn.n108 vbn.n56 8.0005
R1334 vbn.n109 vbn.n55 8.0005
R1335 vbn.n110 vbn.n54 8.0005
R1336 vbn.n111 vbn.n53 8.0005
R1337 vbn.n112 vbn.n52 8.0005
R1338 vbn.n113 vbn.n51 8.0005
R1339 vbn.n114 vbn.n50 8.0005
R1340 vbn.n115 vbn.n49 8.0005
R1341 vbn.n116 vbn.n48 8.0005
R1342 vbn.n117 vbn.n47 8.0005
R1343 vbn.n118 vbn.n46 8.0005
R1344 vbn.n119 vbn.n45 8.0005
R1345 vbn.n120 vbn.n44 8.0005
R1346 vbn.n121 vbn.n43 8.0005
R1347 vbn.n122 vbn.n42 8.0005
R1348 vbn.n123 vbn.n41 8.0005
R1349 vbn.n124 vbn.n40 8.0005
R1350 vbn.n125 vbn.n39 8.0005
R1351 vbn.n126 vbn.n38 8.0005
R1352 vbn.n127 vbn.n37 8.0005
R1353 vbn.n128 vbn.n36 8.0005
R1354 vbn.n129 vbn.n35 8.0005
R1355 vbn.n130 vbn.n34 8.0005
R1356 vbn.n131 vbn.n33 8.0005
R1357 vbn.n132 vbn.n32 8.0005
R1358 vbn.n133 vbn.n31 8.0005
R1359 vbn.n134 vbn.n30 8.0005
R1360 vbn.n135 vbn.n29 8.0005
R1361 vbn.n136 vbn.n27 8.0005
R1362 vbn.n137 vbn.n26 8.0005
R1363 vbn.n138 vbn.n23 8.0005
R1364 vbn.n139 vbn.n22 8.0005
R1365 vbn.n140 vbn.n19 8.0005
R1366 vbn.n141 vbn.n18 8.0005
R1367 vbn.n142 vbn.n15 8.0005
R1368 vbn.n143 vbn.n14 8.0005
R1369 vbn.n144 vbn.n13 8.0005
R1370 vbn.n145 vbn.n12 8.0005
R1371 vbn.n146 vbn.n11 8.0005
R1372 vbn.n147 vbn.n10 8.0005
R1373 vbn.n148 vbn.n7 8.0005
R1374 vbn.n149 vbn.n6 8.0005
R1375 vbn.n150 vbn.n5 8.0005
R1376 vbn.n151 vbn.n4 8.0005
R1377 vbn.n152 vbn.n3 8.0005
R1378 vbn.n153 vbn.n2 8.0005
R1379 vbn.n154 vbn.n1 8.0005
R1380 vbn.n155 vbn.n0 8.0005
R1381 vbn.n157 vbn.n156 5.56684
R1382 vbn.n87 vbn.n86 5.56684
R1383 vbn.n158 vbn.t0 5.15158
R1384 vbn.n159 vbn.n158 4.69589
R1385 vbn.n70 vbn.t7 2.70867
R1386 vbn.n28 vbn.t21 2.70867
R1387 vbn.n67 vbn.n66 1.87392
R1388 vbn.n63 vbn.n62 1.87392
R1389 vbn.n59 vbn.n58 1.87392
R1390 vbn.n25 vbn.n24 1.87392
R1391 vbn.n21 vbn.n20 1.87392
R1392 vbn.n17 vbn.n16 1.87392
R1393 vbn.n158 vbn.n157 0.967396
R1394 vbn.n66 vbn.t11 0.8825
R1395 vbn.n66 vbn.t9 0.8825
R1396 vbn.n62 vbn.t15 0.8825
R1397 vbn.n62 vbn.t13 0.8825
R1398 vbn.n58 vbn.t19 0.8825
R1399 vbn.n58 vbn.t17 0.8825
R1400 vbn.n24 vbn.t25 0.8825
R1401 vbn.n24 vbn.t23 0.8825
R1402 vbn.n20 vbn.t29 0.8825
R1403 vbn.n20 vbn.t27 0.8825
R1404 vbn.n16 vbn.t33 0.8825
R1405 vbn.n16 vbn.t31 0.8825
R1406 vbn.n57 vbn.n56 0.73471
R1407 vbn.n15 vbn.n14 0.73471
R1408 vbn vbn.n159 0.656553
R1409 vbn.n71 vbn.n70 0.525799
R1410 vbn.n29 vbn.n28 0.525799
R1411 vbn.n86 vbn.n85 0.47793
R1412 vbn.n157 vbn.n0 0.47793
R1413 vbn.n72 vbn.n71 0.369974
R1414 vbn.n73 vbn.n72 0.369974
R1415 vbn.n74 vbn.n73 0.369974
R1416 vbn.n75 vbn.n74 0.369974
R1417 vbn.n79 vbn.n78 0.369974
R1418 vbn.n80 vbn.n79 0.369974
R1419 vbn.n81 vbn.n80 0.369974
R1420 vbn.n82 vbn.n81 0.369974
R1421 vbn.n83 vbn.n82 0.369974
R1422 vbn.n84 vbn.n83 0.369974
R1423 vbn.n85 vbn.n84 0.369974
R1424 vbn.n30 vbn.n29 0.369974
R1425 vbn.n31 vbn.n30 0.369974
R1426 vbn.n32 vbn.n31 0.369974
R1427 vbn.n33 vbn.n32 0.369974
R1428 vbn.n34 vbn.n33 0.369974
R1429 vbn.n35 vbn.n34 0.369974
R1430 vbn.n36 vbn.n35 0.369974
R1431 vbn.n37 vbn.n36 0.369974
R1432 vbn.n38 vbn.n37 0.369974
R1433 vbn.n39 vbn.n38 0.369974
R1434 vbn.n40 vbn.n39 0.369974
R1435 vbn.n41 vbn.n40 0.369974
R1436 vbn.n42 vbn.n41 0.369974
R1437 vbn.n43 vbn.n42 0.369974
R1438 vbn.n44 vbn.n43 0.369974
R1439 vbn.n45 vbn.n44 0.369974
R1440 vbn.n46 vbn.n45 0.369974
R1441 vbn.n47 vbn.n46 0.369974
R1442 vbn.n48 vbn.n47 0.369974
R1443 vbn.n49 vbn.n48 0.369974
R1444 vbn.n50 vbn.n49 0.369974
R1445 vbn.n51 vbn.n50 0.369974
R1446 vbn.n52 vbn.n51 0.369974
R1447 vbn.n53 vbn.n52 0.369974
R1448 vbn.n54 vbn.n53 0.369974
R1449 vbn.n55 vbn.n54 0.369974
R1450 vbn.n56 vbn.n55 0.369974
R1451 vbn.n1 vbn.n0 0.369974
R1452 vbn.n2 vbn.n1 0.369974
R1453 vbn.n3 vbn.n2 0.369974
R1454 vbn.n4 vbn.n3 0.369974
R1455 vbn.n5 vbn.n4 0.369974
R1456 vbn.n6 vbn.n5 0.369974
R1457 vbn.n7 vbn.n6 0.369974
R1458 vbn.n11 vbn.n10 0.369974
R1459 vbn.n12 vbn.n11 0.369974
R1460 vbn.n13 vbn.n12 0.369974
R1461 vbn.n14 vbn.n13 0.369974
R1462 vbn.n77 vbn.n75 0.194711
R1463 vbn.n10 vbn.n9 0.194711
R1464 vbn.n78 vbn.n77 0.175763
R1465 vbn.n9 vbn.n7 0.175763
R1466 vbn.n59 vbn.n57 0.15751
R1467 vbn.n17 vbn.n15 0.15751
R1468 vbn.n61 vbn.n60 0.142318
R1469 vbn.n65 vbn.n64 0.142318
R1470 vbn.n69 vbn.n68 0.142318
R1471 vbn.n19 vbn.n18 0.142318
R1472 vbn.n23 vbn.n22 0.142318
R1473 vbn.n27 vbn.n26 0.142318
R1474 vbn.n8 vbn.t2 0.1405
R1475 vbn.n8 vbn.t4 0.1405
R1476 vbn.n76 vbn.t5 0.1405
R1477 vbn.n76 vbn.t3 0.1405
R1478 vbn.n60 vbn.n59 0.0714091
R1479 vbn.n63 vbn.n61 0.0714091
R1480 vbn.n64 vbn.n63 0.0714091
R1481 vbn.n67 vbn.n65 0.0714091
R1482 vbn.n68 vbn.n67 0.0714091
R1483 vbn.n18 vbn.n17 0.0714091
R1484 vbn.n21 vbn.n19 0.0714091
R1485 vbn.n22 vbn.n21 0.0714091
R1486 vbn.n25 vbn.n23 0.0714091
R1487 vbn.n26 vbn.n25 0.0714091
R1488 vbn.n70 vbn.n69 0.0700455
R1489 vbn.n28 vbn.n27 0.0700455
R1490 VDD_LS.t9 VDD_LS.t20 754.851
R1491 VDD_LS.t14 VDD_LS.t24 691.359
R1492 VDD_LS.t20 VDD_LS.t26 604.938
R1493 VDD_LS.t5 VDD_LS.t0 578.484
R1494 VDD_LS.t18 VDD_LS.t22 559.083
R1495 VDD_LS.t22 VDD_LS.t9 446.209
R1496 VDD_LS.t13 VDD_LS.t18 410.935
R1497 VDD_LS.t11 VDD_LS.t14 410.935
R1498 VDD_LS.t24 VDD_LS.t4 410.935
R1499 VDD_LS.t2 VDD_LS.t5 410.935
R1500 VDD_LS.t16 VDD_LS.t11 148.149
R1501 VDD_LS.t4 VDD_LS.t7 148.149
R1502 VDD_LS.t7 VDD_LS.t2 148.149
R1503 VDD_LS.n19 VDD_LS.t16 112.876
R1504 VDD_LS.n19 VDD_LS.t13 35.2739
R1505 VDD_LS.n77 VDD_LS.n76 21.9053
R1506 VDD_LS.n103 VDD_LS.n102 21.9053
R1507 VDD_LS.n94 VDD_LS.n93 21.9053
R1508 VDD_LS.n114 VDD_LS.n45 21.9053
R1509 VDD_LS.n106 VDD_LS.n105 21.9053
R1510 VDD_LS.n86 VDD_LS.n64 19.7393
R1511 VDD_LS.n84 VDD_LS.n66 19.7393
R1512 VDD_LS.n129 VDD_LS.n128 19.7393
R1513 VDD_LS.n122 VDD_LS.n121 19.7393
R1514 VDD_LS.n71 VDD_LS.t31 17.9366
R1515 VDD_LS.n85 VDD_LS.t30 17.9366
R1516 VDD_LS.n60 VDD_LS.t29 17.9366
R1517 VDD_LS.n112 VDD_LS.t28 17.9366
R1518 VDD_LS.n41 VDD_LS.t27 17.9366
R1519 VDD_LS.n76 VDD_LS.n70 13.9053
R1520 VDD_LS.n71 VDD_LS.n70 13.9053
R1521 VDD_LS.n86 VDD_LS.n85 13.9053
R1522 VDD_LS.n85 VDD_LS.n84 13.9053
R1523 VDD_LS.n102 VDD_LS.n54 13.9053
R1524 VDD_LS.n60 VDD_LS.n54 13.9053
R1525 VDD_LS.n95 VDD_LS.n60 13.9053
R1526 VDD_LS.n95 VDD_LS.n94 13.9053
R1527 VDD_LS.n114 VDD_LS.n113 13.9053
R1528 VDD_LS.n113 VDD_LS.n112 13.9053
R1529 VDD_LS.n112 VDD_LS.n48 13.9053
R1530 VDD_LS.n105 VDD_LS.n48 13.9053
R1531 VDD_LS.n128 VDD_LS.n41 13.9053
R1532 VDD_LS.n121 VDD_LS.n41 13.9053
R1533 VDD_LS.n11 VDD_LS.t21 9.77177
R1534 VDD_LS.n121 VDD_LS.n44 8.0005
R1535 VDD_LS.n42 VDD_LS.n41 8.0005
R1536 VDD_LS.n128 VDD_LS.n127 8.0005
R1537 VDD_LS.n105 VDD_LS.n52 8.0005
R1538 VDD_LS.n50 VDD_LS.n48 8.0005
R1539 VDD_LS.n112 VDD_LS.n111 8.0005
R1540 VDD_LS.n113 VDD_LS.n47 8.0005
R1541 VDD_LS.n115 VDD_LS.n114 8.0005
R1542 VDD_LS.n94 VDD_LS.n59 8.0005
R1543 VDD_LS.n96 VDD_LS.n95 8.0005
R1544 VDD_LS.n60 VDD_LS.n58 8.0005
R1545 VDD_LS.n55 VDD_LS.n54 8.0005
R1546 VDD_LS.n102 VDD_LS.n101 8.0005
R1547 VDD_LS.n84 VDD_LS.n83 8.0005
R1548 VDD_LS.n85 VDD_LS.n65 8.0005
R1549 VDD_LS.n87 VDD_LS.n86 8.0005
R1550 VDD_LS.n76 VDD_LS.n75 8.0005
R1551 VDD_LS.n74 VDD_LS.n70 8.0005
R1552 VDD_LS.n73 VDD_LS.n71 5.68076
R1553 VDD_LS.n5 VDD_LS.t25 4.85686
R1554 VDD_LS.n130 VDD_LS.n129 4.67932
R1555 VDD_LS.n72 VDD_LS.n69 4.5005
R1556 VDD_LS.n78 VDD_LS.n68 4.5005
R1557 VDD_LS.n80 VDD_LS.n79 4.5005
R1558 VDD_LS.n82 VDD_LS.n81 4.5005
R1559 VDD_LS.n67 VDD_LS.n63 4.5005
R1560 VDD_LS.n89 VDD_LS.n88 4.5005
R1561 VDD_LS.n90 VDD_LS.n62 4.5005
R1562 VDD_LS.n92 VDD_LS.n91 4.5005
R1563 VDD_LS.n61 VDD_LS.n57 4.5005
R1564 VDD_LS.n98 VDD_LS.n97 4.5005
R1565 VDD_LS.n100 VDD_LS.n99 4.5005
R1566 VDD_LS.n56 VDD_LS.n53 4.5005
R1567 VDD_LS.n104 VDD_LS.n51 4.5005
R1568 VDD_LS.n108 VDD_LS.n107 4.5005
R1569 VDD_LS.n110 VDD_LS.n109 4.5005
R1570 VDD_LS.n49 VDD_LS.n46 4.5005
R1571 VDD_LS.n117 VDD_LS.n116 4.5005
R1572 VDD_LS.n119 VDD_LS.n118 4.5005
R1573 VDD_LS.n120 VDD_LS.n43 4.5005
R1574 VDD_LS.n124 VDD_LS.n123 4.5005
R1575 VDD_LS.n126 VDD_LS.n125 4.5005
R1576 VDD_LS.n40 VDD_LS.n0 4.5005
R1577 VDD_LS.n2 VDD_LS.t6 3.6455
R1578 VDD_LS.n25 VDD_LS.t15 3.6455
R1579 VDD_LS.n12 VDD_LS.t10 3.6455
R1580 VDD_LS.n32 VDD_LS.n4 3.31103
R1581 VDD_LS.n17 VDD_LS.t19 2.84379
R1582 VDD_LS VDD_LS.n130 2.61817
R1583 VDD_LS.n38 VDD_LS.t1 2.33908
R1584 VDD_LS.n10 VDD_LS.t23 1.98287
R1585 VDD_LS.n8 VDD_LS.n7 1.91629
R1586 VDD_LS.n4 VDD_LS.t8 1.63383
R1587 VDD_LS.n4 VDD_LS.t3 1.63383
R1588 VDD_LS.n73 VDD_LS.n72 1.62016
R1589 VDD_LS.n39 VDD_LS.n38 1.51494
R1590 VDD_LS.n14 VDD_LS.n13 1.5005
R1591 VDD_LS.n16 VDD_LS.n15 1.5005
R1592 VDD_LS.n18 VDD_LS.n9 1.5005
R1593 VDD_LS.n22 VDD_LS.n21 1.5005
R1594 VDD_LS.n24 VDD_LS.n23 1.5005
R1595 VDD_LS.n26 VDD_LS.n6 1.5005
R1596 VDD_LS.n28 VDD_LS.n27 1.5005
R1597 VDD_LS.n30 VDD_LS.n29 1.5005
R1598 VDD_LS.n31 VDD_LS.n3 1.5005
R1599 VDD_LS.n34 VDD_LS.n33 1.5005
R1600 VDD_LS.n36 VDD_LS.n35 1.5005
R1601 VDD_LS.n37 VDD_LS.n1 1.5005
R1602 VDD_LS.n7 VDD_LS.t17 0.9805
R1603 VDD_LS.n7 VDD_LS.t12 0.9805
R1604 VDD_LS.n130 VDD_LS.n39 0.719
R1605 VDD_LS.n14 VDD_LS.n11 0.386165
R1606 VDD_LS.n120 VDD_LS.n119 0.2255
R1607 VDD_LS.n92 VDD_LS.n62 0.2255
R1608 VDD_LS.n79 VDD_LS.n78 0.2255
R1609 VDD_LS.n125 VDD_LS.n0 0.2255
R1610 VDD_LS.n125 VDD_LS.n124 0.2255
R1611 VDD_LS.n124 VDD_LS.n43 0.2255
R1612 VDD_LS.n118 VDD_LS.n43 0.2255
R1613 VDD_LS.n118 VDD_LS.n117 0.2255
R1614 VDD_LS.n117 VDD_LS.n46 0.2255
R1615 VDD_LS.n109 VDD_LS.n46 0.2255
R1616 VDD_LS.n109 VDD_LS.n108 0.2255
R1617 VDD_LS.n108 VDD_LS.n51 0.2255
R1618 VDD_LS.n56 VDD_LS.n51 0.2255
R1619 VDD_LS.n99 VDD_LS.n56 0.2255
R1620 VDD_LS.n99 VDD_LS.n98 0.2255
R1621 VDD_LS.n98 VDD_LS.n57 0.2255
R1622 VDD_LS.n91 VDD_LS.n57 0.2255
R1623 VDD_LS.n91 VDD_LS.n90 0.2255
R1624 VDD_LS.n90 VDD_LS.n89 0.2255
R1625 VDD_LS.n89 VDD_LS.n63 0.2255
R1626 VDD_LS.n81 VDD_LS.n63 0.2255
R1627 VDD_LS.n81 VDD_LS.n80 0.2255
R1628 VDD_LS.n80 VDD_LS.n68 0.2255
R1629 VDD_LS.n72 VDD_LS.n68 0.2255
R1630 VDD_LS.n130 VDD_LS.n0 0.21875
R1631 VDD_LS.n104 VDD_LS.n103 0.206375
R1632 VDD_LS.n106 VDD_LS.n104 0.172625
R1633 VDD_LS.n20 VDD_LS.n19 0.162038
R1634 VDD_LS.n74 VDD_LS.n73 0.148883
R1635 VDD_LS.n79 VDD_LS.n66 0.145566
R1636 VDD_LS.n119 VDD_LS.n45 0.143375
R1637 VDD_LS.n64 VDD_LS.n62 0.143316
R1638 VDD_LS.n44 VDD_LS.n42 0.1355
R1639 VDD_LS.n115 VDD_LS.n47 0.1355
R1640 VDD_LS.n52 VDD_LS.n50 0.1355
R1641 VDD_LS.n58 VDD_LS.n55 0.1355
R1642 VDD_LS.n96 VDD_LS.n59 0.1355
R1643 VDD_LS.n87 VDD_LS.n65 0.1355
R1644 VDD_LS.n75 VDD_LS.n74 0.1355
R1645 VDD_LS.n83 VDD_LS.n67 0.134375
R1646 VDD_LS.n111 VDD_LS.n110 0.127625
R1647 VDD_LS.n127 VDD_LS.n40 0.125375
R1648 VDD_LS.n77 VDD_LS.n69 0.118625
R1649 VDD_LS.n123 VDD_LS.n122 0.116827
R1650 VDD_LS.n101 VDD_LS.n53 0.116375
R1651 VDD_LS.n93 VDD_LS.n61 0.116375
R1652 VDD_LS.n12 VDD_LS.n11 0.109999
R1653 VDD_LS.n101 VDD_LS.n100 0.109625
R1654 VDD_LS.n93 VDD_LS.n92 0.109625
R1655 VDD_LS.n122 VDD_LS.n120 0.109566
R1656 VDD_LS.n78 VDD_LS.n77 0.107375
R1657 VDD_LS.n127 VDD_LS.n126 0.100625
R1658 VDD_LS.n111 VDD_LS.n49 0.098375
R1659 VDD_LS.n83 VDD_LS.n82 0.091625
R1660 VDD_LS.n88 VDD_LS.n87 0.089375
R1661 VDD_LS.n88 VDD_LS.n64 0.0830773
R1662 VDD_LS.n116 VDD_LS.n45 0.082625
R1663 VDD_LS.n107 VDD_LS.n52 0.082625
R1664 VDD_LS.n82 VDD_LS.n66 0.0808273
R1665 VDD_LS.n27 VDD_LS.n26 0.0755
R1666 VDD_LS.n31 VDD_LS.n30 0.0755
R1667 VDD_LS.n37 VDD_LS.n36 0.0755
R1668 VDD_LS.n15 VDD_LS.n14 0.0755
R1669 VDD_LS.n15 VDD_LS.n9 0.0755
R1670 VDD_LS.n22 VDD_LS.n9 0.0755
R1671 VDD_LS.n23 VDD_LS.n22 0.0755
R1672 VDD_LS.n23 VDD_LS.n6 0.0755
R1673 VDD_LS.n28 VDD_LS.n6 0.0755
R1674 VDD_LS.n29 VDD_LS.n28 0.0755
R1675 VDD_LS.n29 VDD_LS.n3 0.0755
R1676 VDD_LS.n34 VDD_LS.n3 0.0755
R1677 VDD_LS.n35 VDD_LS.n34 0.0755
R1678 VDD_LS.n35 VDD_LS.n1 0.0755
R1679 VDD_LS.n39 VDD_LS.n1 0.0755
R1680 VDD_LS.n27 VDD_LS.n5 0.0753125
R1681 VDD_LS.n13 VDD_LS.n12 0.0741875
R1682 VDD_LS.n97 VDD_LS.n96 0.071375
R1683 VDD_LS.n20 VDD_LS.n18 0.07025
R1684 VDD_LS.n17 VDD_LS.n16 0.0655625
R1685 VDD_LS.n97 VDD_LS.n58 0.064625
R1686 VDD_LS.n38 VDD_LS.n37 0.0610625
R1687 VDD_LS.n33 VDD_LS.n2 0.0576875
R1688 VDD_LS.n123 VDD_LS.n44 0.055625
R1689 VDD_LS.n16 VDD_LS.n10 0.0543125
R1690 VDD_LS.n116 VDD_LS.n115 0.053375
R1691 VDD_LS.n107 VDD_LS.n106 0.053375
R1692 VDD_LS.n25 VDD_LS.n24 0.0479375
R1693 VDD_LS.n129 VDD_LS.n40 0.0470773
R1694 VDD_LS.n32 VDD_LS.n31 0.04475
R1695 VDD_LS.n24 VDD_LS.n8 0.041
R1696 VDD_LS.n49 VDD_LS.n47 0.037625
R1697 VDD_LS.n126 VDD_LS.n42 0.035375
R1698 VDD_LS.n21 VDD_LS.n8 0.035
R1699 VDD_LS.n33 VDD_LS.n32 0.03125
R1700 VDD_LS.n26 VDD_LS.n25 0.0280625
R1701 VDD_LS.n100 VDD_LS.n55 0.026375
R1702 VDD_LS.n13 VDD_LS.n10 0.0216875
R1703 VDD_LS.n103 VDD_LS.n53 0.019625
R1704 VDD_LS.n61 VDD_LS.n59 0.019625
R1705 VDD_LS.n36 VDD_LS.n2 0.0183125
R1706 VDD_LS.n75 VDD_LS.n69 0.017375
R1707 VDD_LS.n18 VDD_LS.n17 0.0104375
R1708 VDD_LS.n110 VDD_LS.n50 0.008375
R1709 VDD_LS.n21 VDD_LS.n20 0.00575
R1710 VDD_LS.n67 VDD_LS.n65 0.001625
R1711 VDD_LS.n30 VDD_LS.n5 0.0006875
R1712 VDD.n297 VDD.t7 1270.39
R1713 VDD.n295 VDD.n267 927.096
R1714 VDD.t21 VDD.t23 877.638
R1715 VDD.t19 VDD.t21 877.638
R1716 VDD.t17 VDD.t19 877.638
R1717 VDD.t15 VDD.t13 877.638
R1718 VDD.t13 VDD.t11 877.638
R1719 VDD.t11 VDD.t9 877.638
R1720 VDD.n297 VDD.t6 848.045
R1721 VDD.t23 VDD.t30 608.198
R1722 VDD.n159 VDD.t15 525.919
R1723 VDD.t4 VDD.t27 413.409
R1724 VDD.t27 VDD.t32 413.409
R1725 VDD.t32 VDD.t5 413.409
R1726 VDD.t5 VDD.t6 413.409
R1727 VDD.n298 VDD.n264 402.039
R1728 VDD.n298 VDD.n265 402.039
R1729 VDD.n159 VDD.t17 351.719
R1730 VDD.t0 VDD.t28 335.197
R1731 VDD.t25 VDD.t0 324.022
R1732 VDD.t7 VDD.t2 290.503
R1733 VDD.t2 VDD.t25 290.503
R1734 VDD.n266 VDD.t4 207.821
R1735 VDD.t28 VDD.n296 198.883
R1736 VDD.n81 VDD.t31 9.75958
R1737 VDD.n296 VDD.n265 6.3005
R1738 VDD.n266 VDD.n264 6.3005
R1739 VDD.n294 VDD.n265 5.69302
R1740 VDD.n264 VDD.n256 5.69302
R1741 VDD.n328 VDD.n254 4.5005
R1742 VDD.n254 VDD.n251 4.5005
R1743 VDD.n326 VDD.n251 4.5005
R1744 VDD.n330 VDD.n251 4.5005
R1745 VDD.n333 VDD.n251 4.5005
R1746 VDD.n330 VDD.n249 4.5005
R1747 VDD.n333 VDD.n249 4.5005
R1748 VDD.n254 VDD.n252 4.5005
R1749 VDD.n321 VDD.n252 4.5005
R1750 VDD.n330 VDD.n252 4.5005
R1751 VDD.n333 VDD.n252 4.5005
R1752 VDD.n254 VDD.n248 4.5005
R1753 VDD.n321 VDD.n248 4.5005
R1754 VDD.n330 VDD.n248 4.5005
R1755 VDD.n333 VDD.n248 4.5005
R1756 VDD.n332 VDD.n254 4.5005
R1757 VDD.n332 VDD.n321 4.5005
R1758 VDD.n333 VDD.n332 4.5005
R1759 VDD.n327 VDD.n321 2.24729
R1760 VDD.n324 VDD.n323 2.24729
R1761 VDD.n326 VDD.n325 2.24729
R1762 VDD.n324 VDD.n322 2.24729
R1763 VDD.n326 VDD.n253 2.24729
R1764 VDD.n332 VDD.n331 2.24721
R1765 VDD.n329 VDD.n328 2.24721
R1766 VDD.n328 VDD.n250 2.24721
R1767 VDD.n320 VDD.n249 2.24721
R1768 VDD VDD.n247 2.22073
R1769 VDD.n245 VDD.t10 2.10633
R1770 VDD.n85 VDD.t24 2.10633
R1771 VDD.n19 VDD.n18 1.97383
R1772 VDD.n40 VDD.n39 1.97383
R1773 VDD.n126 VDD.n60 1.97383
R1774 VDD.n268 VDD.t29 1.71571
R1775 VDD.n289 VDD.t1 1.71571
R1776 VDD.n270 VDD.t26 1.71571
R1777 VDD.n284 VDD.t3 1.71571
R1778 VDD.n282 VDD.t8 1.71571
R1779 VDD.n246 VDD.n245 1.54681
R1780 VDD.n292 VDD.n291 1.5005
R1781 VDD.n290 VDD.n269 1.5005
R1782 VDD.n288 VDD.n287 1.5005
R1783 VDD.n286 VDD.n285 1.5005
R1784 VDD.n283 VDD.n271 1.5005
R1785 VDD.n281 VDD.n280 1.5005
R1786 VDD.n279 VDD.n272 1.5005
R1787 VDD.n278 VDD.n277 1.5005
R1788 VDD.n276 VDD.n273 1.5005
R1789 VDD.n275 VDD.n274 1.5005
R1790 VDD.n263 VDD.n262 1.5005
R1791 VDD.n301 VDD.n300 1.5005
R1792 VDD.n302 VDD.n261 1.5005
R1793 VDD.n304 VDD.n303 1.5005
R1794 VDD.n305 VDD.n260 1.5005
R1795 VDD.n307 VDD.n306 1.5005
R1796 VDD.n308 VDD.n259 1.5005
R1797 VDD.n310 VDD.n309 1.5005
R1798 VDD.n311 VDD.n258 1.5005
R1799 VDD.n313 VDD.n312 1.5005
R1800 VDD.n314 VDD.n257 1.5005
R1801 VDD.n316 VDD.n315 1.5005
R1802 VDD.n317 VDD.n255 1.5005
R1803 VDD.n244 VDD.n1 1.5005
R1804 VDD.n243 VDD.n242 1.5005
R1805 VDD.n3 VDD.n2 1.5005
R1806 VDD.n236 VDD.n235 1.5005
R1807 VDD.n234 VDD.n233 1.5005
R1808 VDD.n7 VDD.n6 1.5005
R1809 VDD.n228 VDD.n227 1.5005
R1810 VDD.n226 VDD.n225 1.5005
R1811 VDD.n11 VDD.n10 1.5005
R1812 VDD.n220 VDD.n219 1.5005
R1813 VDD.n218 VDD.n217 1.5005
R1814 VDD.n15 VDD.n14 1.5005
R1815 VDD.n212 VDD.n211 1.5005
R1816 VDD.n210 VDD.n209 1.5005
R1817 VDD.n202 VDD.n20 1.5005
R1818 VDD.n204 VDD.n203 1.5005
R1819 VDD.n201 VDD.n200 1.5005
R1820 VDD.n24 VDD.n23 1.5005
R1821 VDD.n195 VDD.n194 1.5005
R1822 VDD.n193 VDD.n192 1.5005
R1823 VDD.n28 VDD.n27 1.5005
R1824 VDD.n187 VDD.n186 1.5005
R1825 VDD.n185 VDD.n184 1.5005
R1826 VDD.n32 VDD.n31 1.5005
R1827 VDD.n179 VDD.n178 1.5005
R1828 VDD.n177 VDD.n176 1.5005
R1829 VDD.n36 VDD.n35 1.5005
R1830 VDD.n171 VDD.n170 1.5005
R1831 VDD.n169 VDD.n168 1.5005
R1832 VDD.n161 VDD.n41 1.5005
R1833 VDD.n163 VDD.n162 1.5005
R1834 VDD.n158 VDD.n157 1.5005
R1835 VDD.n45 VDD.n44 1.5005
R1836 VDD.n152 VDD.n151 1.5005
R1837 VDD.n150 VDD.n149 1.5005
R1838 VDD.n49 VDD.n48 1.5005
R1839 VDD.n144 VDD.n143 1.5005
R1840 VDD.n142 VDD.n141 1.5005
R1841 VDD.n53 VDD.n52 1.5005
R1842 VDD.n136 VDD.n135 1.5005
R1843 VDD.n134 VDD.n133 1.5005
R1844 VDD.n57 VDD.n56 1.5005
R1845 VDD.n128 VDD.n127 1.5005
R1846 VDD.n125 VDD.n124 1.5005
R1847 VDD.n62 VDD.n61 1.5005
R1848 VDD.n119 VDD.n118 1.5005
R1849 VDD.n117 VDD.n116 1.5005
R1850 VDD.n66 VDD.n65 1.5005
R1851 VDD.n111 VDD.n110 1.5005
R1852 VDD.n109 VDD.n108 1.5005
R1853 VDD.n70 VDD.n69 1.5005
R1854 VDD.n103 VDD.n102 1.5005
R1855 VDD.n101 VDD.n100 1.5005
R1856 VDD.n74 VDD.n73 1.5005
R1857 VDD.n95 VDD.n94 1.5005
R1858 VDD.n93 VDD.n92 1.5005
R1859 VDD.n78 VDD.n77 1.5005
R1860 VDD.n87 VDD.n86 1.5005
R1861 VDD.n84 VDD.n83 1.5005
R1862 VDD.n247 VDD.n246 1.1255
R1863 VDD.n241 VDD.n0 1.1255
R1864 VDD.n240 VDD.n239 1.1255
R1865 VDD.n238 VDD.n237 1.1255
R1866 VDD.n5 VDD.n4 1.1255
R1867 VDD.n232 VDD.n231 1.1255
R1868 VDD.n230 VDD.n229 1.1255
R1869 VDD.n9 VDD.n8 1.1255
R1870 VDD.n224 VDD.n223 1.1255
R1871 VDD.n222 VDD.n221 1.1255
R1872 VDD.n13 VDD.n12 1.1255
R1873 VDD.n216 VDD.n215 1.1255
R1874 VDD.n214 VDD.n213 1.1255
R1875 VDD.n17 VDD.n16 1.1255
R1876 VDD.n208 VDD.n207 1.1255
R1877 VDD.n206 VDD.n205 1.1255
R1878 VDD.n22 VDD.n21 1.1255
R1879 VDD.n199 VDD.n198 1.1255
R1880 VDD.n197 VDD.n196 1.1255
R1881 VDD.n26 VDD.n25 1.1255
R1882 VDD.n191 VDD.n190 1.1255
R1883 VDD.n189 VDD.n188 1.1255
R1884 VDD.n30 VDD.n29 1.1255
R1885 VDD.n183 VDD.n182 1.1255
R1886 VDD.n181 VDD.n180 1.1255
R1887 VDD.n34 VDD.n33 1.1255
R1888 VDD.n175 VDD.n174 1.1255
R1889 VDD.n173 VDD.n172 1.1255
R1890 VDD.n38 VDD.n37 1.1255
R1891 VDD.n167 VDD.n166 1.1255
R1892 VDD.n165 VDD.n164 1.1255
R1893 VDD.n43 VDD.n42 1.1255
R1894 VDD.n156 VDD.n155 1.1255
R1895 VDD.n154 VDD.n153 1.1255
R1896 VDD.n47 VDD.n46 1.1255
R1897 VDD.n148 VDD.n147 1.1255
R1898 VDD.n146 VDD.n145 1.1255
R1899 VDD.n51 VDD.n50 1.1255
R1900 VDD.n140 VDD.n139 1.1255
R1901 VDD.n138 VDD.n137 1.1255
R1902 VDD.n55 VDD.n54 1.1255
R1903 VDD.n132 VDD.n131 1.1255
R1904 VDD.n130 VDD.n129 1.1255
R1905 VDD.n59 VDD.n58 1.1255
R1906 VDD.n123 VDD.n122 1.1255
R1907 VDD.n121 VDD.n120 1.1255
R1908 VDD.n64 VDD.n63 1.1255
R1909 VDD.n115 VDD.n114 1.1255
R1910 VDD.n113 VDD.n112 1.1255
R1911 VDD.n68 VDD.n67 1.1255
R1912 VDD.n107 VDD.n106 1.1255
R1913 VDD.n105 VDD.n104 1.1255
R1914 VDD.n72 VDD.n71 1.1255
R1915 VDD.n99 VDD.n98 1.1255
R1916 VDD.n97 VDD.n96 1.1255
R1917 VDD.n76 VDD.n75 1.1255
R1918 VDD.n91 VDD.n90 1.1255
R1919 VDD.n89 VDD.n88 1.1255
R1920 VDD.n80 VDD.n79 1.1255
R1921 VDD.n267 VDD.n256 0.996766
R1922 VDD.n295 VDD.n294 0.996766
R1923 VDD.n293 VDD.n292 0.841357
R1924 VDD.n82 VDD.n81 0.815776
R1925 VDD.n82 VDD.n79 0.611805
R1926 VDD VDD.n333 0.590155
R1927 VDD.n332 VDD.n319 0.548056
R1928 VDD.n267 VDD.n266 0.371088
R1929 VDD.n296 VDD.n295 0.371088
R1930 VDD.n319 VDD.n318 0.280828
R1931 VDD.n319 VDD.n255 0.226094
R1932 VDD.n18 VDD.t14 0.1405
R1933 VDD.n18 VDD.t12 0.1405
R1934 VDD.n39 VDD.t18 0.1405
R1935 VDD.n39 VDD.t16 0.1405
R1936 VDD.n60 VDD.t22 0.1405
R1937 VDD.n60 VDD.t20 0.1405
R1938 VDD.n294 VDD.n293 0.113837
R1939 VDD.n318 VDD.n256 0.0915242
R1940 VDD.n315 VDD.n255 0.0755
R1941 VDD.n315 VDD.n314 0.0755
R1942 VDD.n314 VDD.n313 0.0755
R1943 VDD.n313 VDD.n258 0.0755
R1944 VDD.n309 VDD.n258 0.0755
R1945 VDD.n309 VDD.n308 0.0755
R1946 VDD.n308 VDD.n307 0.0755
R1947 VDD.n307 VDD.n260 0.0755
R1948 VDD.n303 VDD.n260 0.0755
R1949 VDD.n303 VDD.n302 0.0755
R1950 VDD.n302 VDD.n301 0.0755
R1951 VDD.n301 VDD.n262 0.0755
R1952 VDD.n274 VDD.n262 0.0755
R1953 VDD.n274 VDD.n273 0.0755
R1954 VDD.n278 VDD.n273 0.0755
R1955 VDD.n279 VDD.n278 0.0755
R1956 VDD.n280 VDD.n279 0.0755
R1957 VDD.n280 VDD.n271 0.0755
R1958 VDD.n286 VDD.n271 0.0755
R1959 VDD.n287 VDD.n286 0.0755
R1960 VDD.n287 VDD.n269 0.0755
R1961 VDD.n292 VDD.n269 0.0755
R1962 VDD.n317 VDD.n316 0.0755
R1963 VDD.n316 VDD.n257 0.0755
R1964 VDD.n312 VDD.n257 0.0755
R1965 VDD.n312 VDD.n311 0.0755
R1966 VDD.n311 VDD.n310 0.0755
R1967 VDD.n310 VDD.n259 0.0755
R1968 VDD.n306 VDD.n259 0.0755
R1969 VDD.n306 VDD.n305 0.0755
R1970 VDD.n305 VDD.n304 0.0755
R1971 VDD.n304 VDD.n261 0.0755
R1972 VDD.n300 VDD.n261 0.0755
R1973 VDD.n275 VDD.n263 0.0755
R1974 VDD.n276 VDD.n275 0.0755
R1975 VDD.n277 VDD.n276 0.0755
R1976 VDD.n277 VDD.n272 0.0755
R1977 VDD.n281 VDD.n272 0.0755
R1978 VDD.n291 VDD.n290 0.0755
R1979 VDD.n86 VDD.n77 0.0755
R1980 VDD.n93 VDD.n77 0.0755
R1981 VDD.n94 VDD.n93 0.0755
R1982 VDD.n94 VDD.n73 0.0755
R1983 VDD.n101 VDD.n73 0.0755
R1984 VDD.n102 VDD.n101 0.0755
R1985 VDD.n102 VDD.n69 0.0755
R1986 VDD.n109 VDD.n69 0.0755
R1987 VDD.n110 VDD.n109 0.0755
R1988 VDD.n110 VDD.n65 0.0755
R1989 VDD.n117 VDD.n65 0.0755
R1990 VDD.n118 VDD.n117 0.0755
R1991 VDD.n118 VDD.n61 0.0755
R1992 VDD.n125 VDD.n61 0.0755
R1993 VDD.n127 VDD.n56 0.0755
R1994 VDD.n134 VDD.n56 0.0755
R1995 VDD.n135 VDD.n134 0.0755
R1996 VDD.n135 VDD.n52 0.0755
R1997 VDD.n142 VDD.n52 0.0755
R1998 VDD.n143 VDD.n142 0.0755
R1999 VDD.n143 VDD.n48 0.0755
R2000 VDD.n150 VDD.n48 0.0755
R2001 VDD.n151 VDD.n150 0.0755
R2002 VDD.n151 VDD.n44 0.0755
R2003 VDD.n158 VDD.n44 0.0755
R2004 VDD.n162 VDD.n158 0.0755
R2005 VDD.n162 VDD.n161 0.0755
R2006 VDD.n170 VDD.n169 0.0755
R2007 VDD.n170 VDD.n35 0.0755
R2008 VDD.n177 VDD.n35 0.0755
R2009 VDD.n178 VDD.n177 0.0755
R2010 VDD.n178 VDD.n31 0.0755
R2011 VDD.n185 VDD.n31 0.0755
R2012 VDD.n186 VDD.n185 0.0755
R2013 VDD.n186 VDD.n27 0.0755
R2014 VDD.n193 VDD.n27 0.0755
R2015 VDD.n194 VDD.n193 0.0755
R2016 VDD.n194 VDD.n23 0.0755
R2017 VDD.n201 VDD.n23 0.0755
R2018 VDD.n203 VDD.n201 0.0755
R2019 VDD.n203 VDD.n202 0.0755
R2020 VDD.n211 VDD.n210 0.0755
R2021 VDD.n211 VDD.n14 0.0755
R2022 VDD.n218 VDD.n14 0.0755
R2023 VDD.n219 VDD.n218 0.0755
R2024 VDD.n219 VDD.n10 0.0755
R2025 VDD.n226 VDD.n10 0.0755
R2026 VDD.n227 VDD.n226 0.0755
R2027 VDD.n227 VDD.n6 0.0755
R2028 VDD.n234 VDD.n6 0.0755
R2029 VDD.n235 VDD.n234 0.0755
R2030 VDD.n235 VDD.n2 0.0755
R2031 VDD.n243 VDD.n2 0.0755
R2032 VDD.n244 VDD.n243 0.0755
R2033 VDD.n289 VDD.n288 0.0738125
R2034 VDD.n285 VDD.n270 0.0704375
R2035 VDD.n291 VDD.n268 0.0666875
R2036 VDD.n245 VDD.n244 0.0666875
R2037 VDD.n83 VDD.n82 0.0649974
R2038 VDD.n299 VDD.n298 0.0622647
R2039 VDD.n298 VDD.n297 0.0622647
R2040 VDD.n127 VDD.n126 0.05975
R2041 VDD.n84 VDD.n81 0.057125
R2042 VDD.n160 VDD.n40 0.0546875
R2043 VDD.n318 VDD.n317 0.0515
R2044 VDD.n210 VDD.n19 0.05075
R2045 VDD.n283 VDD.n282 0.0505625
R2046 VDD.n85 VDD.n84 0.0498125
R2047 VDD.n160 VDD.n159 0.0497188
R2048 VDD.n284 VDD.n283 0.0479375
R2049 VDD.n89 VDD.n79 0.046477
R2050 VDD.n90 VDD.n89 0.046477
R2051 VDD.n90 VDD.n75 0.046477
R2052 VDD.n97 VDD.n75 0.046477
R2053 VDD.n98 VDD.n97 0.046477
R2054 VDD.n98 VDD.n71 0.046477
R2055 VDD.n105 VDD.n71 0.046477
R2056 VDD.n106 VDD.n105 0.046477
R2057 VDD.n106 VDD.n67 0.046477
R2058 VDD.n113 VDD.n67 0.046477
R2059 VDD.n114 VDD.n113 0.046477
R2060 VDD.n114 VDD.n63 0.046477
R2061 VDD.n121 VDD.n63 0.046477
R2062 VDD.n122 VDD.n121 0.046477
R2063 VDD.n122 VDD.n58 0.046477
R2064 VDD.n130 VDD.n58 0.046477
R2065 VDD.n131 VDD.n130 0.046477
R2066 VDD.n131 VDD.n54 0.046477
R2067 VDD.n138 VDD.n54 0.046477
R2068 VDD.n139 VDD.n138 0.046477
R2069 VDD.n139 VDD.n50 0.046477
R2070 VDD.n146 VDD.n50 0.046477
R2071 VDD.n147 VDD.n146 0.046477
R2072 VDD.n147 VDD.n46 0.046477
R2073 VDD.n154 VDD.n46 0.046477
R2074 VDD.n155 VDD.n154 0.046477
R2075 VDD.n155 VDD.n42 0.046477
R2076 VDD.n165 VDD.n42 0.046477
R2077 VDD.n166 VDD.n165 0.046477
R2078 VDD.n166 VDD.n37 0.046477
R2079 VDD.n173 VDD.n37 0.046477
R2080 VDD.n174 VDD.n173 0.046477
R2081 VDD.n174 VDD.n33 0.046477
R2082 VDD.n181 VDD.n33 0.046477
R2083 VDD.n182 VDD.n181 0.046477
R2084 VDD.n182 VDD.n29 0.046477
R2085 VDD.n189 VDD.n29 0.046477
R2086 VDD.n190 VDD.n189 0.046477
R2087 VDD.n190 VDD.n25 0.046477
R2088 VDD.n197 VDD.n25 0.046477
R2089 VDD.n198 VDD.n197 0.046477
R2090 VDD.n198 VDD.n21 0.046477
R2091 VDD.n206 VDD.n21 0.046477
R2092 VDD.n207 VDD.n206 0.046477
R2093 VDD.n207 VDD.n16 0.046477
R2094 VDD.n214 VDD.n16 0.046477
R2095 VDD.n215 VDD.n214 0.046477
R2096 VDD.n215 VDD.n12 0.046477
R2097 VDD.n222 VDD.n12 0.046477
R2098 VDD.n223 VDD.n222 0.046477
R2099 VDD.n223 VDD.n8 0.046477
R2100 VDD.n230 VDD.n8 0.046477
R2101 VDD.n231 VDD.n230 0.046477
R2102 VDD.n231 VDD.n4 0.046477
R2103 VDD.n238 VDD.n4 0.046477
R2104 VDD.n239 VDD.n238 0.046477
R2105 VDD.n239 VDD.n0 0.046477
R2106 VDD.n247 VDD.n0 0.046477
R2107 VDD.n299 VDD.n263 0.042125
R2108 VDD.n83 VDD.n80 0.038
R2109 VDD.n87 VDD.n80 0.038
R2110 VDD.n88 VDD.n87 0.038
R2111 VDD.n88 VDD.n78 0.038
R2112 VDD.n91 VDD.n78 0.038
R2113 VDD.n92 VDD.n91 0.038
R2114 VDD.n92 VDD.n76 0.038
R2115 VDD.n95 VDD.n76 0.038
R2116 VDD.n96 VDD.n95 0.038
R2117 VDD.n96 VDD.n74 0.038
R2118 VDD.n99 VDD.n74 0.038
R2119 VDD.n100 VDD.n99 0.038
R2120 VDD.n100 VDD.n72 0.038
R2121 VDD.n103 VDD.n72 0.038
R2122 VDD.n104 VDD.n103 0.038
R2123 VDD.n104 VDD.n70 0.038
R2124 VDD.n107 VDD.n70 0.038
R2125 VDD.n108 VDD.n107 0.038
R2126 VDD.n108 VDD.n68 0.038
R2127 VDD.n111 VDD.n68 0.038
R2128 VDD.n112 VDD.n111 0.038
R2129 VDD.n112 VDD.n66 0.038
R2130 VDD.n115 VDD.n66 0.038
R2131 VDD.n116 VDD.n115 0.038
R2132 VDD.n116 VDD.n64 0.038
R2133 VDD.n119 VDD.n64 0.038
R2134 VDD.n120 VDD.n119 0.038
R2135 VDD.n120 VDD.n62 0.038
R2136 VDD.n123 VDD.n62 0.038
R2137 VDD.n124 VDD.n123 0.038
R2138 VDD.n124 VDD.n59 0.038
R2139 VDD.n128 VDD.n59 0.038
R2140 VDD.n129 VDD.n128 0.038
R2141 VDD.n129 VDD.n57 0.038
R2142 VDD.n132 VDD.n57 0.038
R2143 VDD.n133 VDD.n132 0.038
R2144 VDD.n133 VDD.n55 0.038
R2145 VDD.n136 VDD.n55 0.038
R2146 VDD.n137 VDD.n136 0.038
R2147 VDD.n137 VDD.n53 0.038
R2148 VDD.n140 VDD.n53 0.038
R2149 VDD.n141 VDD.n140 0.038
R2150 VDD.n141 VDD.n51 0.038
R2151 VDD.n144 VDD.n51 0.038
R2152 VDD.n145 VDD.n144 0.038
R2153 VDD.n145 VDD.n49 0.038
R2154 VDD.n148 VDD.n49 0.038
R2155 VDD.n149 VDD.n148 0.038
R2156 VDD.n149 VDD.n47 0.038
R2157 VDD.n152 VDD.n47 0.038
R2158 VDD.n153 VDD.n152 0.038
R2159 VDD.n153 VDD.n45 0.038
R2160 VDD.n156 VDD.n45 0.038
R2161 VDD.n157 VDD.n156 0.038
R2162 VDD.n157 VDD.n43 0.038
R2163 VDD.n163 VDD.n43 0.038
R2164 VDD.n164 VDD.n163 0.038
R2165 VDD.n164 VDD.n41 0.038
R2166 VDD.n167 VDD.n41 0.038
R2167 VDD.n168 VDD.n167 0.038
R2168 VDD.n168 VDD.n38 0.038
R2169 VDD.n171 VDD.n38 0.038
R2170 VDD.n172 VDD.n171 0.038
R2171 VDD.n172 VDD.n36 0.038
R2172 VDD.n175 VDD.n36 0.038
R2173 VDD.n176 VDD.n175 0.038
R2174 VDD.n176 VDD.n34 0.038
R2175 VDD.n179 VDD.n34 0.038
R2176 VDD.n180 VDD.n179 0.038
R2177 VDD.n180 VDD.n32 0.038
R2178 VDD.n183 VDD.n32 0.038
R2179 VDD.n184 VDD.n183 0.038
R2180 VDD.n184 VDD.n30 0.038
R2181 VDD.n187 VDD.n30 0.038
R2182 VDD.n188 VDD.n187 0.038
R2183 VDD.n188 VDD.n28 0.038
R2184 VDD.n191 VDD.n28 0.038
R2185 VDD.n192 VDD.n191 0.038
R2186 VDD.n192 VDD.n26 0.038
R2187 VDD.n195 VDD.n26 0.038
R2188 VDD.n196 VDD.n195 0.038
R2189 VDD.n196 VDD.n24 0.038
R2190 VDD.n199 VDD.n24 0.038
R2191 VDD.n200 VDD.n199 0.038
R2192 VDD.n200 VDD.n22 0.038
R2193 VDD.n204 VDD.n22 0.038
R2194 VDD.n205 VDD.n204 0.038
R2195 VDD.n205 VDD.n20 0.038
R2196 VDD.n208 VDD.n20 0.038
R2197 VDD.n209 VDD.n208 0.038
R2198 VDD.n209 VDD.n17 0.038
R2199 VDD.n212 VDD.n17 0.038
R2200 VDD.n213 VDD.n212 0.038
R2201 VDD.n213 VDD.n15 0.038
R2202 VDD.n216 VDD.n15 0.038
R2203 VDD.n217 VDD.n216 0.038
R2204 VDD.n217 VDD.n13 0.038
R2205 VDD.n220 VDD.n13 0.038
R2206 VDD.n221 VDD.n220 0.038
R2207 VDD.n221 VDD.n11 0.038
R2208 VDD.n224 VDD.n11 0.038
R2209 VDD.n225 VDD.n224 0.038
R2210 VDD.n225 VDD.n9 0.038
R2211 VDD.n228 VDD.n9 0.038
R2212 VDD.n229 VDD.n228 0.038
R2213 VDD.n229 VDD.n7 0.038
R2214 VDD.n232 VDD.n7 0.038
R2215 VDD.n233 VDD.n232 0.038
R2216 VDD.n233 VDD.n5 0.038
R2217 VDD.n236 VDD.n5 0.038
R2218 VDD.n237 VDD.n236 0.038
R2219 VDD.n237 VDD.n3 0.038
R2220 VDD.n240 VDD.n3 0.038
R2221 VDD.n242 VDD.n240 0.038
R2222 VDD.n242 VDD.n241 0.038
R2223 VDD.n241 VDD.n1 0.038
R2224 VDD.n246 VDD.n1 0.038
R2225 VDD.n300 VDD.n299 0.033875
R2226 VDD.n293 VDD.n268 0.0301696
R2227 VDD.n285 VDD.n284 0.0280625
R2228 VDD.n86 VDD.n85 0.0261875
R2229 VDD.n282 VDD.n281 0.0254375
R2230 VDD.n202 VDD.n19 0.02525
R2231 VDD.n169 VDD.n40 0.01775
R2232 VDD.n126 VDD.n125 0.01625
R2233 VDD.n326 VDD.n321 0.0156724
R2234 VDD.n331 VDD.n330 0.00857344
R2235 VDD.n331 VDD.n324 0.00857344
R2236 VDD.n333 VDD.n250 0.00857344
R2237 VDD.n330 VDD.n329 0.00857344
R2238 VDD.n320 VDD.n254 0.00857344
R2239 VDD.n329 VDD.n326 0.00857344
R2240 VDD.n324 VDD.n250 0.00857344
R2241 VDD.n321 VDD.n320 0.00857344
R2242 VDD.n327 VDD.n251 0.00841277
R2243 VDD.n323 VDD.n249 0.00841277
R2244 VDD.n325 VDD.n252 0.00841277
R2245 VDD.n322 VDD.n248 0.00841277
R2246 VDD.n332 VDD.n253 0.00841277
R2247 VDD.n328 VDD.n327 0.00841277
R2248 VDD.n323 VDD.n251 0.00841277
R2249 VDD.n325 VDD.n249 0.00841277
R2250 VDD.n322 VDD.n252 0.00841277
R2251 VDD.n253 VDD.n248 0.00841277
R2252 VDD.n288 VDD.n270 0.0055625
R2253 VDD.n161 VDD.n160 0.0040625
R2254 VDD.n290 VDD.n289 0.0021875
R2255 VSS.n285 VSS.t34 185036
R2256 VSS.n286 VSS.n285 109582
R2257 VSS.n285 VSS.t86 17503.1
R2258 VSS.n920 VSS.n145 4991
R2259 VSS.n922 VSS.n921 3678.14
R2260 VSS.n155 VSS.n145 2431.62
R2261 VSS.t130 VSS.n286 1989.9
R2262 VSS.n972 VSS.t32 1447.89
R2263 VSS.t32 VSS.n971 1243.46
R2264 VSS.n974 VSS.n111 632.212
R2265 VSS.n912 VSS.n911 627.33
R2266 VSS.n911 VSS.n153 627.33
R2267 VSS.n915 VSS.n147 627.33
R2268 VSS.n919 VSS.n147 627.33
R2269 VSS.n924 VSS.n922 557.902
R2270 VSS.n921 VSS.t41 486.454
R2271 VSS.t126 VSS.t128 484.781
R2272 VSS.t124 VSS.t122 484.781
R2273 VSS.t122 VSS.t120 484.781
R2274 VSS.t27 VSS.t29 484.781
R2275 VSS.t13 VSS.t27 484.781
R2276 VSS.t25 VSS.t13 484.781
R2277 VSS.t23 VSS.t25 484.781
R2278 VSS.t19 VSS.t21 484.781
R2279 VSS.t17 VSS.t19 484.781
R2280 VSS.t11 VSS.t17 484.781
R2281 VSS.t9 VSS.t11 484.781
R2282 VSS.t128 VSS.n972 457.236
R2283 VSS.t75 VSS.t165 440.748
R2284 VSS.n919 VSS.n146 432.067
R2285 VSS.n912 VSS.n150 431.974
R2286 VSS.t61 VSS.t29 386.08
R2287 VSS.t165 VSS.t163 372.877
R2288 VSS.t163 VSS.t161 372.877
R2289 VSS.t79 VSS.t59 338.938
R2290 VSS.n973 VSS.t124 332.827
R2291 VSS.t61 VSS.t21 326.63
R2292 VSS.t134 VSS.n144 285.014
R2293 VSS.t5 VSS.t50 270.623
R2294 VSS.t15 VSS.t5 270.623
R2295 VSS.n926 VSS.n142 268.026
R2296 VSS.n140 VSS.n111 268.026
R2297 VSS.t67 VSS.t45 243.909
R2298 VSS.t47 VSS.t39 243.909
R2299 VSS.t161 VSS.t78 237.954
R2300 VSS.t31 VSS.t42 228.071
R2301 VSS.t37 VSS.t155 218.329
R2302 VSS.t38 VSS.t81 212.606
R2303 VSS.n913 VSS.t50 207.96
R2304 VSS.t82 VSS.t69 200.353
R2305 VSS.t175 VSS.n155 179.898
R2306 VSS.n284 VSS.t61 176.744
R2307 VSS.t172 VSS.t132 176.626
R2308 VSS.n913 VSS.t61 167.102
R2309 VSS.n929 VSS.n928 154.819
R2310 VSS.t157 VSS.t37 154.548
R2311 VSS.n973 VSS.t126 151.953
R2312 VSS.t61 VSS.t9 151.494
R2313 VSS.n921 VSS.n920 147.758
R2314 VSS.t71 VSS.t67 140.96
R2315 VSS.t84 VSS.t47 140.96
R2316 VSS.n927 VSS.n926 138.159
R2317 VSS.n927 VSS.n111 138.159
R2318 VSS.t78 VSS.t159 134.923
R2319 VSS.t52 VSS.t73 134.514
R2320 VSS.n926 VSS.n925 129.869
R2321 VSS.t103 VSS.t130 129.654
R2322 VSS.t170 VSS.t168 127.154
R2323 VSS.t132 VSS.t0 125.928
R2324 VSS.t73 VSS.t173 125.928
R2325 VSS.t174 VSS.t75 125.928
R2326 VSS.n924 VSS.t79 117.996
R2327 VSS.t88 VSS.t89 114.37
R2328 VSS.t87 VSS.t88 114.37
R2329 VSS.t86 VSS.t87 114.37
R2330 VSS.t65 VSS.n909 110.8
R2331 VSS.t59 VSS.n923 101.365
R2332 VSS.n971 VSS.t41 99.1805
R2333 VSS.n923 VSS.t82 98.9893
R2334 VSS.t0 VSS.t1 98.5349
R2335 VSS.n972 VSS.t39 94.2378
R2336 VSS.t61 VSS.t23 92.0444
R2337 VSS.n922 VSS.n144 86.7147
R2338 VSS.t81 VSS.t157 82.5895
R2339 VSS.t91 VSS.t92 81.1211
R2340 VSS.t92 VSS.t93 81.1211
R2341 VSS.t93 VSS.t94 81.1211
R2342 VSS.t94 VSS.t95 81.1211
R2343 VSS.t95 VSS.t96 81.1211
R2344 VSS.t98 VSS.t97 81.1211
R2345 VSS.t99 VSS.t100 81.1211
R2346 VSS.t100 VSS.t101 81.1211
R2347 VSS.t101 VSS.t102 81.1211
R2348 VSS.t102 VSS.t103 81.1211
R2349 VSS.t3 VSS.t172 80.9541
R2350 VSS.t1 VSS.t65 78.0921
R2351 VSS.t159 VSS.t38 77.6832
R2352 VSS.n285 VSS.n284 68.4022
R2353 VSS.t69 VSS.t63 66.521
R2354 VSS.t63 VSS.t167 66.521
R2355 VSS.n928 VSS.t62 66.521
R2356 VSS.t62 VSS.t71 66.521
R2357 VSS.t45 VSS.t43 66.521
R2358 VSS.t42 VSS.t84 66.521
R2359 VSS.n141 VSS.t31 57.018
R2360 VSS.n287 VSS.t99 56.7849
R2361 VSS.t90 VSS.t118 53.1485
R2362 VSS.t89 VSS.n261 50.2204
R2363 VSS.t173 VSS.t170 49.4721
R2364 VSS.t168 VSS.t3 44.9747
R2365 VSS.n470 VSS.t96 40.5608
R2366 VSS.n910 VSS.t174 38.0241
R2367 VSS.n155 VSS.t15 35.2818
R2368 VSS.t97 VSS.n261 31.6096
R2369 VSS.n283 VSS.t176 31.5873
R2370 VSS.t118 VSS.t91 27.9731
R2371 VSS.t155 VSS.t134 26.985
R2372 VSS.n287 VSS.t98 24.3367
R2373 VSS.n909 VSS.t175 15.1282
R2374 VSS.t34 VSS.t90 13.1476
R2375 VSS.n128 VSS.t80 13.0008
R2376 VSS.n129 VSS.t177 11.6669
R2377 VSS.t43 VSS.n141 9.50342
R2378 VSS.n126 VSS.t60 9.43826
R2379 VSS.n937 VSS.t68 9.43826
R2380 VSS.n944 VSS.t85 9.43826
R2381 VSS.n118 VSS.t48 9.43826
R2382 VSS.n470 VSS.n261 8.95174
R2383 VSS.n917 VSS.n916 7.85935
R2384 VSS.n918 VSS.n917 7.85935
R2385 VSS.n929 VSS.t167 6.73174
R2386 VSS.n121 VSS.n120 6.65576
R2387 VSS.n470 VSS.n469 6.27865
R2388 VSS.n470 VSS.n260 6.27865
R2389 VSS.n470 VSS.n262 6.27865
R2390 VSS.n471 VSS.n470 6.27865
R2391 VSS.n908 VSS.t66 6.08947
R2392 VSS.n907 VSS.t133 6.08947
R2393 VSS.n906 VSS.t169 6.08947
R2394 VSS.n905 VSS.t74 6.08947
R2395 VSS.n904 VSS.t76 6.08947
R2396 VSS.n1000 VSS.t129 6.05637
R2397 VSS.n64 VSS.t121 6.05637
R2398 VSS.n54 VSS.n31 6.02239
R2399 VSS.n55 VSS.n36 6.02239
R2400 VSS.n56 VSS.n45 6.02239
R2401 VSS.n78 VSS.n57 6.02239
R2402 VSS.n167 VSS.t142 5.72359
R2403 VSS.n284 VSS.n239 5.56918
R2404 VSS.n918 VSS.n148 5.41204
R2405 VSS.n916 VSS.n149 5.41204
R2406 VSS.n916 VSS.n915 5.2005
R2407 VSS.n912 VSS.n151 5.2005
R2408 VSS.n913 VSS.n912 5.2005
R2409 VSS.n856 VSS.n153 5.2005
R2410 VSS.n919 VSS.n918 5.2005
R2411 VSS.n920 VSS.n919 5.2005
R2412 VSS.n856 VSS.n148 5.17896
R2413 VSS.n151 VSS.n149 5.17896
R2414 VSS.n915 VSS.n914 5.13854
R2415 VSS.n153 VSS.n152 5.13853
R2416 VSS.n936 VSS.t72 5.12789
R2417 VSS.n950 VSS.t40 5.12789
R2418 VSS.n288 VSS.n283 5.0855
R2419 VSS.n289 VSS.n288 4.97703
R2420 VSS.n137 VSS.t83 4.82596
R2421 VSS.n158 VSS.t51 4.82596
R2422 VSS.n158 VSS.t137 4.82596
R2423 VSS.n173 VSS.t138 4.82596
R2424 VSS.n173 VSS.t151 4.82596
R2425 VSS.n177 VSS.t53 4.82596
R2426 VSS.n176 VSS.t171 4.82596
R2427 VSS.n167 VSS.t77 4.82596
R2428 VSS.n163 VSS.t147 4.82596
R2429 VSS.n163 VSS.t56 4.82596
R2430 VSS.n181 VSS.t57 4.82596
R2431 VSS.n181 VSS.t143 4.82596
R2432 VSS.n745 VSS.t154 4.75491
R2433 VSS.n184 VSS.t148 4.75491
R2434 VSS.n792 VSS.n791 4.5755
R2435 VSS.n895 VSS.n794 4.5755
R2436 VSS.n292 VSS.n291 4.5005
R2437 VSS.n280 VSS.n279 4.5005
R2438 VSS.n298 VSS.n297 4.5005
R2439 VSS.n300 VSS.n299 4.5005
R2440 VSS.n276 VSS.n275 4.5005
R2441 VSS.n307 VSS.n306 4.5005
R2442 VSS.n309 VSS.n308 4.5005
R2443 VSS.n272 VSS.n271 4.5005
R2444 VSS.n315 VSS.n314 4.5005
R2445 VSS.n317 VSS.n316 4.5005
R2446 VSS.n268 VSS.n267 4.5005
R2447 VSS.n324 VSS.n323 4.5005
R2448 VSS.n325 VSS.n265 4.5005
R2449 VSS.n466 VSS.n465 4.5005
R2450 VSS.n464 VSS.n463 4.5005
R2451 VSS.n327 VSS.n326 4.5005
R2452 VSS.n457 VSS.n456 4.5005
R2453 VSS.n455 VSS.n454 4.5005
R2454 VSS.n451 VSS.n335 4.5005
R2455 VSS.n339 VSS.n336 4.5005
R2456 VSS.n446 VSS.n445 4.5005
R2457 VSS.n444 VSS.n443 4.5005
R2458 VSS.n341 VSS.n340 4.5005
R2459 VSS.n438 VSS.n437 4.5005
R2460 VSS.n436 VSS.n435 4.5005
R2461 VSS.n345 VSS.n344 4.5005
R2462 VSS.n430 VSS.n429 4.5005
R2463 VSS.n428 VSS.n427 4.5005
R2464 VSS.n349 VSS.n348 4.5005
R2465 VSS.n422 VSS.n421 4.5005
R2466 VSS.n420 VSS.n419 4.5005
R2467 VSS.n353 VSS.n352 4.5005
R2468 VSS.n414 VSS.n413 4.5005
R2469 VSS.n412 VSS.n411 4.5005
R2470 VSS.n357 VSS.n356 4.5005
R2471 VSS.n406 VSS.n405 4.5005
R2472 VSS.n404 VSS.n403 4.5005
R2473 VSS.n361 VSS.n360 4.5005
R2474 VSS.n398 VSS.n397 4.5005
R2475 VSS.n396 VSS.n395 4.5005
R2476 VSS.n365 VSS.n364 4.5005
R2477 VSS.n390 VSS.n389 4.5005
R2478 VSS.n388 VSS.n387 4.5005
R2479 VSS.n368 VSS.n367 4.5005
R2480 VSS.n382 VSS.n381 4.5005
R2481 VSS.n380 VSS.n379 4.5005
R2482 VSS.n258 VSS.n257 4.5005
R2483 VSS.n475 VSS.n474 4.5005
R2484 VSS.n477 VSS.n476 4.5005
R2485 VSS.n254 VSS.n253 4.5005
R2486 VSS.n483 VSS.n482 4.5005
R2487 VSS.n485 VSS.n484 4.5005
R2488 VSS.n250 VSS.n249 4.5005
R2489 VSS.n491 VSS.n490 4.5005
R2490 VSS.n493 VSS.n492 4.5005
R2491 VSS.n246 VSS.n245 4.5005
R2492 VSS.n500 VSS.n499 4.5005
R2493 VSS.n502 VSS.n501 4.5005
R2494 VSS.n242 VSS.n241 4.5005
R2495 VSS.n509 VSS.n508 4.5005
R2496 VSS.n511 VSS.n510 4.5005
R2497 VSS.n238 VSS.n237 4.5005
R2498 VSS.n518 VSS.n517 4.5005
R2499 VSS.n519 VSS.n235 4.5005
R2500 VSS.n720 VSS.n719 4.5005
R2501 VSS.n718 VSS.n717 4.5005
R2502 VSS.n521 VSS.n520 4.5005
R2503 VSS.n712 VSS.n711 4.5005
R2504 VSS.n710 VSS.n709 4.5005
R2505 VSS.n706 VSS.n524 4.5005
R2506 VSS.n528 VSS.n525 4.5005
R2507 VSS.n701 VSS.n700 4.5005
R2508 VSS.n699 VSS.n698 4.5005
R2509 VSS.n530 VSS.n529 4.5005
R2510 VSS.n693 VSS.n692 4.5005
R2511 VSS.n691 VSS.n690 4.5005
R2512 VSS.n533 VSS.n532 4.5005
R2513 VSS.n685 VSS.n684 4.5005
R2514 VSS.n683 VSS.n682 4.5005
R2515 VSS.n679 VSS.n537 4.5005
R2516 VSS.n541 VSS.n538 4.5005
R2517 VSS.n674 VSS.n673 4.5005
R2518 VSS.n672 VSS.n671 4.5005
R2519 VSS.n543 VSS.n542 4.5005
R2520 VSS.n666 VSS.n665 4.5005
R2521 VSS.n664 VSS.n663 4.5005
R2522 VSS.n546 VSS.n545 4.5005
R2523 VSS.n658 VSS.n657 4.5005
R2524 VSS.n656 VSS.n655 4.5005
R2525 VSS.n551 VSS.n550 4.5005
R2526 VSS.n650 VSS.n649 4.5005
R2527 VSS.n648 VSS.n647 4.5005
R2528 VSS.n554 VSS.n553 4.5005
R2529 VSS.n642 VSS.n641 4.5005
R2530 VSS.n640 VSS.n639 4.5005
R2531 VSS.n636 VSS.n558 4.5005
R2532 VSS.n562 VSS.n559 4.5005
R2533 VSS.n631 VSS.n630 4.5005
R2534 VSS.n629 VSS.n628 4.5005
R2535 VSS.n564 VSS.n563 4.5005
R2536 VSS.n623 VSS.n622 4.5005
R2537 VSS.n621 VSS.n620 4.5005
R2538 VSS.n567 VSS.n566 4.5005
R2539 VSS.n615 VSS.n614 4.5005
R2540 VSS.n613 VSS.n612 4.5005
R2541 VSS.n572 VSS.n571 4.5005
R2542 VSS.n607 VSS.n606 4.5005
R2543 VSS.n605 VSS.n604 4.5005
R2544 VSS.n575 VSS.n574 4.5005
R2545 VSS.n599 VSS.n598 4.5005
R2546 VSS.n597 VSS.n596 4.5005
R2547 VSS.n593 VSS.n579 4.5005
R2548 VSS.n583 VSS.n580 4.5005
R2549 VSS.n588 VSS.n587 4.5005
R2550 VSS.n586 VSS.n585 4.5005
R2551 VSS.n213 VSS.n212 4.5005
R2552 VSS.n740 VSS.n739 4.5005
R2553 VSS.n742 VSS.n741 4.5005
R2554 VSS.n210 VSS.n209 4.5005
R2555 VSS.n749 VSS.n748 4.5005
R2556 VSS.n751 VSS.n750 4.5005
R2557 VSS.n206 VSS.n205 4.5005
R2558 VSS.n757 VSS.n756 4.5005
R2559 VSS.n759 VSS.n758 4.5005
R2560 VSS.n201 VSS.n200 4.5005
R2561 VSS.n766 VSS.n765 4.5005
R2562 VSS.n768 VSS.n767 4.5005
R2563 VSS.n197 VSS.n196 4.5005
R2564 VSS.n775 VSS.n774 4.5005
R2565 VSS.n777 VSS.n776 4.5005
R2566 VSS.n192 VSS.n191 4.5005
R2567 VSS.n783 VSS.n782 4.5005
R2568 VSS.n785 VSS.n784 4.5005
R2569 VSS.n188 VSS.n187 4.5005
R2570 VSS.n791 VSS.n790 4.5005
R2571 VSS.n1006 VSS.n1005 4.5005
R2572 VSS.n1004 VSS.n1003 4.5005
R2573 VSS.n21 VSS.n20 4.5005
R2574 VSS.n997 VSS.n996 4.5005
R2575 VSS.n995 VSS.n994 4.5005
R2576 VSS.n26 VSS.n25 4.5005
R2577 VSS.n989 VSS.n988 4.5005
R2578 VSS.n987 VSS.n986 4.5005
R2579 VSS.n30 VSS.n29 4.5005
R2580 VSS.n981 VSS.n980 4.5005
R2581 VSS.n979 VSS.n978 4.5005
R2582 VSS.n35 VSS.n34 4.5005
R2583 VSS.n108 VSS.n107 4.5005
R2584 VSS.n106 VSS.n105 4.5005
R2585 VSS.n39 VSS.n38 4.5005
R2586 VSS.n100 VSS.n99 4.5005
R2587 VSS.n98 VSS.n97 4.5005
R2588 VSS.n44 VSS.n43 4.5005
R2589 VSS.n92 VSS.n91 4.5005
R2590 VSS.n90 VSS.n89 4.5005
R2591 VSS.n48 VSS.n47 4.5005
R2592 VSS.n84 VSS.n83 4.5005
R2593 VSS.n82 VSS.n81 4.5005
R2594 VSS.n53 VSS.n52 4.5005
R2595 VSS.n75 VSS.n74 4.5005
R2596 VSS.n73 VSS.n72 4.5005
R2597 VSS.n61 VSS.n60 4.5005
R2598 VSS.n67 VSS.n66 4.5005
R2599 VSS.n17 VSS.n16 4.5005
R2600 VSS.n1008 VSS.n16 4.5005
R2601 VSS.n954 VSS.n953 4.5005
R2602 VSS.n953 VSS.n952 4.5005
R2603 VSS.n896 VSS.n895 4.5005
R2604 VSS.n894 VSS.n893 4.5005
R2605 VSS.n797 VSS.n796 4.5005
R2606 VSS.n887 VSS.n886 4.5005
R2607 VSS.n885 VSS.n884 4.5005
R2608 VSS.n802 VSS.n801 4.5005
R2609 VSS.n879 VSS.n878 4.5005
R2610 VSS.n877 VSS.n876 4.5005
R2611 VSS.n807 VSS.n806 4.5005
R2612 VSS.n871 VSS.n870 4.5005
R2613 VSS.n869 VSS.n868 4.5005
R2614 VSS.n812 VSS.n811 4.5005
R2615 VSS.n862 VSS.n861 4.5005
R2616 VSS.n860 VSS.n859 4.5005
R2617 VSS.n824 VSS.n820 4.5005
R2618 VSS.n852 VSS.n851 4.5005
R2619 VSS.n850 VSS.n849 4.5005
R2620 VSS.n846 VSS.n826 4.5005
R2621 VSS.n830 VSS.n827 4.5005
R2622 VSS.n841 VSS.n840 4.5005
R2623 VSS.n839 VSS.n838 4.5005
R2624 VSS.n834 VSS.n832 4.5005
R2625 VSS.n831 VSS.n0 4.5005
R2626 VSS.n5 VSS.n1 4.5005
R2627 VSS.n1032 VSS.n1031 4.5005
R2628 VSS.n1030 VSS.n1029 4.5005
R2629 VSS.n7 VSS.n6 4.5005
R2630 VSS.n1024 VSS.n1023 4.5005
R2631 VSS.n1022 VSS.n1021 4.5005
R2632 VSS.n12 VSS.n11 4.5005
R2633 VSS.n1016 VSS.n1015 4.5005
R2634 VSS.n1014 VSS.n1013 4.5005
R2635 VSS.n955 VSS.n954 4.13203
R2636 VSS.n910 VSS.t52 4.08906
R2637 VSS.n899 VSS.t166 3.88323
R2638 VSS.n822 VSS.t156 3.88323
R2639 VSS.n890 VSS.n798 3.82887
R2640 VSS.n814 VSS.n803 3.82887
R2641 VSS.n815 VSS.n804 3.82887
R2642 VSS.n816 VSS.n809 3.82887
R2643 VSS.n865 VSS.n817 3.82887
R2644 VSS.n303 VSS.t131 3.58511
R2645 VSS.n139 VSS.n125 3.45839
R2646 VSS.n329 VSS.t111 3.44407
R2647 VSS.n371 VSS.t104 3.44407
R2648 VSS.n159 VSS.n156 3.43471
R2649 VSS.n159 VSS.n157 3.43471
R2650 VSS.n172 VSS.n170 3.43471
R2651 VSS.n172 VSS.n171 3.43471
R2652 VSS.n168 VSS.n166 3.43471
R2653 VSS.n175 VSS.n174 3.43471
R2654 VSS.n164 VSS.n161 3.43471
R2655 VSS.n164 VSS.n162 3.43471
R2656 VSS.n180 VSS.n178 3.43471
R2657 VSS.n180 VSS.n179 3.43471
R2658 VSS.n762 VSS.n202 3.36366
R2659 VSS.n194 VSS.n193 3.36366
R2660 VSS.n835 VSS.n142 3.29259
R2661 VSS.n140 VSS.n13 3.29259
R2662 VSS.n120 VSS.t46 2.9405
R2663 VSS.n120 VSS.t44 2.9405
R2664 VSS.n283 VSS.t119 2.88275
R2665 VSS.n159 VSS.n158 2.78932
R2666 VSS.n173 VSS.n172 2.78932
R2667 VSS.n164 VSS.n163 2.78932
R2668 VSS.n181 VSS.n180 2.78932
R2669 VSS.n956 VSS.t33 2.64712
R2670 VSS.n969 VSS.t33 2.64712
R2671 VSS.n724 VSS.n723 2.59037
R2672 VSS.n725 VSS.n232 2.59037
R2673 VSS.n726 VSS.n230 2.59037
R2674 VSS.n727 VSS.n228 2.59037
R2675 VSS.n728 VSS.n226 2.59037
R2676 VSS.n729 VSS.n224 2.59037
R2677 VSS.n730 VSS.n222 2.59037
R2678 VSS.n731 VSS.n220 2.59037
R2679 VSS.n732 VSS.n218 2.59037
R2680 VSS.n733 VSS.n216 2.59037
R2681 VSS.n736 VSS.n734 2.59037
R2682 VSS.n332 VSS.n330 2.54182
R2683 VSS.n374 VSS.n372 2.54182
R2684 VSS.n734 VSS.t10 2.51913
R2685 VSS.n724 VSS.t30 2.51913
R2686 VSS.n725 VSS.n231 2.48516
R2687 VSS.n726 VSS.n229 2.48516
R2688 VSS.n727 VSS.n227 2.48516
R2689 VSS.n728 VSS.n225 2.48516
R2690 VSS.n729 VSS.n223 2.48516
R2691 VSS.n730 VSS.n221 2.48516
R2692 VSS.n731 VSS.n219 2.48516
R2693 VSS.n732 VSS.n217 2.48516
R2694 VSS.n733 VSS.n215 2.48516
R2695 VSS.n291 VSS.n290 2.33873
R2696 VSS.n66 VSS.n65 2.32784
R2697 VSS.n951 VSS.n116 2.25177
R2698 VSS.n332 VSS.n331 1.90242
R2699 VSS.n374 VSS.n373 1.90242
R2700 VSS.n168 VSS.n167 1.89168
R2701 VSS.n176 VSS.n175 1.89168
R2702 VSS.n329 VSS.n328 1.87392
R2703 VSS.n371 VSS.n370 1.87392
R2704 VSS.n902 VSS.n901 1.86918
R2705 VSS.n125 VSS.t70 1.7645
R2706 VSS.n125 VSS.t64 1.7645
R2707 VSS.n903 VSS.n902 1.70813
R2708 VSS.n901 VSS.n900 1.63708
R2709 VSS.n65 VSS.n64 1.56609
R2710 VSS.n160 VSS.n159 1.54826
R2711 VSS.n169 VSS.n168 1.54826
R2712 VSS.n165 VSS.n164 1.54826
R2713 VSS.n904 VSS.n903 1.54471
R2714 VSS.n290 VSS.n289 1.5257
R2715 VSS.n951 VSS.n950 1.51494
R2716 VSS.n949 VSS.n117 1.5005
R2717 VSS.n948 VSS.n947 1.5005
R2718 VSS.n946 VSS.n945 1.5005
R2719 VSS.n943 VSS.n119 1.5005
R2720 VSS.n942 VSS.n941 1.5005
R2721 VSS.n940 VSS.n939 1.5005
R2722 VSS.n938 VSS.n122 1.5005
R2723 VSS.n935 VSS.n934 1.5005
R2724 VSS.n933 VSS.n123 1.5005
R2725 VSS.n932 VSS.n931 1.5005
R2726 VSS.n138 VSS.n124 1.5005
R2727 VSS.n136 VSS.n135 1.5005
R2728 VSS.n134 VSS.n133 1.5005
R2729 VSS.n132 VSS.n127 1.5005
R2730 VSS.n131 VSS.n130 1.5005
R2731 VSS.n282 VSS.n281 1.5005
R2732 VSS.n294 VSS.n293 1.5005
R2733 VSS.n296 VSS.n295 1.5005
R2734 VSS.n278 VSS.n277 1.5005
R2735 VSS.n302 VSS.n301 1.5005
R2736 VSS.n305 VSS.n304 1.5005
R2737 VSS.n274 VSS.n273 1.5005
R2738 VSS.n311 VSS.n310 1.5005
R2739 VSS.n313 VSS.n312 1.5005
R2740 VSS.n270 VSS.n269 1.5005
R2741 VSS.n319 VSS.n318 1.5005
R2742 VSS.n321 VSS.n320 1.5005
R2743 VSS.n322 VSS.n263 1.5005
R2744 VSS.n468 VSS.n467 1.5005
R2745 VSS.n266 VSS.n264 1.5005
R2746 VSS.n462 VSS.n461 1.5005
R2747 VSS.n459 VSS.n458 1.5005
R2748 VSS.n334 VSS.n333 1.5005
R2749 VSS.n453 VSS.n452 1.5005
R2750 VSS.n450 VSS.n449 1.5005
R2751 VSS.n448 VSS.n447 1.5005
R2752 VSS.n338 VSS.n337 1.5005
R2753 VSS.n442 VSS.n441 1.5005
R2754 VSS.n440 VSS.n439 1.5005
R2755 VSS.n343 VSS.n342 1.5005
R2756 VSS.n434 VSS.n433 1.5005
R2757 VSS.n432 VSS.n431 1.5005
R2758 VSS.n347 VSS.n346 1.5005
R2759 VSS.n426 VSS.n425 1.5005
R2760 VSS.n424 VSS.n423 1.5005
R2761 VSS.n351 VSS.n350 1.5005
R2762 VSS.n418 VSS.n417 1.5005
R2763 VSS.n416 VSS.n415 1.5005
R2764 VSS.n355 VSS.n354 1.5005
R2765 VSS.n410 VSS.n409 1.5005
R2766 VSS.n408 VSS.n407 1.5005
R2767 VSS.n359 VSS.n358 1.5005
R2768 VSS.n402 VSS.n401 1.5005
R2769 VSS.n400 VSS.n399 1.5005
R2770 VSS.n363 VSS.n362 1.5005
R2771 VSS.n394 VSS.n393 1.5005
R2772 VSS.n392 VSS.n391 1.5005
R2773 VSS.n369 VSS.n366 1.5005
R2774 VSS.n386 VSS.n385 1.5005
R2775 VSS.n384 VSS.n383 1.5005
R2776 VSS.n377 VSS.n376 1.5005
R2777 VSS.n378 VSS.n259 1.5005
R2778 VSS.n473 VSS.n472 1.5005
R2779 VSS.n256 VSS.n255 1.5005
R2780 VSS.n479 VSS.n478 1.5005
R2781 VSS.n481 VSS.n480 1.5005
R2782 VSS.n252 VSS.n251 1.5005
R2783 VSS.n487 VSS.n486 1.5005
R2784 VSS.n489 VSS.n488 1.5005
R2785 VSS.n248 VSS.n247 1.5005
R2786 VSS.n495 VSS.n494 1.5005
R2787 VSS.n498 VSS.n497 1.5005
R2788 VSS.n496 VSS.n244 1.5005
R2789 VSS.n504 VSS.n503 1.5005
R2790 VSS.n507 VSS.n506 1.5005
R2791 VSS.n505 VSS.n240 1.5005
R2792 VSS.n513 VSS.n512 1.5005
R2793 VSS.n515 VSS.n514 1.5005
R2794 VSS.n516 VSS.n233 1.5005
R2795 VSS.n722 VSS.n721 1.5005
R2796 VSS.n236 VSS.n234 1.5005
R2797 VSS.n716 VSS.n715 1.5005
R2798 VSS.n714 VSS.n713 1.5005
R2799 VSS.n523 VSS.n522 1.5005
R2800 VSS.n708 VSS.n707 1.5005
R2801 VSS.n705 VSS.n704 1.5005
R2802 VSS.n703 VSS.n702 1.5005
R2803 VSS.n527 VSS.n526 1.5005
R2804 VSS.n697 VSS.n696 1.5005
R2805 VSS.n695 VSS.n694 1.5005
R2806 VSS.n534 VSS.n531 1.5005
R2807 VSS.n689 VSS.n688 1.5005
R2808 VSS.n687 VSS.n686 1.5005
R2809 VSS.n536 VSS.n535 1.5005
R2810 VSS.n681 VSS.n680 1.5005
R2811 VSS.n678 VSS.n677 1.5005
R2812 VSS.n676 VSS.n675 1.5005
R2813 VSS.n540 VSS.n539 1.5005
R2814 VSS.n670 VSS.n669 1.5005
R2815 VSS.n668 VSS.n667 1.5005
R2816 VSS.n547 VSS.n544 1.5005
R2817 VSS.n662 VSS.n661 1.5005
R2818 VSS.n660 VSS.n659 1.5005
R2819 VSS.n549 VSS.n548 1.5005
R2820 VSS.n654 VSS.n653 1.5005
R2821 VSS.n652 VSS.n651 1.5005
R2822 VSS.n555 VSS.n552 1.5005
R2823 VSS.n646 VSS.n645 1.5005
R2824 VSS.n644 VSS.n643 1.5005
R2825 VSS.n557 VSS.n556 1.5005
R2826 VSS.n638 VSS.n637 1.5005
R2827 VSS.n635 VSS.n634 1.5005
R2828 VSS.n633 VSS.n632 1.5005
R2829 VSS.n561 VSS.n560 1.5005
R2830 VSS.n627 VSS.n626 1.5005
R2831 VSS.n625 VSS.n624 1.5005
R2832 VSS.n568 VSS.n565 1.5005
R2833 VSS.n619 VSS.n618 1.5005
R2834 VSS.n617 VSS.n616 1.5005
R2835 VSS.n570 VSS.n569 1.5005
R2836 VSS.n611 VSS.n610 1.5005
R2837 VSS.n609 VSS.n608 1.5005
R2838 VSS.n576 VSS.n573 1.5005
R2839 VSS.n603 VSS.n602 1.5005
R2840 VSS.n601 VSS.n600 1.5005
R2841 VSS.n578 VSS.n577 1.5005
R2842 VSS.n595 VSS.n594 1.5005
R2843 VSS.n592 VSS.n591 1.5005
R2844 VSS.n590 VSS.n589 1.5005
R2845 VSS.n582 VSS.n581 1.5005
R2846 VSS.n584 VSS.n214 1.5005
R2847 VSS.n738 VSS.n737 1.5005
R2848 VSS.n735 VSS.n211 1.5005
R2849 VSS.n744 VSS.n743 1.5005
R2850 VSS.n747 VSS.n746 1.5005
R2851 VSS.n208 VSS.n207 1.5005
R2852 VSS.n753 VSS.n752 1.5005
R2853 VSS.n755 VSS.n754 1.5005
R2854 VSS.n204 VSS.n203 1.5005
R2855 VSS.n761 VSS.n760 1.5005
R2856 VSS.n764 VSS.n763 1.5005
R2857 VSS.n199 VSS.n198 1.5005
R2858 VSS.n770 VSS.n769 1.5005
R2859 VSS.n773 VSS.n772 1.5005
R2860 VSS.n771 VSS.n195 1.5005
R2861 VSS.n779 VSS.n778 1.5005
R2862 VSS.n781 VSS.n780 1.5005
R2863 VSS.n190 VSS.n189 1.5005
R2864 VSS.n787 VSS.n786 1.5005
R2865 VSS.n789 VSS.n788 1.5005
R2866 VSS.n186 VSS.n185 1.5005
R2867 VSS.n793 VSS.n182 1.5005
R2868 VSS.n898 VSS.n897 1.5005
R2869 VSS.n795 VSS.n183 1.5005
R2870 VSS.n892 VSS.n891 1.5005
R2871 VSS.n889 VSS.n888 1.5005
R2872 VSS.n800 VSS.n799 1.5005
R2873 VSS.n883 VSS.n882 1.5005
R2874 VSS.n881 VSS.n880 1.5005
R2875 VSS.n808 VSS.n805 1.5005
R2876 VSS.n875 VSS.n874 1.5005
R2877 VSS.n873 VSS.n872 1.5005
R2878 VSS.n813 VSS.n810 1.5005
R2879 VSS.n867 VSS.n866 1.5005
R2880 VSS.n864 VSS.n863 1.5005
R2881 VSS.n819 VSS.n818 1.5005
R2882 VSS.n858 VSS.n857 1.5005
R2883 VSS.n855 VSS.n821 1.5005
R2884 VSS.n854 VSS.n853 1.5005
R2885 VSS.n825 VSS.n823 1.5005
R2886 VSS.n848 VSS.n847 1.5005
R2887 VSS.n845 VSS.n844 1.5005
R2888 VSS.n843 VSS.n842 1.5005
R2889 VSS.n829 VSS.n828 1.5005
R2890 VSS.n837 VSS.n836 1.5005
R2891 VSS.n833 VSS.n2 1.5005
R2892 VSS.n1036 VSS.n1035 1.5005
R2893 VSS.n1034 VSS.n1033 1.5005
R2894 VSS.n8 VSS.n4 1.5005
R2895 VSS.n1028 VSS.n1027 1.5005
R2896 VSS.n1026 VSS.n1025 1.5005
R2897 VSS.n10 VSS.n9 1.5005
R2898 VSS.n1020 VSS.n1019 1.5005
R2899 VSS.n1018 VSS.n1017 1.5005
R2900 VSS.n15 VSS.n14 1.5005
R2901 VSS.n1012 VSS.n1011 1.5005
R2902 VSS.n1010 VSS.n1009 1.5005
R2903 VSS.n1007 VSS.n18 1.5005
R2904 VSS.n22 VSS.n19 1.5005
R2905 VSS.n1002 VSS.n1001 1.5005
R2906 VSS.n999 VSS.n998 1.5005
R2907 VSS.n24 VSS.n23 1.5005
R2908 VSS.n993 VSS.n992 1.5005
R2909 VSS.n991 VSS.n990 1.5005
R2910 VSS.n28 VSS.n27 1.5005
R2911 VSS.n985 VSS.n984 1.5005
R2912 VSS.n983 VSS.n982 1.5005
R2913 VSS.n33 VSS.n32 1.5005
R2914 VSS.n977 VSS.n976 1.5005
R2915 VSS.n110 VSS.n109 1.5005
R2916 VSS.n40 VSS.n37 1.5005
R2917 VSS.n104 VSS.n103 1.5005
R2918 VSS.n102 VSS.n101 1.5005
R2919 VSS.n42 VSS.n41 1.5005
R2920 VSS.n96 VSS.n95 1.5005
R2921 VSS.n94 VSS.n93 1.5005
R2922 VSS.n49 VSS.n46 1.5005
R2923 VSS.n88 VSS.n87 1.5005
R2924 VSS.n86 VSS.n85 1.5005
R2925 VSS.n51 VSS.n50 1.5005
R2926 VSS.n80 VSS.n79 1.5005
R2927 VSS.n77 VSS.n76 1.5005
R2928 VSS.n59 VSS.n58 1.5005
R2929 VSS.n71 VSS.n70 1.5005
R2930 VSS.n69 VSS.n68 1.5005
R2931 VSS.n63 VSS.n62 1.5005
R2932 VSS.n958 VSS.n957 1.5005
R2933 VSS.n959 VSS.n115 1.5005
R2934 VSS.n961 VSS.n960 1.5005
R2935 VSS.n962 VSS.n114 1.5005
R2936 VSS.n964 VSS.n963 1.5005
R2937 VSS.n965 VSS.n113 1.5005
R2938 VSS.n967 VSS.n966 1.5005
R2939 VSS.n968 VSS.n112 1.5005
R2940 VSS.n202 VSS.t150 1.4705
R2941 VSS.n202 VSS.t16 1.4705
R2942 VSS.n193 VSS.t149 1.4705
R2943 VSS.n193 VSS.t58 1.4705
R2944 VSS.n157 VSS.t140 1.4705
R2945 VSS.n157 VSS.t35 1.4705
R2946 VSS.n156 VSS.t49 1.4705
R2947 VSS.n156 VSS.t136 1.4705
R2948 VSS.n171 VSS.t139 1.4705
R2949 VSS.n171 VSS.t4 1.4705
R2950 VSS.n170 VSS.t2 1.4705
R2951 VSS.n170 VSS.t135 1.4705
R2952 VSS.n166 VSS.t6 1.4705
R2953 VSS.n166 VSS.t152 1.4705
R2954 VSS.n174 VSS.t54 1.4705
R2955 VSS.n174 VSS.t141 1.4705
R2956 VSS.n162 VSS.t8 1.4705
R2957 VSS.n162 VSS.t146 1.4705
R2958 VSS.n161 VSS.t144 1.4705
R2959 VSS.n161 VSS.t55 1.4705
R2960 VSS.n179 VSS.t36 1.4705
R2961 VSS.n179 VSS.t145 1.4705
R2962 VSS.n178 VSS.t153 1.4705
R2963 VSS.n178 VSS.t7 1.4705
R2964 VSS.n172 VSS.n160 1.24511
R2965 VSS.n175 VSS.n169 1.24511
R2966 VSS.n180 VSS.n165 1.24511
R2967 VSS.n177 VSS.n176 0.898132
R2968 VSS.n330 VSS.t117 0.8825
R2969 VSS.n330 VSS.t116 0.8825
R2970 VSS.n328 VSS.t113 0.8825
R2971 VSS.n328 VSS.t112 0.8825
R2972 VSS.n331 VSS.t115 0.8825
R2973 VSS.n331 VSS.t114 0.8825
R2974 VSS.n372 VSS.t110 0.8825
R2975 VSS.n372 VSS.t109 0.8825
R2976 VSS.n370 VSS.t106 0.8825
R2977 VSS.n370 VSS.t105 0.8825
R2978 VSS.n373 VSS.t108 0.8825
R2979 VSS.n373 VSS.t107 0.8825
R2980 VSS.n908 VSS.n907 0.876816
R2981 VSS.n907 VSS.n906 0.876816
R2982 VSS.n906 VSS.n905 0.876816
R2983 VSS.n905 VSS.n904 0.876816
R2984 VSS.n460 VSS.n332 0.85325
R2985 VSS.n375 VSS.n374 0.85325
R2986 VSS.n956 VSS.n955 0.757202
R2987 VSS.n952 VSS.n16 0.694737
R2988 VSS.n332 VSS.n329 0.668395
R2989 VSS.n374 VSS.n371 0.668395
R2990 VSS.n909 VSS.n908 0.550675
R2991 VSS.n130 VSS.n129 0.513873
R2992 VSS.n970 VSS.n112 0.501672
R2993 VSS.n903 VSS.n173 0.302474
R2994 VSS.n902 VSS.n177 0.302474
R2995 VSS.n901 VSS.n181 0.302474
R2996 VSS.n726 VSS.n725 0.2381
R2997 VSS.n727 VSS.n726 0.2381
R2998 VSS.n728 VSS.n727 0.2381
R2999 VSS.n729 VSS.n728 0.2381
R3000 VSS.n730 VSS.n729 0.2381
R3001 VSS.n731 VSS.n730 0.2381
R3002 VSS.n732 VSS.n731 0.2381
R3003 VSS.n733 VSS.n732 0.2381
R3004 VSS.n725 VSS.n724 0.237763
R3005 VSS.n734 VSS.n733 0.237763
R3006 VSS.n927 VSS.n3 0.173833
R3007 VSS.n928 VSS.n927 0.173833
R3008 VSS.n925 VSS.n143 0.168242
R3009 VSS.n925 VSS.n924 0.168242
R3010 VSS.n909 VSS.n165 0.133833
R3011 VSS.n909 VSS.n169 0.133833
R3012 VSS.n909 VSS.n160 0.133833
R3013 VSS.n930 VSS.n929 0.122853
R3014 VSS.n971 VSS.n970 0.122853
R3015 VSS.n288 VSS.n287 0.12143
R3016 VSS.n958 VSS.n955 0.108353
R3017 VSS.n129 VSS.n128 0.0872074
R3018 VSS.n141 VSS.n140 0.0857459
R3019 VSS.n923 VSS.n142 0.0857459
R3020 VSS.n130 VSS.n127 0.0755
R3021 VSS.n134 VSS.n127 0.0755
R3022 VSS.n135 VSS.n134 0.0755
R3023 VSS.n135 VSS.n124 0.0755
R3024 VSS.n932 VSS.n124 0.0755
R3025 VSS.n933 VSS.n932 0.0755
R3026 VSS.n934 VSS.n933 0.0755
R3027 VSS.n934 VSS.n122 0.0755
R3028 VSS.n940 VSS.n122 0.0755
R3029 VSS.n941 VSS.n940 0.0755
R3030 VSS.n941 VSS.n119 0.0755
R3031 VSS.n946 VSS.n119 0.0755
R3032 VSS.n947 VSS.n946 0.0755
R3033 VSS.n947 VSS.n117 0.0755
R3034 VSS.n132 VSS.n131 0.0755
R3035 VSS.n133 VSS.n132 0.0755
R3036 VSS.n935 VSS.n123 0.0755
R3037 VSS.n939 VSS.n938 0.0755
R3038 VSS.n943 VSS.n942 0.0755
R3039 VSS.n945 VSS.n943 0.0755
R3040 VSS.n949 VSS.n948 0.0755
R3041 VSS.n1005 VSS.n1004 0.0755
R3042 VSS.n1004 VSS.n20 0.0755
R3043 VSS.n996 VSS.n20 0.0755
R3044 VSS.n996 VSS.n995 0.0755
R3045 VSS.n995 VSS.n25 0.0755
R3046 VSS.n988 VSS.n25 0.0755
R3047 VSS.n988 VSS.n987 0.0755
R3048 VSS.n987 VSS.n29 0.0755
R3049 VSS.n980 VSS.n29 0.0755
R3050 VSS.n980 VSS.n979 0.0755
R3051 VSS.n979 VSS.n34 0.0755
R3052 VSS.n107 VSS.n34 0.0755
R3053 VSS.n107 VSS.n106 0.0755
R3054 VSS.n106 VSS.n38 0.0755
R3055 VSS.n99 VSS.n38 0.0755
R3056 VSS.n99 VSS.n98 0.0755
R3057 VSS.n98 VSS.n43 0.0755
R3058 VSS.n91 VSS.n43 0.0755
R3059 VSS.n91 VSS.n90 0.0755
R3060 VSS.n90 VSS.n47 0.0755
R3061 VSS.n83 VSS.n47 0.0755
R3062 VSS.n83 VSS.n82 0.0755
R3063 VSS.n82 VSS.n52 0.0755
R3064 VSS.n74 VSS.n52 0.0755
R3065 VSS.n74 VSS.n73 0.0755
R3066 VSS.n73 VSS.n60 0.0755
R3067 VSS.n66 VSS.n60 0.0755
R3068 VSS.n291 VSS.n279 0.0755
R3069 VSS.n298 VSS.n279 0.0755
R3070 VSS.n299 VSS.n298 0.0755
R3071 VSS.n299 VSS.n275 0.0755
R3072 VSS.n307 VSS.n275 0.0755
R3073 VSS.n308 VSS.n307 0.0755
R3074 VSS.n308 VSS.n271 0.0755
R3075 VSS.n315 VSS.n271 0.0755
R3076 VSS.n316 VSS.n315 0.0755
R3077 VSS.n316 VSS.n267 0.0755
R3078 VSS.n324 VSS.n267 0.0755
R3079 VSS.n325 VSS.n324 0.0755
R3080 VSS.n465 VSS.n325 0.0755
R3081 VSS.n465 VSS.n464 0.0755
R3082 VSS.n464 VSS.n326 0.0755
R3083 VSS.n456 VSS.n326 0.0755
R3084 VSS.n456 VSS.n455 0.0755
R3085 VSS.n455 VSS.n335 0.0755
R3086 VSS.n339 VSS.n335 0.0755
R3087 VSS.n445 VSS.n339 0.0755
R3088 VSS.n445 VSS.n444 0.0755
R3089 VSS.n444 VSS.n340 0.0755
R3090 VSS.n437 VSS.n340 0.0755
R3091 VSS.n437 VSS.n436 0.0755
R3092 VSS.n436 VSS.n344 0.0755
R3093 VSS.n429 VSS.n344 0.0755
R3094 VSS.n429 VSS.n428 0.0755
R3095 VSS.n428 VSS.n348 0.0755
R3096 VSS.n421 VSS.n348 0.0755
R3097 VSS.n421 VSS.n420 0.0755
R3098 VSS.n420 VSS.n352 0.0755
R3099 VSS.n413 VSS.n352 0.0755
R3100 VSS.n413 VSS.n412 0.0755
R3101 VSS.n412 VSS.n356 0.0755
R3102 VSS.n405 VSS.n356 0.0755
R3103 VSS.n405 VSS.n404 0.0755
R3104 VSS.n404 VSS.n360 0.0755
R3105 VSS.n397 VSS.n360 0.0755
R3106 VSS.n397 VSS.n396 0.0755
R3107 VSS.n396 VSS.n364 0.0755
R3108 VSS.n389 VSS.n364 0.0755
R3109 VSS.n389 VSS.n388 0.0755
R3110 VSS.n388 VSS.n367 0.0755
R3111 VSS.n381 VSS.n367 0.0755
R3112 VSS.n381 VSS.n380 0.0755
R3113 VSS.n380 VSS.n257 0.0755
R3114 VSS.n475 VSS.n257 0.0755
R3115 VSS.n476 VSS.n475 0.0755
R3116 VSS.n476 VSS.n253 0.0755
R3117 VSS.n483 VSS.n253 0.0755
R3118 VSS.n484 VSS.n483 0.0755
R3119 VSS.n484 VSS.n249 0.0755
R3120 VSS.n491 VSS.n249 0.0755
R3121 VSS.n492 VSS.n491 0.0755
R3122 VSS.n492 VSS.n245 0.0755
R3123 VSS.n500 VSS.n245 0.0755
R3124 VSS.n501 VSS.n500 0.0755
R3125 VSS.n501 VSS.n241 0.0755
R3126 VSS.n509 VSS.n241 0.0755
R3127 VSS.n510 VSS.n509 0.0755
R3128 VSS.n510 VSS.n237 0.0755
R3129 VSS.n518 VSS.n237 0.0755
R3130 VSS.n519 VSS.n518 0.0755
R3131 VSS.n719 VSS.n519 0.0755
R3132 VSS.n719 VSS.n718 0.0755
R3133 VSS.n718 VSS.n520 0.0755
R3134 VSS.n711 VSS.n520 0.0755
R3135 VSS.n711 VSS.n710 0.0755
R3136 VSS.n710 VSS.n524 0.0755
R3137 VSS.n528 VSS.n524 0.0755
R3138 VSS.n700 VSS.n528 0.0755
R3139 VSS.n700 VSS.n699 0.0755
R3140 VSS.n699 VSS.n529 0.0755
R3141 VSS.n692 VSS.n529 0.0755
R3142 VSS.n692 VSS.n691 0.0755
R3143 VSS.n691 VSS.n532 0.0755
R3144 VSS.n684 VSS.n532 0.0755
R3145 VSS.n684 VSS.n683 0.0755
R3146 VSS.n683 VSS.n537 0.0755
R3147 VSS.n541 VSS.n537 0.0755
R3148 VSS.n673 VSS.n541 0.0755
R3149 VSS.n673 VSS.n672 0.0755
R3150 VSS.n672 VSS.n542 0.0755
R3151 VSS.n665 VSS.n542 0.0755
R3152 VSS.n665 VSS.n664 0.0755
R3153 VSS.n664 VSS.n545 0.0755
R3154 VSS.n657 VSS.n545 0.0755
R3155 VSS.n657 VSS.n656 0.0755
R3156 VSS.n656 VSS.n550 0.0755
R3157 VSS.n649 VSS.n550 0.0755
R3158 VSS.n649 VSS.n648 0.0755
R3159 VSS.n648 VSS.n553 0.0755
R3160 VSS.n641 VSS.n553 0.0755
R3161 VSS.n641 VSS.n640 0.0755
R3162 VSS.n640 VSS.n558 0.0755
R3163 VSS.n562 VSS.n558 0.0755
R3164 VSS.n630 VSS.n562 0.0755
R3165 VSS.n630 VSS.n629 0.0755
R3166 VSS.n629 VSS.n563 0.0755
R3167 VSS.n622 VSS.n563 0.0755
R3168 VSS.n622 VSS.n621 0.0755
R3169 VSS.n621 VSS.n566 0.0755
R3170 VSS.n614 VSS.n566 0.0755
R3171 VSS.n614 VSS.n613 0.0755
R3172 VSS.n613 VSS.n571 0.0755
R3173 VSS.n606 VSS.n571 0.0755
R3174 VSS.n606 VSS.n605 0.0755
R3175 VSS.n605 VSS.n574 0.0755
R3176 VSS.n598 VSS.n574 0.0755
R3177 VSS.n598 VSS.n597 0.0755
R3178 VSS.n597 VSS.n579 0.0755
R3179 VSS.n583 VSS.n579 0.0755
R3180 VSS.n587 VSS.n583 0.0755
R3181 VSS.n587 VSS.n586 0.0755
R3182 VSS.n586 VSS.n212 0.0755
R3183 VSS.n740 VSS.n212 0.0755
R3184 VSS.n741 VSS.n740 0.0755
R3185 VSS.n741 VSS.n209 0.0755
R3186 VSS.n749 VSS.n209 0.0755
R3187 VSS.n750 VSS.n749 0.0755
R3188 VSS.n750 VSS.n205 0.0755
R3189 VSS.n757 VSS.n205 0.0755
R3190 VSS.n758 VSS.n757 0.0755
R3191 VSS.n758 VSS.n200 0.0755
R3192 VSS.n766 VSS.n200 0.0755
R3193 VSS.n767 VSS.n766 0.0755
R3194 VSS.n767 VSS.n196 0.0755
R3195 VSS.n775 VSS.n196 0.0755
R3196 VSS.n776 VSS.n775 0.0755
R3197 VSS.n776 VSS.n191 0.0755
R3198 VSS.n783 VSS.n191 0.0755
R3199 VSS.n784 VSS.n783 0.0755
R3200 VSS.n784 VSS.n187 0.0755
R3201 VSS.n791 VSS.n187 0.0755
R3202 VSS.n289 VSS.n281 0.0755
R3203 VSS.n294 VSS.n281 0.0755
R3204 VSS.n295 VSS.n294 0.0755
R3205 VSS.n295 VSS.n277 0.0755
R3206 VSS.n302 VSS.n277 0.0755
R3207 VSS.n304 VSS.n273 0.0755
R3208 VSS.n311 VSS.n273 0.0755
R3209 VSS.n312 VSS.n311 0.0755
R3210 VSS.n312 VSS.n269 0.0755
R3211 VSS.n319 VSS.n269 0.0755
R3212 VSS.n320 VSS.n319 0.0755
R3213 VSS.n320 VSS.n263 0.0755
R3214 VSS.n468 VSS.n264 0.0755
R3215 VSS.n461 VSS.n264 0.0755
R3216 VSS.n459 VSS.n333 0.0755
R3217 VSS.n452 VSS.n333 0.0755
R3218 VSS.n449 VSS.n448 0.0755
R3219 VSS.n448 VSS.n337 0.0755
R3220 VSS.n441 VSS.n337 0.0755
R3221 VSS.n441 VSS.n440 0.0755
R3222 VSS.n440 VSS.n342 0.0755
R3223 VSS.n433 VSS.n342 0.0755
R3224 VSS.n433 VSS.n432 0.0755
R3225 VSS.n432 VSS.n346 0.0755
R3226 VSS.n425 VSS.n346 0.0755
R3227 VSS.n425 VSS.n424 0.0755
R3228 VSS.n424 VSS.n350 0.0755
R3229 VSS.n417 VSS.n350 0.0755
R3230 VSS.n417 VSS.n416 0.0755
R3231 VSS.n416 VSS.n354 0.0755
R3232 VSS.n409 VSS.n354 0.0755
R3233 VSS.n409 VSS.n408 0.0755
R3234 VSS.n408 VSS.n358 0.0755
R3235 VSS.n401 VSS.n358 0.0755
R3236 VSS.n401 VSS.n400 0.0755
R3237 VSS.n400 VSS.n362 0.0755
R3238 VSS.n393 VSS.n362 0.0755
R3239 VSS.n393 VSS.n392 0.0755
R3240 VSS.n385 VSS.n369 0.0755
R3241 VSS.n385 VSS.n384 0.0755
R3242 VSS.n376 VSS.n259 0.0755
R3243 VSS.n472 VSS.n259 0.0755
R3244 VSS.n479 VSS.n255 0.0755
R3245 VSS.n480 VSS.n479 0.0755
R3246 VSS.n480 VSS.n251 0.0755
R3247 VSS.n487 VSS.n251 0.0755
R3248 VSS.n488 VSS.n487 0.0755
R3249 VSS.n488 VSS.n247 0.0755
R3250 VSS.n495 VSS.n247 0.0755
R3251 VSS.n497 VSS.n495 0.0755
R3252 VSS.n497 VSS.n496 0.0755
R3253 VSS.n506 VSS.n504 0.0755
R3254 VSS.n506 VSS.n505 0.0755
R3255 VSS.n514 VSS.n513 0.0755
R3256 VSS.n514 VSS.n233 0.0755
R3257 VSS.n722 VSS.n234 0.0755
R3258 VSS.n715 VSS.n234 0.0755
R3259 VSS.n715 VSS.n714 0.0755
R3260 VSS.n714 VSS.n522 0.0755
R3261 VSS.n707 VSS.n522 0.0755
R3262 VSS.n704 VSS.n703 0.0755
R3263 VSS.n703 VSS.n526 0.0755
R3264 VSS.n696 VSS.n526 0.0755
R3265 VSS.n696 VSS.n695 0.0755
R3266 VSS.n688 VSS.n534 0.0755
R3267 VSS.n688 VSS.n687 0.0755
R3268 VSS.n687 VSS.n535 0.0755
R3269 VSS.n680 VSS.n535 0.0755
R3270 VSS.n677 VSS.n676 0.0755
R3271 VSS.n676 VSS.n539 0.0755
R3272 VSS.n669 VSS.n539 0.0755
R3273 VSS.n669 VSS.n668 0.0755
R3274 VSS.n661 VSS.n547 0.0755
R3275 VSS.n661 VSS.n660 0.0755
R3276 VSS.n660 VSS.n548 0.0755
R3277 VSS.n653 VSS.n548 0.0755
R3278 VSS.n653 VSS.n652 0.0755
R3279 VSS.n645 VSS.n555 0.0755
R3280 VSS.n645 VSS.n644 0.0755
R3281 VSS.n644 VSS.n556 0.0755
R3282 VSS.n637 VSS.n556 0.0755
R3283 VSS.n634 VSS.n633 0.0755
R3284 VSS.n633 VSS.n560 0.0755
R3285 VSS.n626 VSS.n560 0.0755
R3286 VSS.n626 VSS.n625 0.0755
R3287 VSS.n618 VSS.n568 0.0755
R3288 VSS.n618 VSS.n617 0.0755
R3289 VSS.n617 VSS.n569 0.0755
R3290 VSS.n610 VSS.n569 0.0755
R3291 VSS.n610 VSS.n609 0.0755
R3292 VSS.n602 VSS.n576 0.0755
R3293 VSS.n602 VSS.n601 0.0755
R3294 VSS.n601 VSS.n577 0.0755
R3295 VSS.n594 VSS.n577 0.0755
R3296 VSS.n591 VSS.n590 0.0755
R3297 VSS.n590 VSS.n581 0.0755
R3298 VSS.n581 VSS.n214 0.0755
R3299 VSS.n737 VSS.n214 0.0755
R3300 VSS.n746 VSS.n207 0.0755
R3301 VSS.n753 VSS.n207 0.0755
R3302 VSS.n754 VSS.n753 0.0755
R3303 VSS.n754 VSS.n203 0.0755
R3304 VSS.n761 VSS.n203 0.0755
R3305 VSS.n763 VSS.n198 0.0755
R3306 VSS.n770 VSS.n198 0.0755
R3307 VSS.n772 VSS.n770 0.0755
R3308 VSS.n772 VSS.n771 0.0755
R3309 VSS.n780 VSS.n779 0.0755
R3310 VSS.n780 VSS.n189 0.0755
R3311 VSS.n787 VSS.n189 0.0755
R3312 VSS.n788 VSS.n787 0.0755
R3313 VSS.n898 VSS.n183 0.0755
R3314 VSS.n891 VSS.n183 0.0755
R3315 VSS.n889 VSS.n799 0.0755
R3316 VSS.n882 VSS.n881 0.0755
R3317 VSS.n874 VSS.n808 0.0755
R3318 VSS.n874 VSS.n873 0.0755
R3319 VSS.n866 VSS.n813 0.0755
R3320 VSS.n864 VSS.n818 0.0755
R3321 VSS.n855 VSS.n854 0.0755
R3322 VSS.n854 VSS.n823 0.0755
R3323 VSS.n847 VSS.n823 0.0755
R3324 VSS.n844 VSS.n843 0.0755
R3325 VSS.n843 VSS.n828 0.0755
R3326 VSS.n836 VSS.n828 0.0755
R3327 VSS.n1035 VSS.n2 0.0755
R3328 VSS.n1035 VSS.n1034 0.0755
R3329 VSS.n1027 VSS.n8 0.0755
R3330 VSS.n1027 VSS.n1026 0.0755
R3331 VSS.n1026 VSS.n9 0.0755
R3332 VSS.n1019 VSS.n1018 0.0755
R3333 VSS.n1018 VSS.n14 0.0755
R3334 VSS.n1011 VSS.n14 0.0755
R3335 VSS.n1011 VSS.n1010 0.0755
R3336 VSS.n1010 VSS.n18 0.0755
R3337 VSS.n22 VSS.n18 0.0755
R3338 VSS.n1001 VSS.n22 0.0755
R3339 VSS.n999 VSS.n23 0.0755
R3340 VSS.n992 VSS.n23 0.0755
R3341 VSS.n992 VSS.n991 0.0755
R3342 VSS.n991 VSS.n27 0.0755
R3343 VSS.n984 VSS.n983 0.0755
R3344 VSS.n983 VSS.n32 0.0755
R3345 VSS.n976 VSS.n32 0.0755
R3346 VSS.n103 VSS.n40 0.0755
R3347 VSS.n103 VSS.n102 0.0755
R3348 VSS.n102 VSS.n41 0.0755
R3349 VSS.n95 VSS.n41 0.0755
R3350 VSS.n95 VSS.n94 0.0755
R3351 VSS.n87 VSS.n49 0.0755
R3352 VSS.n87 VSS.n86 0.0755
R3353 VSS.n86 VSS.n50 0.0755
R3354 VSS.n79 VSS.n50 0.0755
R3355 VSS.n77 VSS.n58 0.0755
R3356 VSS.n70 VSS.n58 0.0755
R3357 VSS.n70 VSS.n69 0.0755
R3358 VSS.n69 VSS.n62 0.0755
R3359 VSS.n968 VSS.n967 0.0755
R3360 VSS.n967 VSS.n113 0.0755
R3361 VSS.n963 VSS.n113 0.0755
R3362 VSS.n963 VSS.n962 0.0755
R3363 VSS.n962 VSS.n961 0.0755
R3364 VSS.n961 VSS.n115 0.0755
R3365 VSS.n957 VSS.n115 0.0755
R3366 VSS.n966 VSS.n112 0.0755
R3367 VSS.n966 VSS.n965 0.0755
R3368 VSS.n965 VSS.n964 0.0755
R3369 VSS.n964 VSS.n114 0.0755
R3370 VSS.n960 VSS.n114 0.0755
R3371 VSS.n960 VSS.n959 0.0755
R3372 VSS.n959 VSS.n958 0.0755
R3373 VSS.n895 VSS.n894 0.0755
R3374 VSS.n894 VSS.n796 0.0755
R3375 VSS.n886 VSS.n796 0.0755
R3376 VSS.n886 VSS.n885 0.0755
R3377 VSS.n885 VSS.n801 0.0755
R3378 VSS.n878 VSS.n801 0.0755
R3379 VSS.n878 VSS.n877 0.0755
R3380 VSS.n877 VSS.n806 0.0755
R3381 VSS.n870 VSS.n806 0.0755
R3382 VSS.n870 VSS.n869 0.0755
R3383 VSS.n869 VSS.n811 0.0755
R3384 VSS.n861 VSS.n811 0.0755
R3385 VSS.n861 VSS.n860 0.0755
R3386 VSS.n860 VSS.n820 0.0755
R3387 VSS.n851 VSS.n820 0.0755
R3388 VSS.n851 VSS.n850 0.0755
R3389 VSS.n850 VSS.n826 0.0755
R3390 VSS.n830 VSS.n826 0.0755
R3391 VSS.n840 VSS.n830 0.0755
R3392 VSS.n840 VSS.n839 0.0755
R3393 VSS.n839 VSS.n832 0.0755
R3394 VSS.n832 VSS.n831 0.0755
R3395 VSS.n831 VSS.n5 0.0755
R3396 VSS.n1031 VSS.n5 0.0755
R3397 VSS.n1031 VSS.n1030 0.0755
R3398 VSS.n1030 VSS.n6 0.0755
R3399 VSS.n1023 VSS.n6 0.0755
R3400 VSS.n1022 VSS.n11 0.0755
R3401 VSS.n1015 VSS.n11 0.0755
R3402 VSS.n1015 VSS.n1014 0.0755
R3403 VSS.n136 VSS.n126 0.0741875
R3404 VSS.n771 VSS.n194 0.07325
R3405 VSS.n957 VSS.n956 0.072875
R3406 VSS.n794 VSS.n793 0.0725
R3407 VSS.n897 VSS.n896 0.0725
R3408 VSS.n893 VSS.n795 0.0725
R3409 VSS.n892 VSS.n797 0.0725
R3410 VSS.n888 VSS.n887 0.0725
R3411 VSS.n884 VSS.n800 0.0725
R3412 VSS.n883 VSS.n802 0.0725
R3413 VSS.n880 VSS.n879 0.0725
R3414 VSS.n876 VSS.n805 0.0725
R3415 VSS.n875 VSS.n807 0.0725
R3416 VSS.n872 VSS.n871 0.0725
R3417 VSS.n868 VSS.n810 0.0725
R3418 VSS.n867 VSS.n812 0.0725
R3419 VSS.n863 VSS.n862 0.0725
R3420 VSS.n859 VSS.n819 0.0725
R3421 VSS.n853 VSS.n824 0.07175
R3422 VSS.n852 VSS.n825 0.07175
R3423 VSS.n849 VSS.n848 0.07175
R3424 VSS.n846 VSS.n845 0.07175
R3425 VSS.n842 VSS.n827 0.07175
R3426 VSS.n841 VSS.n829 0.07175
R3427 VSS.n838 VSS.n837 0.07175
R3428 VSS.n834 VSS.n833 0.07175
R3429 VSS.n1033 VSS.n1 0.07175
R3430 VSS.n1032 VSS.n4 0.07175
R3431 VSS.n1029 VSS.n1028 0.07175
R3432 VSS.n1025 VSS.n7 0.07175
R3433 VSS.n1024 VSS.n10 0.07175
R3434 VSS.n1021 VSS.n1020 0.07175
R3435 VSS.n1017 VSS.n12 0.07175
R3436 VSS.n1016 VSS.n15 0.07175
R3437 VSS.n1013 VSS.n1012 0.07175
R3438 VSS.n1009 VSS.n17 0.07175
R3439 VSS.n1008 VSS.n1007 0.07175
R3440 VSS.n1006 VSS.n19 0.07175
R3441 VSS.n1003 VSS.n1002 0.07175
R3442 VSS.n998 VSS.n21 0.07175
R3443 VSS.n997 VSS.n24 0.07175
R3444 VSS.n994 VSS.n993 0.07175
R3445 VSS.n990 VSS.n26 0.07175
R3446 VSS.n989 VSS.n28 0.07175
R3447 VSS.n986 VSS.n985 0.07175
R3448 VSS.n982 VSS.n30 0.07175
R3449 VSS.n981 VSS.n33 0.07175
R3450 VSS.n978 VSS.n977 0.07175
R3451 VSS.n109 VSS.n35 0.07175
R3452 VSS.n108 VSS.n37 0.07175
R3453 VSS.n105 VSS.n104 0.07175
R3454 VSS.n101 VSS.n39 0.07175
R3455 VSS.n100 VSS.n42 0.07175
R3456 VSS.n97 VSS.n96 0.07175
R3457 VSS.n93 VSS.n44 0.07175
R3458 VSS.n92 VSS.n46 0.07175
R3459 VSS.n89 VSS.n88 0.07175
R3460 VSS.n85 VSS.n48 0.07175
R3461 VSS.n84 VSS.n51 0.07175
R3462 VSS.n81 VSS.n80 0.07175
R3463 VSS.n76 VSS.n53 0.07175
R3464 VSS.n75 VSS.n59 0.07175
R3465 VSS.n72 VSS.n71 0.07175
R3466 VSS.n68 VSS.n61 0.07175
R3467 VSS.n67 VSS.n63 0.07175
R3468 VSS.n576 VSS.n218 0.071375
R3469 VSS.n49 VSS.n45 0.071375
R3470 VSS.n668 VSS.n226 0.070625
R3471 VSS.n763 VSS.n762 0.069875
R3472 VSS.n858 VSS.n821 0.06875
R3473 VSS.n704 VSS.n232 0.068375
R3474 VSS.n813 VSS.n809 0.068375
R3475 VSS.n1034 VSS.n3 0.0665
R3476 VSS.n304 VSS.n303 0.0659375
R3477 VSS.n835 VSS.n2 0.06575
R3478 VSS.n185 VSS.n184 0.0648125
R3479 VSS.n452 VSS.n260 0.063875
R3480 VSS.n1014 VSS.n16 0.062375
R3481 VSS.n723 VSS.n233 0.0621875
R3482 VSS.n376 VSS.n375 0.062
R3483 VSS.n881 VSS.n804 0.061625
R3484 VSS.n746 VSS.n745 0.0614375
R3485 VSS.n950 VSS.n949 0.0610625
R3486 VSS.n953 VSS.n117 0.0605
R3487 VSS.n976 VSS.n975 0.05975
R3488 VSS.n555 VSS.n224 0.059375
R3489 VSS VSS.n0 0.059
R3490 VSS.n1023 VSS 0.059
R3491 VSS.n1000 VSS.n999 0.0588125
R3492 VSS.n625 VSS.n220 0.058625
R3493 VSS.n110 VSS.n36 0.058625
R3494 VSS.n930 VSS.n123 0.0584375
R3495 VSS.n798 VSS.t166 0.0579406
R3496 VSS.t164 VSS.n798 0.0579406
R3497 VSS.n814 VSS.t164 0.0579406
R3498 VSS.t162 VSS.n814 0.0579406
R3499 VSS.n815 VSS.t162 0.0579406
R3500 VSS.t160 VSS.n815 0.0579406
R3501 VSS.n816 VSS.t160 0.0579406
R3502 VSS.t158 VSS.n816 0.0579406
R3503 VSS.n817 VSS.t158 0.0579406
R3504 VSS.t156 VSS.n817 0.0579406
R3505 VSS.n890 VSS.n889 0.056375
R3506 VSS.n138 VSS.n137 0.0543125
R3507 VSS.n150 VSS.n149 0.0530253
R3508 VSS.n148 VSS.n146 0.0530253
R3509 VSS.n914 VSS.n150 0.0528944
R3510 VSS.n152 VSS.n146 0.0528943
R3511 VSS.n939 VSS.n121 0.051875
R3512 VSS.n472 VSS.n471 0.051875
R3513 VSS.n513 VSS.n239 0.051125
R3514 VSS.n290 VSS.n282 0.0510348
R3515 VSS.n591 VSS.n216 0.050375
R3516 VSS.n78 VSS.n77 0.050375
R3517 VSS.n460 VSS.n459 0.05
R3518 VSS.n292 VSS.n282 0.049625
R3519 VSS.n293 VSS.n280 0.049625
R3520 VSS.n297 VSS.n296 0.049625
R3521 VSS.n300 VSS.n278 0.049625
R3522 VSS.n301 VSS.n276 0.049625
R3523 VSS.n306 VSS.n305 0.049625
R3524 VSS.n309 VSS.n274 0.049625
R3525 VSS.n310 VSS.n272 0.049625
R3526 VSS.n314 VSS.n313 0.049625
R3527 VSS.n317 VSS.n270 0.049625
R3528 VSS.n318 VSS.n268 0.049625
R3529 VSS.n323 VSS.n321 0.049625
R3530 VSS.n322 VSS.n265 0.049625
R3531 VSS.n467 VSS.n466 0.049625
R3532 VSS.n463 VSS.n266 0.049625
R3533 VSS.n462 VSS.n327 0.049625
R3534 VSS.n458 VSS.n457 0.049625
R3535 VSS.n454 VSS.n334 0.049625
R3536 VSS.n453 VSS.n451 0.049625
R3537 VSS.n450 VSS.n336 0.049625
R3538 VSS.n447 VSS.n446 0.049625
R3539 VSS.n443 VSS.n338 0.049625
R3540 VSS.n442 VSS.n341 0.049625
R3541 VSS.n439 VSS.n438 0.049625
R3542 VSS.n435 VSS.n343 0.049625
R3543 VSS.n434 VSS.n345 0.049625
R3544 VSS.n431 VSS.n430 0.049625
R3545 VSS.n427 VSS.n347 0.049625
R3546 VSS.n426 VSS.n349 0.049625
R3547 VSS.n423 VSS.n422 0.049625
R3548 VSS.n419 VSS.n351 0.049625
R3549 VSS.n418 VSS.n353 0.049625
R3550 VSS.n415 VSS.n414 0.049625
R3551 VSS.n411 VSS.n355 0.049625
R3552 VSS.n410 VSS.n357 0.049625
R3553 VSS.n407 VSS.n406 0.049625
R3554 VSS.n403 VSS.n359 0.049625
R3555 VSS.n402 VSS.n361 0.049625
R3556 VSS.n399 VSS.n398 0.049625
R3557 VSS.n395 VSS.n363 0.049625
R3558 VSS.n394 VSS.n365 0.049625
R3559 VSS.n391 VSS.n390 0.049625
R3560 VSS.n387 VSS.n366 0.049625
R3561 VSS.n386 VSS.n368 0.049625
R3562 VSS.n383 VSS.n382 0.049625
R3563 VSS.n379 VSS.n377 0.049625
R3564 VSS.n378 VSS.n258 0.049625
R3565 VSS.n474 VSS.n473 0.049625
R3566 VSS.n477 VSS.n256 0.049625
R3567 VSS.n478 VSS.n254 0.049625
R3568 VSS.n482 VSS.n481 0.049625
R3569 VSS.n485 VSS.n252 0.049625
R3570 VSS.n486 VSS.n250 0.049625
R3571 VSS.n490 VSS.n489 0.049625
R3572 VSS.n493 VSS.n248 0.049625
R3573 VSS.n494 VSS.n246 0.049625
R3574 VSS.n499 VSS.n498 0.049625
R3575 VSS.n502 VSS.n244 0.049625
R3576 VSS.n503 VSS.n242 0.049625
R3577 VSS.n508 VSS.n507 0.049625
R3578 VSS.n511 VSS.n240 0.049625
R3579 VSS.n512 VSS.n238 0.049625
R3580 VSS.n517 VSS.n515 0.049625
R3581 VSS.n516 VSS.n235 0.049625
R3582 VSS.n721 VSS.n720 0.049625
R3583 VSS.n717 VSS.n236 0.049625
R3584 VSS.n716 VSS.n521 0.049625
R3585 VSS.n713 VSS.n712 0.049625
R3586 VSS.n709 VSS.n523 0.049625
R3587 VSS.n708 VSS.n706 0.049625
R3588 VSS.n705 VSS.n525 0.049625
R3589 VSS.n702 VSS.n701 0.049625
R3590 VSS.n698 VSS.n527 0.049625
R3591 VSS.n697 VSS.n530 0.049625
R3592 VSS.n694 VSS.n693 0.049625
R3593 VSS.n690 VSS.n531 0.049625
R3594 VSS.n689 VSS.n533 0.049625
R3595 VSS.n686 VSS.n685 0.049625
R3596 VSS.n682 VSS.n536 0.049625
R3597 VSS.n681 VSS.n679 0.049625
R3598 VSS.n678 VSS.n538 0.049625
R3599 VSS.n675 VSS.n674 0.049625
R3600 VSS.n671 VSS.n540 0.049625
R3601 VSS.n670 VSS.n543 0.049625
R3602 VSS.n667 VSS.n666 0.049625
R3603 VSS.n663 VSS.n544 0.049625
R3604 VSS.n662 VSS.n546 0.049625
R3605 VSS.n659 VSS.n658 0.049625
R3606 VSS.n655 VSS.n549 0.049625
R3607 VSS.n654 VSS.n551 0.049625
R3608 VSS.n651 VSS.n650 0.049625
R3609 VSS.n647 VSS.n552 0.049625
R3610 VSS.n646 VSS.n554 0.049625
R3611 VSS.n643 VSS.n642 0.049625
R3612 VSS.n639 VSS.n557 0.049625
R3613 VSS.n638 VSS.n636 0.049625
R3614 VSS.n635 VSS.n559 0.049625
R3615 VSS.n632 VSS.n631 0.049625
R3616 VSS.n628 VSS.n561 0.049625
R3617 VSS.n627 VSS.n564 0.049625
R3618 VSS.n624 VSS.n623 0.049625
R3619 VSS.n620 VSS.n565 0.049625
R3620 VSS.n619 VSS.n567 0.049625
R3621 VSS.n616 VSS.n615 0.049625
R3622 VSS.n612 VSS.n570 0.049625
R3623 VSS.n611 VSS.n572 0.049625
R3624 VSS.n608 VSS.n607 0.049625
R3625 VSS.n604 VSS.n573 0.049625
R3626 VSS.n603 VSS.n575 0.049625
R3627 VSS.n600 VSS.n599 0.049625
R3628 VSS.n596 VSS.n578 0.049625
R3629 VSS.n595 VSS.n593 0.049625
R3630 VSS.n592 VSS.n580 0.049625
R3631 VSS.n589 VSS.n588 0.049625
R3632 VSS.n585 VSS.n582 0.049625
R3633 VSS.n584 VSS.n213 0.049625
R3634 VSS.n739 VSS.n738 0.049625
R3635 VSS.n742 VSS.n211 0.049625
R3636 VSS.n680 VSS.n228 0.049625
R3637 VSS.n822 VSS.n818 0.0490625
R3638 VSS.n13 VSS.n9 0.04775
R3639 VSS.n534 VSS.n230 0.047375
R3640 VSS.n865 VSS.n864 0.047375
R3641 VSS.n469 VSS.n263 0.046625
R3642 VSS.n744 VSS.n151 0.04625
R3643 VSS.n737 VSS.n736 0.0460625
R3644 VSS.n64 VSS.n62 0.0460625
R3645 VSS.n847 VSS.n143 0.045875
R3646 VSS.n743 VSS.n210 0.0455
R3647 VSS.n748 VSS.n747 0.0455
R3648 VSS.n751 VSS.n208 0.0455
R3649 VSS.n752 VSS.n206 0.0455
R3650 VSS.n756 VSS.n755 0.0455
R3651 VSS.n759 VSS.n204 0.0455
R3652 VSS.n760 VSS.n201 0.0455
R3653 VSS.n765 VSS.n764 0.0455
R3654 VSS.n768 VSS.n199 0.0455
R3655 VSS.n769 VSS.n197 0.0455
R3656 VSS.n774 VSS.n773 0.0455
R3657 VSS.n777 VSS.n195 0.0455
R3658 VSS.n778 VSS.n192 0.0455
R3659 VSS.n782 VSS.n781 0.0455
R3660 VSS.n785 VSS.n190 0.0455
R3661 VSS.n786 VSS.n188 0.0455
R3662 VSS.n790 VSS.n789 0.0455
R3663 VSS.n792 VSS.n186 0.0455
R3664 VSS.n185 VSS.n154 0.0441875
R3665 VSS.n139 VSS.n138 0.042125
R3666 VSS.n131 VSS.n128 0.041375
R3667 VSS.n369 VSS.n262 0.041375
R3668 VSS.n803 VSS.n799 0.040625
R3669 VSS.n65 VSS.n63 0.039791
R3670 VSS.n496 VSS.n243 0.0389375
R3671 VSS.n634 VSS.n222 0.038375
R3672 VSS.n984 VSS.n31 0.038375
R3673 VSS.n637 VSS.n222 0.037625
R3674 VSS.n900 VSS.n182 0.037625
R3675 VSS.n31 VSS.n27 0.037625
R3676 VSS.n504 VSS.n243 0.0370625
R3677 VSS.n900 VSS.n899 0.0370625
R3678 VSS.n937 VSS.n936 0.036875
R3679 VSS.n944 VSS.n118 0.036875
R3680 VSS.n917 VSS.n147 0.0368636
R3681 VSS.n147 VSS.n145 0.0368636
R3682 VSS.n911 VSS.n154 0.0368636
R3683 VSS.n911 VSS.n910 0.0368636
R3684 VSS.t30 VSS.n231 0.0363974
R3685 VSS.n231 VSS.t28 0.0363974
R3686 VSS.t28 VSS.n229 0.0363974
R3687 VSS.n229 VSS.t14 0.0363974
R3688 VSS.t14 VSS.n227 0.0363974
R3689 VSS.n227 VSS.t26 0.0363974
R3690 VSS.t26 VSS.n225 0.0363974
R3691 VSS.n225 VSS.t24 0.0363974
R3692 VSS.t24 VSS.n223 0.0363974
R3693 VSS.n223 VSS.t22 0.0363974
R3694 VSS.t22 VSS.n221 0.0363974
R3695 VSS.n221 VSS.t20 0.0363974
R3696 VSS.t20 VSS.n219 0.0363974
R3697 VSS.n219 VSS.t18 0.0363974
R3698 VSS.t18 VSS.n217 0.0363974
R3699 VSS.n217 VSS.t12 0.0363974
R3700 VSS.t12 VSS.n215 0.0363974
R3701 VSS.n215 VSS.t10 0.0363974
R3702 VSS.n54 VSS.t129 0.0363974
R3703 VSS.t127 VSS.n54 0.0363974
R3704 VSS.n55 VSS.t127 0.0363974
R3705 VSS.t125 VSS.n55 0.0363974
R3706 VSS.n56 VSS.t125 0.0363974
R3707 VSS.t123 VSS.n56 0.0363974
R3708 VSS.n57 VSS.t123 0.0363974
R3709 VSS.t121 VSS.n57 0.0363974
R3710 VSS.n970 VSS.n969 0.0363125
R3711 VSS.n975 VSS.n974 0.0358741
R3712 VSS.n974 VSS.n973 0.0358741
R3713 VSS.n882 VSS.n803 0.035375
R3714 VSS.n856 VSS.n855 0.035375
R3715 VSS.n392 VSS.n262 0.034625
R3716 VSS.n931 VSS.n139 0.033875
R3717 VSS.n735 VSS.n151 0.033875
R3718 VSS.n857 VSS.n856 0.033875
R3719 VSS.n788 VSS.n154 0.0318125
R3720 VSS.n743 VSS.n742 0.0305
R3721 VSS.n747 VSS.n210 0.0305
R3722 VSS.n748 VSS.n208 0.0305
R3723 VSS.n752 VSS.n751 0.0305
R3724 VSS.n755 VSS.n206 0.0305
R3725 VSS.n756 VSS.n204 0.0305
R3726 VSS.n760 VSS.n759 0.0305
R3727 VSS.n764 VSS.n201 0.0305
R3728 VSS.n765 VSS.n199 0.0305
R3729 VSS.n769 VSS.n768 0.0305
R3730 VSS.n773 VSS.n197 0.0305
R3731 VSS.n774 VSS.n195 0.0305
R3732 VSS.n778 VSS.n777 0.0305
R3733 VSS.n781 VSS.n192 0.0305
R3734 VSS.n782 VSS.n190 0.0305
R3735 VSS.n786 VSS.n785 0.0305
R3736 VSS.n789 VSS.n188 0.0305
R3737 VSS.n790 VSS.n186 0.0305
R3738 VSS.n793 VSS.n792 0.0305
R3739 VSS.n844 VSS.n143 0.030125
R3740 VSS.n736 VSS.n735 0.0299375
R3741 VSS.n469 VSS.n468 0.029375
R3742 VSS.n945 VSS.n944 0.0288125
R3743 VSS.n695 VSS.n230 0.028625
R3744 VSS.n866 VSS.n865 0.028625
R3745 VSS.n1019 VSS.n13 0.02825
R3746 VSS.n857 VSS.n822 0.0269375
R3747 VSS.n293 VSS.n292 0.026375
R3748 VSS.n296 VSS.n280 0.026375
R3749 VSS.n297 VSS.n278 0.026375
R3750 VSS.n301 VSS.n300 0.026375
R3751 VSS.n305 VSS.n276 0.026375
R3752 VSS.n306 VSS.n274 0.026375
R3753 VSS.n310 VSS.n309 0.026375
R3754 VSS.n313 VSS.n272 0.026375
R3755 VSS.n314 VSS.n270 0.026375
R3756 VSS.n318 VSS.n317 0.026375
R3757 VSS.n321 VSS.n268 0.026375
R3758 VSS.n323 VSS.n322 0.026375
R3759 VSS.n467 VSS.n265 0.026375
R3760 VSS.n466 VSS.n266 0.026375
R3761 VSS.n463 VSS.n462 0.026375
R3762 VSS.n458 VSS.n327 0.026375
R3763 VSS.n457 VSS.n334 0.026375
R3764 VSS.n454 VSS.n453 0.026375
R3765 VSS.n451 VSS.n450 0.026375
R3766 VSS.n447 VSS.n336 0.026375
R3767 VSS.n446 VSS.n338 0.026375
R3768 VSS.n443 VSS.n442 0.026375
R3769 VSS.n439 VSS.n341 0.026375
R3770 VSS.n438 VSS.n343 0.026375
R3771 VSS.n435 VSS.n434 0.026375
R3772 VSS.n431 VSS.n345 0.026375
R3773 VSS.n430 VSS.n347 0.026375
R3774 VSS.n427 VSS.n426 0.026375
R3775 VSS.n423 VSS.n349 0.026375
R3776 VSS.n422 VSS.n351 0.026375
R3777 VSS.n419 VSS.n418 0.026375
R3778 VSS.n415 VSS.n353 0.026375
R3779 VSS.n414 VSS.n355 0.026375
R3780 VSS.n411 VSS.n410 0.026375
R3781 VSS.n407 VSS.n357 0.026375
R3782 VSS.n406 VSS.n359 0.026375
R3783 VSS.n403 VSS.n402 0.026375
R3784 VSS.n399 VSS.n361 0.026375
R3785 VSS.n398 VSS.n363 0.026375
R3786 VSS.n395 VSS.n394 0.026375
R3787 VSS.n391 VSS.n365 0.026375
R3788 VSS.n390 VSS.n366 0.026375
R3789 VSS.n387 VSS.n386 0.026375
R3790 VSS.n383 VSS.n368 0.026375
R3791 VSS.n382 VSS.n377 0.026375
R3792 VSS.n379 VSS.n378 0.026375
R3793 VSS.n473 VSS.n258 0.026375
R3794 VSS.n474 VSS.n256 0.026375
R3795 VSS.n478 VSS.n477 0.026375
R3796 VSS.n481 VSS.n254 0.026375
R3797 VSS.n482 VSS.n252 0.026375
R3798 VSS.n486 VSS.n485 0.026375
R3799 VSS.n489 VSS.n250 0.026375
R3800 VSS.n490 VSS.n248 0.026375
R3801 VSS.n494 VSS.n493 0.026375
R3802 VSS.n498 VSS.n246 0.026375
R3803 VSS.n499 VSS.n244 0.026375
R3804 VSS.n503 VSS.n502 0.026375
R3805 VSS.n507 VSS.n242 0.026375
R3806 VSS.n508 VSS.n240 0.026375
R3807 VSS.n512 VSS.n511 0.026375
R3808 VSS.n515 VSS.n238 0.026375
R3809 VSS.n517 VSS.n516 0.026375
R3810 VSS.n721 VSS.n235 0.026375
R3811 VSS.n720 VSS.n236 0.026375
R3812 VSS.n717 VSS.n716 0.026375
R3813 VSS.n713 VSS.n521 0.026375
R3814 VSS.n712 VSS.n523 0.026375
R3815 VSS.n709 VSS.n708 0.026375
R3816 VSS.n706 VSS.n705 0.026375
R3817 VSS.n702 VSS.n525 0.026375
R3818 VSS.n701 VSS.n527 0.026375
R3819 VSS.n698 VSS.n697 0.026375
R3820 VSS.n694 VSS.n530 0.026375
R3821 VSS.n693 VSS.n531 0.026375
R3822 VSS.n690 VSS.n689 0.026375
R3823 VSS.n686 VSS.n533 0.026375
R3824 VSS.n685 VSS.n536 0.026375
R3825 VSS.n682 VSS.n681 0.026375
R3826 VSS.n679 VSS.n678 0.026375
R3827 VSS.n675 VSS.n538 0.026375
R3828 VSS.n674 VSS.n540 0.026375
R3829 VSS.n671 VSS.n670 0.026375
R3830 VSS.n667 VSS.n543 0.026375
R3831 VSS.n666 VSS.n544 0.026375
R3832 VSS.n663 VSS.n662 0.026375
R3833 VSS.n659 VSS.n546 0.026375
R3834 VSS.n658 VSS.n549 0.026375
R3835 VSS.n655 VSS.n654 0.026375
R3836 VSS.n651 VSS.n551 0.026375
R3837 VSS.n650 VSS.n552 0.026375
R3838 VSS.n647 VSS.n646 0.026375
R3839 VSS.n643 VSS.n554 0.026375
R3840 VSS.n642 VSS.n557 0.026375
R3841 VSS.n639 VSS.n638 0.026375
R3842 VSS.n636 VSS.n635 0.026375
R3843 VSS.n632 VSS.n559 0.026375
R3844 VSS.n631 VSS.n561 0.026375
R3845 VSS.n628 VSS.n627 0.026375
R3846 VSS.n624 VSS.n564 0.026375
R3847 VSS.n623 VSS.n565 0.026375
R3848 VSS.n620 VSS.n619 0.026375
R3849 VSS.n616 VSS.n567 0.026375
R3850 VSS.n615 VSS.n570 0.026375
R3851 VSS.n612 VSS.n611 0.026375
R3852 VSS.n608 VSS.n572 0.026375
R3853 VSS.n607 VSS.n573 0.026375
R3854 VSS.n604 VSS.n603 0.026375
R3855 VSS.n600 VSS.n575 0.026375
R3856 VSS.n599 VSS.n578 0.026375
R3857 VSS.n596 VSS.n595 0.026375
R3858 VSS.n593 VSS.n592 0.026375
R3859 VSS.n589 VSS.n580 0.026375
R3860 VSS.n588 VSS.n582 0.026375
R3861 VSS.n585 VSS.n584 0.026375
R3862 VSS.n738 VSS.n213 0.026375
R3863 VSS.n739 VSS.n211 0.026375
R3864 VSS.n677 VSS.n228 0.026375
R3865 VSS.n461 VSS.n460 0.026
R3866 VSS.n594 VSS.n216 0.025625
R3867 VSS.n79 VSS.n78 0.025625
R3868 VSS.n505 VSS.n239 0.024875
R3869 VSS.n942 VSS.n121 0.024125
R3870 VSS.n471 VSS.n255 0.024125
R3871 VSS.n969 VSS.n968 0.022625
R3872 VSS.n137 VSS.n136 0.0216875
R3873 VSS.n286 VSS.n243 0.0210534
R3874 VSS.n938 VSS.n937 0.0205625
R3875 VSS.n891 VSS.n890 0.019625
R3876 VSS.n936 VSS.n935 0.0190625
R3877 VSS.n931 VSS.n930 0.0175625
R3878 VSS.n568 VSS.n220 0.017375
R3879 VSS.n40 VSS.n36 0.017375
R3880 VSS.n1001 VSS.n1000 0.0171875
R3881 VSS VSS.n1022 0.017
R3882 VSS.n652 VSS.n224 0.016625
R3883 VSS.n975 VSS.n110 0.01625
R3884 VSS.n953 VSS.n951 0.0155
R3885 VSS.n745 VSS.n744 0.0145625
R3886 VSS.n952 VSS.n116 0.0144596
R3887 VSS.n954 VSS.n116 0.0144596
R3888 VSS.n808 VSS.n804 0.014375
R3889 VSS.n384 VSS.n375 0.014
R3890 VSS.n723 VSS.n722 0.0138125
R3891 VSS.n1005 VSS.n16 0.013625
R3892 VSS VSS.n1036 0.01325
R3893 VSS.n449 VSS.n260 0.012125
R3894 VSS.n184 VSS.n182 0.0111875
R3895 VSS.n948 VSS.n118 0.0108125
R3896 VSS.n836 VSS.n835 0.01025
R3897 VSS.n303 VSS.n302 0.0100625
R3898 VSS.n8 VSS.n3 0.0095
R3899 VSS.n707 VSS.n232 0.007625
R3900 VSS.n873 VSS.n809 0.007625
R3901 VSS.n762 VSS.n761 0.006125
R3902 VSS.n547 VSS.n226 0.005375
R3903 VSS.n609 VSS.n218 0.004625
R3904 VSS.n94 VSS.n45 0.004625
R3905 VSS.n824 VSS.n821 0.00425
R3906 VSS.n853 VSS.n852 0.00425
R3907 VSS.n849 VSS.n825 0.00425
R3908 VSS.n848 VSS.n846 0.00425
R3909 VSS.n845 VSS.n827 0.00425
R3910 VSS.n842 VSS.n841 0.00425
R3911 VSS.n838 VSS.n829 0.00425
R3912 VSS.n837 VSS.n834 0.00425
R3913 VSS.n833 VSS.n0 0.00425
R3914 VSS.n1036 VSS.n1 0.00425
R3915 VSS.n1033 VSS.n1032 0.00425
R3916 VSS.n1029 VSS.n4 0.00425
R3917 VSS.n1028 VSS.n7 0.00425
R3918 VSS.n1025 VSS.n1024 0.00425
R3919 VSS.n1021 VSS.n10 0.00425
R3920 VSS.n1020 VSS.n12 0.00425
R3921 VSS.n1017 VSS.n1016 0.00425
R3922 VSS.n1013 VSS.n15 0.00425
R3923 VSS.n1012 VSS.n17 0.00425
R3924 VSS.n1009 VSS.n1008 0.00425
R3925 VSS.n1007 VSS.n1006 0.00425
R3926 VSS.n1003 VSS.n19 0.00425
R3927 VSS.n1002 VSS.n21 0.00425
R3928 VSS.n998 VSS.n997 0.00425
R3929 VSS.n994 VSS.n24 0.00425
R3930 VSS.n993 VSS.n26 0.00425
R3931 VSS.n990 VSS.n989 0.00425
R3932 VSS.n986 VSS.n28 0.00425
R3933 VSS.n985 VSS.n30 0.00425
R3934 VSS.n982 VSS.n981 0.00425
R3935 VSS.n978 VSS.n33 0.00425
R3936 VSS.n977 VSS.n35 0.00425
R3937 VSS.n109 VSS.n108 0.00425
R3938 VSS.n105 VSS.n37 0.00425
R3939 VSS.n104 VSS.n39 0.00425
R3940 VSS.n101 VSS.n100 0.00425
R3941 VSS.n97 VSS.n42 0.00425
R3942 VSS.n96 VSS.n44 0.00425
R3943 VSS.n93 VSS.n92 0.00425
R3944 VSS.n89 VSS.n46 0.00425
R3945 VSS.n88 VSS.n48 0.00425
R3946 VSS.n85 VSS.n84 0.00425
R3947 VSS.n81 VSS.n51 0.00425
R3948 VSS.n80 VSS.n53 0.00425
R3949 VSS.n76 VSS.n75 0.00425
R3950 VSS.n72 VSS.n59 0.00425
R3951 VSS.n71 VSS.n61 0.00425
R3952 VSS.n68 VSS.n67 0.00425
R3953 VSS.n897 VSS.n794 0.0035
R3954 VSS.n896 VSS.n795 0.0035
R3955 VSS.n893 VSS.n892 0.0035
R3956 VSS.n888 VSS.n797 0.0035
R3957 VSS.n887 VSS.n800 0.0035
R3958 VSS.n884 VSS.n883 0.0035
R3959 VSS.n880 VSS.n802 0.0035
R3960 VSS.n879 VSS.n805 0.0035
R3961 VSS.n876 VSS.n875 0.0035
R3962 VSS.n872 VSS.n807 0.0035
R3963 VSS.n871 VSS.n810 0.0035
R3964 VSS.n868 VSS.n867 0.0035
R3965 VSS.n863 VSS.n812 0.0035
R3966 VSS.n862 VSS.n819 0.0035
R3967 VSS.n859 VSS.n858 0.0035
R3968 VSS.n779 VSS.n194 0.00275
R3969 VSS.n133 VSS.n126 0.0018125
R3970 VSS.n899 VSS.n898 0.0018125
R3971 VSS.n152 VSS.n144 0.00162469
R3972 VSS.n914 VSS.n913 0.00162456
C0 bit1 a_6006_896# 0.00331f
C1 a_36688_2967# vbn 13.2571f
C2 a_36978_3547# a_41654_3547# 4.03621f
C3 a_36688_4127# a_41364_2967# 0.00177f
C4 a_n7872_8894# ck 0
C5 a_n5234_7514# a_n3101_6703# 0
C6 a_41654_4707# a_36978_5867# 0.00115f
C7 a_6006_4704# bitb2 0.21396f
C8 a_6006_896# VDD 0.19338f
C9 a_36978_1227# w_36626_300# 12.307f
C10 VDD_LS a_n4810_7514# 0.23085f
C11 bit1 a_6006_4704# 0.00886f
C12 a_n5549_6703# a_n3101_6703# 0
C13 a_36978_3547# vbn 12.4223f
C14 a_36688_4127# a_41654_3547# 2.91652f
C15 a_36978_3547# a_41364_4127# 0.03322f
C16 a_6896_6633# bitb2 0.00121f
C17 a_6006_4704# VDD 0.19338f
C18 a_41654_5867# a_41364_5287# 2.37452f
C19 a_6006_896# a_6006_14# 8.81578f
C20 a0 VDD_LS 0.0349f
C21 bitb0 VDD 0.77881f
C22 VDD_LS a_n6694_7514# 0.21816f
C23 bit1 a_6896_6633# 0.04998f
C24 a_36688_4127# vbn 13.2616f
C25 a_n3607_6703# a_n2245_6719# 0.00588f
C26 a_36688_4127# a_41364_4127# 4.1149f
C27 a_36978_4707# a_41654_3547# 0.00115f
C28 a_41364_6447# a_41364_5287# 0.05596f
C29 a_6896_6633# VDD 0.19338f
C30 a_6006_4704# a_6006_14# 7.70065f
C31 a_n5234_7514# q1 0.00721f
C32 a_6006_896# bitb4 0.00214f
C33 a_36688_6447# a_36978_5867# 10.9862f
C34 VDD_LS a_n6862_7514# 0.14459f
C35 bitb0 a_6006_14# 0
C36 w_36626_300# w_37791_300# 0.09601f
C37 ls a_n4642_7514# 0.63671f
C38 a_n3607_6703# a_n3101_6703# 1.04229f
C39 a_36978_4707# vbn 12.4223f
C40 a_36978_4707# a_41364_4127# 2.88648f
C41 a_6156_6633# VDD 0.25281f
C42 bit3 a_6006_896# 0.05328f
C43 a_41364_6447# a_41654_5867# 2.37431f
C44 a_n5549_6703# q1 0.74328f
C45 a_6896_6633# a_6006_14# 1.30715f
C46 a_6006_4704# bitb4 0
C47 VDD_LS a_n7286_7514# 0.40251f
C48 a_36978_7027# a_36978_5867# 0.01838f
C49 a_1867_7085# a_1632_6633# 0.37174f
C50 a_41364_1807# a_41654_1227# 2.37431f
C51 ck a_n7601_6703# 0.00938f
C52 ls a_n4810_7514# 0.02307f
C53 a_n7872_8894# a_n2245_6719# 0.22692f
C54 bit3 a_6006_4704# 0
C55 a_41654_7027# a_41654_5867# 0.05596f
C56 a_1632_6633# VDD 1.51352f
C57 a_6156_6633# a_6006_14# 0.21414f
C58 a_n8217_6703# q1 0.00656f
C59 bit1 bitb2 1.85602f
C60 a_36978_7027# a_36688_6447# 11.0476f
C61 a_36688_7607# a_36978_5867# 0
C62 a_41654_2387# a_41654_1227# 0.05596f
C63 bitb2 VDD 0.69643f
C64 ls a_n6694_7514# 0
C65 a_n7872_8894# a_n3101_6703# 0.00642f
C66 a_452_6633# VDD_LS 0
C67 a_1867_7085# VDD 1.30092f
C68 a_41654_7027# a_41364_6447# 2.37452f
C69 a_36688_7607# a_36688_6447# 0.18664f
C70 bit1 VDD 0.39958f
C71 a_41654_2387# a_41364_1807# 2.34764f
C72 a_n6436_6531# a_n7601_6703# 0.00463f
C73 bitb2 a_6006_14# 0
C74 a_41364_7607# a_41364_6447# 0.05596f
C75 a_41364_5287# vbn 3.48625f
C76 a_41364_5287# a_41364_4127# 0.05596f
C77 a_36978_8187# a_36688_6447# 0
C78 a_36688_7607# a_36978_7027# 10.9862f
C79 a_41364_2967# a_41364_1807# 0.05596f
C80 vg a_6006_896# 3.0381f
C81 bit1 a_6006_14# 0
C82 a_n7180_6531# a_n7601_6703# 0.04749f
C83 a_6006_896# vbnf 8.01765f
C84 VDD a_6006_14# 0.19338f
C85 a_41364_7607# a_41654_7027# 2.37431f
C86 a_41654_5867# vbn 3.49251f
C87 a_n7872_8894# q1 0.00168f
C88 a_41654_1227# vbn 3.47973f
C89 a_36978_8187# a_36978_7027# 0.01838f
C90 vg a_6006_4704# 2.53379f
C91 a_41364_2967# a_41654_2387# 2.37431f
C92 vg bitb0 1.37238f
C93 bit2 bitb3 1.85602f
C94 a_6006_4704# vbnf 11.0435f
C95 a_41654_8187# VDD 0.00481f
C96 bitb4 VDD 0.69669f
C97 bitb0 vbnf 0.0727f
C98 a_41654_8187# a_41654_7027# 0.05596f
C99 a_41364_6447# vbn 3.48625f
C100 a_n4384_6451# a_n4642_7514# 0.00911f
C101 a_36978_8187# a_36688_7607# 11.0477f
C102 a_41364_1807# vbn 3.27202f
C103 vg a_6896_6633# 3.93006f
C104 a_41654_3547# a_41654_2387# 0.05596f
C105 a_6896_6633# vbnf 4.66746f
C106 bit3 VDD 0.39972f
C107 vctrl a_36978_1227# 0.06613f
C108 VDD vbn 0.61636f
C109 a_41654_8187# a_41364_7607# 2.37452f
C110 bitb4 a_6006_14# 0.21399f
C111 a0 a_996_6587# 0.1634f
C112 a_41654_7027# vbn 3.49334f
C113 a_60350_8387# a_36688_7607# 0.01558f
C114 a_41654_2387# vbn 3.49251f
C115 vg a_6156_6633# 1.06444f
C116 a_41654_3547# a_41364_2967# 2.37452f
C117 a_6156_6633# vbnf 1.13433f
C118 bit3 a_6006_14# 0.00887f
C119 a_41364_7607# vbn 3.54873f
C120 ck a_n6694_7514# 0
C121 a_60350_8387# a_36978_8187# 0.0117f
C122 a_41364_2967# vbn 3.48625f
C123 vg a_1632_6633# 0.41376f
C124 a_41364_4127# a_41364_2967# 0.05596f
C125 bit3 bitb4 1.85602f
C126 a_n5549_6703# a_n5234_7514# 0.74379f
C127 a_n7601_6703# q1 1.57175f
C128 a_41654_8187# vbn 6.27374f
C129 bitb2 vbnf 0.1755f
C130 a_41654_3547# vbn 3.49251f
C131 vg a_1867_7085# 0.52938f
C132 a_41364_4127# a_41654_3547# 2.37431f
C133 bit1 vg 0
C134 a_36666_9481# VDD 28.8396f
C135 bit1 vbnf 0.19681f
C136 vg VDD 0.88943f
C137 a_n6436_6531# a_n6694_7514# 0.00564f
C138 ck a_n7286_7514# 0
C139 VDD vbnf 5.67878f
C140 VDD_LS ls 1.22951f
C141 a_41364_4127# vbn 3.48625f
C142 a_n7872_8894# VDD 0.02233f
C143 a_452_6633# a_996_6587# 0.39821f
C144 a_41364_7607# a_36666_9481# 0
C145 a_n3607_6703# a_n5234_7514# 0.003f
C146 vctrl w_36626_300# 0.07808f
C147 vg a_6006_14# 5.82374f
C148 a_36978_1227# a_36688_1807# 10.9861f
C149 a_n3101_6703# a_n4642_7514# 0
C150 vbnf a_6006_14# 9.72296f
C151 a_n3607_6703# a_n5549_6703# 0.02485f
C152 a_41654_8187# a_36666_9481# 1.20914f
C153 a0 a_n2245_6719# 1.9857f
C154 a_n6436_6531# a_n7286_7514# 0.04322f
C155 a_36978_1227# a_36978_2387# 0
C156 bitb4 vbnf 0.17851f
C157 a_n7872_8894# a_n5234_7514# 0
C158 a_36688_5287# a_41654_4707# 2.91652f
C159 a_36666_9481# vbn 53.2906f
C160 a_n7180_6531# a_n7286_7514# 0.00757f
C161 bit3 vbnf 0.19848f
C162 q1 a_n4642_7514# 0
C163 vbn vbnf 0.01083f
C164 a_n7872_8894# a_n5549_6703# 0.00156f
C165 bit0 a_6006_896# 0.00331f
C166 a_36688_5287# a_36978_5867# 11.0476f
C167 a_996_6587# VDD_LS 0
C168 a_n7872_8894# a_n8217_6703# 0
C169 bit0 a_6006_4704# 0
C170 a_36688_1807# w_36626_300# 0.1968f
C171 a_36688_5287# a_36688_6447# 0.18664f
C172 bit0 bitb0 0.79928f
C173 q1 a_n6694_7514# 0.67113f
C174 a_n4384_6451# VDD_LS 0.00409f
C175 ck VDD_LS 0.92368f
C176 a_n7872_8894# a_n3607_6703# 0
C177 bit0 a_6896_6633# 0.00884f
C178 a_36688_4127# a_41654_4707# 0.03482f
C179 a_36978_2387# w_36626_300# 0.00101f
C180 a_36688_5287# a_36978_7027# 0
C181 q1 a_n6862_7514# 0.01095f
C182 vg vbnf 1.37664f
C183 a_n5234_7514# a_n7601_6703# 0
C184 a_n5128_6451# VDD_LS 0.00198f
C185 bit0 a_6156_6633# 0.04998f
C186 a_36978_4707# a_41654_4707# 4.03621f
C187 q1 a_n7286_7514# 1.29375f
C188 a_n5549_6703# a_n7601_6703# 0.0098f
C189 a_36688_4127# a_36978_5867# 0
C190 a_n6436_6531# VDD_LS 0.00406f
C191 a_n8217_6703# a_n7601_6703# 0.7483f
C192 a_n7180_6531# VDD_LS 0.00222f
C193 a_36978_4707# a_36978_5867# 0.01838f
C194 a_6006_896# bitb1 0
C195 a_n4384_6451# ls 0.01106f
C196 a_1632_6633# a0 0.00356f
C197 bit0 bit1 0.02757f
C198 a_6006_4704# bitb1 0
C199 a_n2245_6719# VDD_LS 0.33992f
C200 a_36978_4707# a_36688_6447# 0
C201 bit0 VDD 0.40315f
C202 bitb0 bitb1 0.01415f
C203 a_n5128_6451# ls 0.01045f
C204 a_36978_1227# a_41654_1227# 4.04491f
C205 a_41364_5287# a_41654_4707# 2.37431f
C206 a_n3101_6703# VDD_LS 0.28227f
C207 a_6896_6633# bitb1 0.21396f
C208 bit0 a_6006_14# 0
C209 a0 VDD 1.58578f
C210 a_n5234_7514# a_n4642_7514# 0.88042f
C211 a_n7872_8894# a_n7601_6703# 0.00167f
C212 a_36978_1227# a_41364_1807# 0.03322f
C213 a_41654_5867# a_41654_4707# 0.05596f
C214 a_6156_6633# bitb1 0.00121f
C215 a_6006_896# bitb3 0.21489f
C216 a_41364_5287# a_36978_5867# 2.88648f
C217 a_n5234_7514# a_n4810_7514# 0.00509f
C218 a_n5549_6703# a_n4642_7514# 0.70987f
C219 bit2 a_6006_896# 0.01215f
C220 a_6006_4704# bitb3 0.00123f
C221 a_n2245_6719# ls 0
C222 VDD_LS q1 0.47949f
C223 a_41364_5287# a_36688_6447# 0.00177f
C224 a_41654_5867# a_36978_5867# 4.03621f
C225 a_452_6633# a_1632_6633# 0.1528f
C226 bitb1 bitb2 0.01415f
C227 a_n5549_6703# a_n4810_7514# 0.01794f
C228 a_n5234_7514# a_n6694_7514# 0
C229 bit2 a_6006_4704# 0.04998f
C230 vctrl a_36688_1807# 2.4556f
C231 a_n3101_6703# ls 0.12117f
C232 bit1 bitb1 0.79928f
C233 a_41364_6447# a_36978_5867# 0.03322f
C234 a_41654_5867# a_36688_6447# 2.91652f
C235 a_452_6633# a_1867_7085# 0.02066f
C236 a_n3607_6703# a_n4642_7514# 0.08987f
C237 a_n5549_6703# a_n6694_7514# 0.00175f
C238 bitb1 VDD 0.69643f
C239 a_452_6633# VDD 1.2f
C240 w_36626_300# a_41654_1227# 0.05949f
C241 vctrl a_36978_2387# 8.43974f
C242 a_41654_5867# a_36978_7027# 0.00115f
C243 a_41364_6447# a_36688_6447# 4.1149f
C244 a_n8217_6703# a_n6694_7514# 0
C245 a_n5234_7514# a_n7286_7514# 0.00334f
C246 bitb1 a_6006_14# 0
C247 a_36978_1227# vbn 12.5272f
C248 a_41654_4707# a_41654_3547# 0.05596f
C249 vctrl a_36688_2967# 0.07604f
C250 a_41654_7027# a_36688_6447# 0.03482f
C251 a_41364_6447# a_36978_7027# 2.88648f
C252 bit0 vg 0.02208f
C253 bit4 a_6006_896# 0.00331f
C254 a_n5549_6703# a_n7286_7514# 0.00223f
C255 ls q1 0.00995f
C256 bit0 vbnf 0.19018f
C257 bitb2 bitb3 0.01415f
C258 a_41654_4707# vbn 3.49251f
C259 a_41654_4707# a_41364_4127# 2.37452f
C260 vctrl a_36978_3547# 0.01256f
C261 bit4 a_6006_4704# 0
C262 a_41364_6447# a_36688_7607# 0.00177f
C263 a_41654_7027# a_36978_7027# 4.03621f
C264 a_n7872_8894# a_n4810_7514# 0
C265 a_n8217_6703# a_n7286_7514# 0.00738f
C266 bit2 bitb2 0.79928f
C267 vg a0 0.40499f
C268 bitb3 VDD 0.69649f
C269 w_37791_300# vbn 0.00346f
C270 vctrl a_36688_4127# 0.00108f
C271 a_41654_7027# a_36688_7607# 2.91652f
C272 a_41364_7607# a_36978_7027# 0.03322f
C273 bit1 bit2 0.02757f
C274 a_n7872_8894# a0 0.00459f
C275 vbn a_36978_5867# 12.4223f
C276 a_n7872_8894# a_n6694_7514# 0
C277 bit2 VDD 0.39961f
C278 VDD VDD_LS 0.03331f
C279 bitb3 a_6006_14# 0
C280 VDD a_36978_8187# 0.00193f
C281 a_41364_7607# a_36688_7607# 4.1149f
C282 a_41654_7027# a_36978_8187# 0.00115f
C283 vbn a_36688_6447# 13.2616f
C284 a_36978_2387# a_36688_1807# 10.222f
C285 a_n7872_8894# a_n6862_7514# 0
C286 vctrl a_6006_896# 0.30122f
C287 a_n3101_6703# a_n4384_6451# 0
C288 bit2 a_6006_14# 0
C289 w_36626_300# vbn 6.10627f
C290 VDD a_60350_8387# 0.05007f
C291 bitb3 bitb4 0.01415f
C292 a_41654_8187# a_36688_7607# 0.03482f
C293 a_41364_7607# a_36978_8187# 2.88648f
C294 a_36688_2967# a_36688_1807# 0.17041f
C295 vbn a_36978_7027# 12.4252f
C296 a_n7872_8894# a_n7286_7514# 0
C297 vctrl a_6006_4704# 0.17004f
C298 bit3 bitb3 0.79928f
C299 vg bitb1 0.00141f
C300 a_n5234_7514# VDD_LS 0.51666f
C301 bitb1 vbnf 0.1755f
C302 vg a_452_6633# 0.52711f
C303 a_41654_8187# a_36978_8187# 4.07037f
C304 a_36978_3547# a_36688_1807# 0
C305 a_36688_2967# a_36978_2387# 10.9859f
C306 vbn a_36688_7607# 13.2849f
C307 vctrl a_6896_6633# 0.04912f
C308 bit2 bit3 0.02757f
C309 bit4 VDD 0.45851f
C310 a_n5549_6703# VDD_LS 0.58961f
C311 a_36688_5287# a_36978_3547# 0
C312 ck q1 0
C313 a_n7601_6703# a_n6694_7514# 0.70254f
C314 vbn a_36978_8187# 12.6636f
C315 a_36978_3547# a_36978_2387# 0.01838f
C316 vctrl a_6156_6633# 3.22782f
C317 a_36688_5287# a_36688_4127# 0.18664f
C318 a_n8217_6703# VDD_LS 0.37512f
C319 bit4 a_6006_14# 0.05001f
C320 a_n7601_6703# a_n6862_7514# 0.01101f
C321 a_36688_4127# a_36978_2387# 0
C322 vbn a_60350_8387# 0.27863f
C323 a_36978_3547# a_36688_2967# 11.0476f
C324 vctrl a_41654_1227# 0.00174f
C325 a_n3101_6703# a_n2245_6719# 0.20859f
C326 a_36688_5287# a_36978_4707# 10.9862f
C327 a_n3607_6703# VDD_LS 0.39275f
C328 a_n6436_6531# q1 0.00604f
C329 bit4 bitb4 0.79928f
C330 a_36666_9481# a_36688_7607# 0.17366f
C331 a_n7601_6703# a_n7286_7514# 0.71835f
C332 a_n5234_7514# ls 1.35416f
C333 a_36688_4127# a_36688_2967# 0.18664f
C334 bitb3 vbnf 0.17647f
C335 vctrl a_41364_1807# 4.74781f
C336 bit3 bit4 0.02757f
C337 a_n7180_6531# q1 0.00689f
C338 a_1632_6633# a_996_6587# 0.37969f
C339 a_36666_9481# a_36978_8187# 9.66738f
C340 bit2 vbnf 0.19681f
C341 a_n5549_6703# ls 1.56506f
C342 a_36978_4707# a_36688_2967# 0
C343 a_36688_4127# a_36978_3547# 10.9862f
C344 vctrl a_41654_2387# 0.3277f
C345 a_n4810_7514# a_n4642_7514# 0.14135f
C346 a_n7872_8894# VDD_LS 2.59119f
C347 a_1867_7085# a_996_6587# 0.34397f
C348 a_36666_9481# a_60350_8387# 0.14595f
C349 a_36978_4707# a_36978_3547# 0.01838f
C350 vctrl a_6006_14# 0.19159f
C351 vctrl a_41364_2967# 0
C352 a_996_6587# VDD 1.3832f
C353 a_n6694_7514# a_n4642_7514# 0.00248f
C354 a_36978_4707# a_36688_4127# 11.0476f
C355 a_n3607_6703# ls 0.96168f
C356 a_41364_5287# a_36688_5287# 4.1149f
C357 a_36688_1807# a_41654_1227# 2.91652f
C358 a_41654_5867# a_36688_5287# 0.03482f
C359 bit4 vbnf 1.13336f
C360 vctrl vbn 1.86478f
C361 a_36978_2387# a_41654_1227# 0
C362 a_36688_1807# a_41364_1807# 4.00658f
C363 a_n7872_8894# ls 0.33461f
C364 a_n6862_7514# a_n6694_7514# 0.08507f
C365 VDD_LS a_n7601_6703# 0.45003f
C366 a_n7286_7514# a_n4810_7514# 0
C367 a_n5234_7514# a_n4384_6451# 0.07136f
C368 a_36688_1807# a_41654_2387# 0.0269f
C369 a_36978_2387# a_41364_1807# 0.72603f
C370 a_6006_4704# a_6006_896# 4.47742f
C371 a_6006_896# bitb0 0
C372 bit0 bitb1 1.85602f
C373 a_n7286_7514# a_n6694_7514# 0.87554f
C374 a_n5549_6703# a_n4384_6451# 0.0061f
C375 a_36688_2967# a_41364_1807# 0.00177f
C376 a_36978_2387# a_41654_2387# 3.97376f
C377 a_n5234_7514# a_n5128_6451# 0.01134f
C378 a_6896_6633# a_6006_896# 0.6087f
C379 vg vctrl 1.00676f
C380 a_6006_4704# bitb0 0
C381 a_41364_5287# a_36978_4707# 0.03322f
C382 vctrl vbnf 3.18603f
C383 a_n7286_7514# a_n6862_7514# 0.00388f
C384 a_n5549_6703# a_n5128_6451# 0.07726f
C385 a_n8217_6703# ck 1.12832f
C386 a_36688_2967# a_41654_2387# 2.91652f
C387 a_36978_2387# a_41364_2967# 0.03322f
C388 a_452_6633# a0 0.60056f
C389 a_6156_6633# a_6006_896# 3.25671f
C390 a_6896_6633# a_6006_4704# 3.99805f
C391 a_6896_6633# bitb0 0
C392 a_36688_1807# vbn 13.1706f
C393 a_36978_3547# a_41654_2387# 0.00115f
C394 a_36688_2967# a_41364_2967# 4.1149f
C395 vg a_996_6587# 0.45933f
C396 a_6156_6633# a_6006_4704# 0.20544f
C397 a_36688_5287# vbn 13.2616f
C398 a_36688_5287# a_41364_4127# 0.00177f
C399 a_6156_6633# bitb0 0.21396f
C400 a_36978_2387# vbn 11.9387f
C401 a_36688_2967# a_41654_3547# 0.03482f
C402 a_36978_3547# a_41364_2967# 2.88648f
C403 a_6006_896# bitb2 0.00104f
C404 VDD_LS a_n4642_7514# 0.26831f
C405 a_6156_6633# a_6896_6633# 0.51329f
C406 vctrl VSS 31.392f
C407 vg VSS 34.29891f
C408 bit4 VSS 3.03991f
C409 bit3 VSS 3.61766f
C410 bit2 VSS 3.61644f
C411 bit1 VSS 3.61744f
C412 bit0 VSS 3.61493f
C413 bitb4 VSS 2.90376f
C414 bitb3 VSS 2.89511f
C415 bitb2 VSS 2.8943f
C416 bitb1 VSS 2.89514f
C417 bitb0 VSS 2.64908f
C418 a0 VSS 1.55263f
C419 ck VSS 3.68251f
C420 vbnf VSS 0.11644p
C421 ls VSS 4.21743f
C422 vbn VSS 0.18989p
C423 VDD_LS VSS 72.7929f
C424 VDD VSS 0.33786p
C425 a_41654_1227# VSS 3.93442f
C426 a_41364_1807# VSS 1.69719f
C427 a_41654_2387# VSS 1.65655f
C428 a_41364_2967# VSS 1.65198f
C429 a_41654_3547# VSS 1.65655f
C430 a_41364_4127# VSS 1.65198f
C431 a_41654_4707# VSS 1.65655f
C432 a_41364_5287# VSS 1.65198f
C433 a_41654_5867# VSS 1.65655f
C434 a_41364_6447# VSS 1.65198f
C435 a_41654_7027# VSS 1.65655f
C436 a_41364_7607# VSS 1.65198f
C437 a_41654_8187# VSS 2.25067f
C438 a_36978_1227# VSS 1.91496f
C439 a_36688_1807# VSS 3.9691f
C440 a_36978_2387# VSS 1.31364f
C441 a_36688_2967# VSS 3.9634f
C442 a_36978_3547# VSS 1.34623f
C443 a_36688_4127# VSS 3.96359f
C444 a_36978_4707# VSS 1.34623f
C445 a_36688_5287# VSS 3.96359f
C446 a_36978_5867# VSS 1.34623f
C447 a_36688_6447# VSS 3.96359f
C448 a_36978_7027# VSS 1.34623f
C449 a_36688_7607# VSS 3.95929f
C450 a_36978_8187# VSS 1.67149f
C451 a_60350_8387# VSS 0.65251f
C452 a_6006_14# VSS 24.4863f
C453 a_6006_896# VSS 15.2643f
C454 a_6006_4704# VSS 7.95248f
C455 a_6896_6633# VSS 3.8085f
C456 a_6156_6633# VSS 2.52433f
C457 a_1632_6633# VSS 0.27347f
C458 a_1867_7085# VSS 0.42674f
C459 a_452_6633# VSS 0.36118f
C460 a_996_6587# VSS 0.28482f
C461 a_n4384_6451# VSS 0.14599f
C462 a_n5128_6451# VSS 0.14869f
C463 a_n6436_6531# VSS 0.09609f
C464 a_n7180_6531# VSS 0.09795f
C465 a_n2245_6719# VSS 1.45122f
C466 a_n3101_6703# VSS 0.65272f
C467 a_n4642_7514# VSS 0.56414f
C468 a_n4810_7514# VSS 0.01195f
C469 a_n6694_7514# VSS 0.47458f
C470 a_n6862_7514# VSS 0.01275f
C471 a_n7286_7514# VSS 0.51067f
C472 q1 VSS 0.88857f
C473 a_n7601_6703# VSS 1.00618f
C474 a_n5234_7514# VSS 0.52691f
C475 a_n5549_6703# VSS 1.00806f
C476 a_n8217_6703# VSS 0.82236f
C477 a_n3607_6703# VSS 0.69051f
C478 a_36666_9481# VSS 12.6032f
C479 a_n7872_8894# VSS 7.24156f
C480 w_37791_300# VSS 0.66986f
C481 w_36626_300# VSS 11.6672f
C482 VDD.n0 VSS 0.08643f
C483 VDD.n1 VSS 0.02649f
C484 VDD.t10 VSS 0.1052f
C485 VDD.n2 VSS 0.05298f
C486 VDD.n3 VSS 0.02649f
C487 VDD.n4 VSS 0.08643f
C488 VDD.n5 VSS 0.02649f
C489 VDD.n6 VSS 0.05298f
C490 VDD.n7 VSS 0.02649f
C491 VDD.n8 VSS 0.08643f
C492 VDD.n9 VSS 0.02649f
C493 VDD.n10 VSS 0.05298f
C494 VDD.n11 VSS 0.02649f
C495 VDD.n12 VSS 0.08643f
C496 VDD.n13 VSS 0.02649f
C497 VDD.n14 VSS 0.05298f
C498 VDD.n15 VSS 0.02649f
C499 VDD.n16 VSS 0.08643f
C500 VDD.n17 VSS 0.02649f
C501 VDD.t14 VSS 0.02164f
C502 VDD.t12 VSS 0.02164f
C503 VDD.n18 VSS 0.08461f
C504 VDD.n19 VSS 0.04641f
C505 VDD.n20 VSS 0.02649f
C506 VDD.n21 VSS 0.08643f
C507 VDD.n22 VSS 0.02649f
C508 VDD.n23 VSS 0.05298f
C509 VDD.n24 VSS 0.02649f
C510 VDD.n25 VSS 0.08643f
C511 VDD.n26 VSS 0.02649f
C512 VDD.n27 VSS 0.05298f
C513 VDD.n28 VSS 0.02649f
C514 VDD.n29 VSS 0.08643f
C515 VDD.n30 VSS 0.02649f
C516 VDD.n31 VSS 0.05298f
C517 VDD.n32 VSS 0.02649f
C518 VDD.n33 VSS 0.08643f
C519 VDD.n34 VSS 0.02649f
C520 VDD.n35 VSS 0.05298f
C521 VDD.n36 VSS 0.02649f
C522 VDD.n37 VSS 0.08643f
C523 VDD.n38 VSS 0.02649f
C524 VDD.t18 VSS 0.02164f
C525 VDD.t16 VSS 0.02164f
C526 VDD.n39 VSS 0.08461f
C527 VDD.n40 VSS 0.04515f
C528 VDD.n41 VSS 0.02649f
C529 VDD.n42 VSS 0.08643f
C530 VDD.n43 VSS 0.02649f
C531 VDD.n44 VSS 0.05298f
C532 VDD.n45 VSS 0.02649f
C533 VDD.n46 VSS 0.08643f
C534 VDD.n47 VSS 0.02649f
C535 VDD.n48 VSS 0.05298f
C536 VDD.n49 VSS 0.02649f
C537 VDD.n50 VSS 0.08643f
C538 VDD.n51 VSS 0.02649f
C539 VDD.n52 VSS 0.05298f
C540 VDD.n53 VSS 0.02649f
C541 VDD.n54 VSS 0.08643f
C542 VDD.n55 VSS 0.02649f
C543 VDD.n56 VSS 0.05298f
C544 VDD.n57 VSS 0.02649f
C545 VDD.n58 VSS 0.08643f
C546 VDD.n59 VSS 0.02649f
C547 VDD.t22 VSS 0.02164f
C548 VDD.t20 VSS 0.02164f
C549 VDD.n60 VSS 0.08461f
C550 VDD.n61 VSS 0.05298f
C551 VDD.n62 VSS 0.02649f
C552 VDD.n63 VSS 0.08643f
C553 VDD.n64 VSS 0.02649f
C554 VDD.n65 VSS 0.05298f
C555 VDD.n66 VSS 0.02649f
C556 VDD.n67 VSS 0.08643f
C557 VDD.n68 VSS 0.02649f
C558 VDD.n69 VSS 0.05298f
C559 VDD.n70 VSS 0.02649f
C560 VDD.n71 VSS 0.08643f
C561 VDD.n72 VSS 0.02649f
C562 VDD.n73 VSS 0.05298f
C563 VDD.n74 VSS 0.02649f
C564 VDD.n75 VSS 0.08643f
C565 VDD.n76 VSS 0.02649f
C566 VDD.n77 VSS 0.05298f
C567 VDD.n78 VSS 0.02649f
C568 VDD.n79 VSS 0.28694f
C569 VDD.n80 VSS 0.02649f
C570 VDD.t24 VSS 0.1052f
C571 VDD.t31 VSS 0.00254f
C572 VDD.n81 VSS 0.13082f
C573 VDD.n82 VSS 0.12806f
C574 VDD.n83 VSS 0.04123f
C575 VDD.n84 VSS 0.03742f
C576 VDD.n85 VSS 0.0521f
C577 VDD.n86 VSS 0.03557f
C578 VDD.n87 VSS 0.02649f
C579 VDD.n88 VSS 0.02649f
C580 VDD.n89 VSS 0.08643f
C581 VDD.n90 VSS 0.08643f
C582 VDD.n91 VSS 0.02649f
C583 VDD.n92 VSS 0.02649f
C584 VDD.n93 VSS 0.05298f
C585 VDD.n94 VSS 0.05298f
C586 VDD.n95 VSS 0.02649f
C587 VDD.n96 VSS 0.02649f
C588 VDD.n97 VSS 0.08643f
C589 VDD.n98 VSS 0.08643f
C590 VDD.n99 VSS 0.02649f
C591 VDD.n100 VSS 0.02649f
C592 VDD.n101 VSS 0.05298f
C593 VDD.n102 VSS 0.05298f
C594 VDD.n103 VSS 0.02649f
C595 VDD.n104 VSS 0.02649f
C596 VDD.n105 VSS 0.08643f
C597 VDD.n106 VSS 0.08643f
C598 VDD.n107 VSS 0.02649f
C599 VDD.n108 VSS 0.02649f
C600 VDD.n109 VSS 0.05298f
C601 VDD.n110 VSS 0.05298f
C602 VDD.n111 VSS 0.02649f
C603 VDD.n112 VSS 0.02649f
C604 VDD.n113 VSS 0.08643f
C605 VDD.n114 VSS 0.08643f
C606 VDD.n115 VSS 0.02649f
C607 VDD.n116 VSS 0.02649f
C608 VDD.n117 VSS 0.05298f
C609 VDD.n118 VSS 0.05298f
C610 VDD.n119 VSS 0.02649f
C611 VDD.n120 VSS 0.02649f
C612 VDD.n121 VSS 0.08643f
C613 VDD.n122 VSS 0.08643f
C614 VDD.n123 VSS 0.02649f
C615 VDD.n124 VSS 0.02649f
C616 VDD.n125 VSS 0.03206f
C617 VDD.n126 VSS 0.04641f
C618 VDD.n127 VSS 0.04742f
C619 VDD.n128 VSS 0.02649f
C620 VDD.n129 VSS 0.02649f
C621 VDD.n130 VSS 0.08643f
C622 VDD.n131 VSS 0.08643f
C623 VDD.n132 VSS 0.02649f
C624 VDD.n133 VSS 0.02649f
C625 VDD.n134 VSS 0.05298f
C626 VDD.n135 VSS 0.05298f
C627 VDD.n136 VSS 0.02649f
C628 VDD.n137 VSS 0.02649f
C629 VDD.n138 VSS 0.08643f
C630 VDD.n139 VSS 0.08643f
C631 VDD.n140 VSS 0.02649f
C632 VDD.n141 VSS 0.02649f
C633 VDD.n142 VSS 0.05298f
C634 VDD.n143 VSS 0.05298f
C635 VDD.n144 VSS 0.02649f
C636 VDD.n145 VSS 0.02649f
C637 VDD.n146 VSS 0.08643f
C638 VDD.n147 VSS 0.08643f
C639 VDD.n148 VSS 0.02649f
C640 VDD.n149 VSS 0.02649f
C641 VDD.n150 VSS 0.05298f
C642 VDD.n151 VSS 0.05298f
C643 VDD.n152 VSS 0.02649f
C644 VDD.n153 VSS 0.02649f
C645 VDD.n154 VSS 0.08643f
C646 VDD.n155 VSS 0.08643f
C647 VDD.n156 VSS 0.02649f
C648 VDD.n157 VSS 0.02649f
C649 VDD.n158 VSS 0.05298f
C650 VDD.t30 VSS 1.05208f
C651 VDD.t23 VSS 2.25707f
C652 VDD.t21 VSS 2.66636f
C653 VDD.t19 VSS 2.66636f
C654 VDD.t17 VSS 1.86746f
C655 VDD.t9 VSS 2.7799f
C656 VDD.t11 VSS 2.66636f
C657 VDD.t13 VSS 2.66636f
C658 VDD.t15 VSS 2.13208f
C659 VDD.n159 VSS 1.08085f
C660 VDD.n160 VSS -0.23193f
C661 VDD.n161 VSS 0.02775f
C662 VDD.n162 VSS 0.05298f
C663 VDD.n163 VSS 0.02649f
C664 VDD.n164 VSS 0.02649f
C665 VDD.n165 VSS 0.08643f
C666 VDD.n166 VSS 0.08643f
C667 VDD.n167 VSS 0.02649f
C668 VDD.n168 VSS 0.02649f
C669 VDD.n169 VSS 0.03259f
C670 VDD.n170 VSS 0.05298f
C671 VDD.n171 VSS 0.02649f
C672 VDD.n172 VSS 0.02649f
C673 VDD.n173 VSS 0.08643f
C674 VDD.n174 VSS 0.08643f
C675 VDD.n175 VSS 0.02649f
C676 VDD.n176 VSS 0.02649f
C677 VDD.n177 VSS 0.05298f
C678 VDD.n178 VSS 0.05298f
C679 VDD.n179 VSS 0.02649f
C680 VDD.n180 VSS 0.02649f
C681 VDD.n181 VSS 0.08643f
C682 VDD.n182 VSS 0.08643f
C683 VDD.n183 VSS 0.02649f
C684 VDD.n184 VSS 0.02649f
C685 VDD.n185 VSS 0.05298f
C686 VDD.n186 VSS 0.05298f
C687 VDD.n187 VSS 0.02649f
C688 VDD.n188 VSS 0.02649f
C689 VDD.n189 VSS 0.08643f
C690 VDD.n190 VSS 0.08643f
C691 VDD.n191 VSS 0.02649f
C692 VDD.n192 VSS 0.02649f
C693 VDD.n193 VSS 0.05298f
C694 VDD.n194 VSS 0.05298f
C695 VDD.n195 VSS 0.02649f
C696 VDD.n196 VSS 0.02649f
C697 VDD.n197 VSS 0.08643f
C698 VDD.n198 VSS 0.08643f
C699 VDD.n199 VSS 0.02649f
C700 VDD.n200 VSS 0.02649f
C701 VDD.n201 VSS 0.05298f
C702 VDD.n202 VSS 0.03523f
C703 VDD.n203 VSS 0.05298f
C704 VDD.n204 VSS 0.02649f
C705 VDD.n205 VSS 0.02649f
C706 VDD.n206 VSS 0.08643f
C707 VDD.n207 VSS 0.08643f
C708 VDD.n208 VSS 0.02649f
C709 VDD.n209 VSS 0.02649f
C710 VDD.n210 VSS 0.04424f
C711 VDD.n211 VSS 0.05298f
C712 VDD.n212 VSS 0.02649f
C713 VDD.n213 VSS 0.02649f
C714 VDD.n214 VSS 0.08643f
C715 VDD.n215 VSS 0.08643f
C716 VDD.n216 VSS 0.02649f
C717 VDD.n217 VSS 0.02649f
C718 VDD.n218 VSS 0.05298f
C719 VDD.n219 VSS 0.05298f
C720 VDD.n220 VSS 0.02649f
C721 VDD.n221 VSS 0.02649f
C722 VDD.n222 VSS 0.08643f
C723 VDD.n223 VSS 0.08643f
C724 VDD.n224 VSS 0.02649f
C725 VDD.n225 VSS 0.02649f
C726 VDD.n226 VSS 0.05298f
C727 VDD.n227 VSS 0.05298f
C728 VDD.n228 VSS 0.02649f
C729 VDD.n229 VSS 0.02649f
C730 VDD.n230 VSS 0.08643f
C731 VDD.n231 VSS 0.08643f
C732 VDD.n232 VSS 0.02649f
C733 VDD.n233 VSS 0.02649f
C734 VDD.n234 VSS 0.05298f
C735 VDD.n235 VSS 0.05298f
C736 VDD.n236 VSS 0.02649f
C737 VDD.n237 VSS 0.02649f
C738 VDD.n238 VSS 0.08643f
C739 VDD.n239 VSS 0.08643f
C740 VDD.n240 VSS 0.02649f
C741 VDD.n241 VSS 0.02649f
C742 VDD.n242 VSS 0.02649f
C743 VDD.n243 VSS 0.05298f
C744 VDD.n244 VSS 0.04987f
C745 VDD.n245 VSS 0.06631f
C746 VDD.n246 VSS 0.04984f
C747 VDD.n247 VSS 2.13011f
C748 VDD.n248 VSS 0.02914f
C749 VDD.n249 VSS 0.02914f
C750 VDD.n251 VSS 0.02914f
C751 VDD.n252 VSS 0.02914f
C752 VDD.n254 VSS 0.09205f
C753 VDD.n255 VSS 0.13061f
C754 VDD.n257 VSS 0.05298f
C755 VDD.n258 VSS 0.05298f
C756 VDD.n259 VSS 0.05298f
C757 VDD.n260 VSS 0.05298f
C758 VDD.n261 VSS 0.05298f
C759 VDD.n262 VSS 0.05298f
C760 VDD.n263 VSS 0.0412f
C761 VDD.n264 VSS 0.06042f
C762 VDD.n265 VSS 0.06042f
C763 VDD.t6 VSS 0.5577f
C764 VDD.t5 VSS 0.36554f
C765 VDD.t32 VSS 0.36554f
C766 VDD.t27 VSS 0.36554f
C767 VDD.t4 VSS 0.27465f
C768 VDD.n266 VSS 0.12547f
C769 VDD.n267 VSS 0.14308f
C770 VDD.t29 VSS 0.0296f
C771 VDD.n268 VSS 0.05964f
C772 VDD.n269 VSS 0.05298f
C773 VDD.t1 VSS 0.0296f
C774 VDD.t26 VSS 0.0296f
C775 VDD.n270 VSS 0.04683f
C776 VDD.n271 VSS 0.05298f
C777 VDD.t3 VSS 0.0296f
C778 VDD.t8 VSS 0.0296f
C779 VDD.n272 VSS 0.05298f
C780 VDD.n273 VSS 0.05298f
C781 VDD.n274 VSS 0.05298f
C782 VDD.n275 VSS 0.05298f
C783 VDD.n276 VSS 0.05298f
C784 VDD.n277 VSS 0.05298f
C785 VDD.n278 VSS 0.05298f
C786 VDD.n279 VSS 0.05298f
C787 VDD.n280 VSS 0.05298f
C788 VDD.n281 VSS 0.0353f
C789 VDD.n282 VSS 0.04683f
C790 VDD.n283 VSS 0.03444f
C791 VDD.n284 VSS 0.04683f
C792 VDD.n285 VSS 0.03444f
C793 VDD.n286 VSS 0.05298f
C794 VDD.n287 VSS 0.05298f
C795 VDD.n288 VSS 0.02768f
C796 VDD.n289 VSS 0.04683f
C797 VDD.n290 VSS 0.02709f
C798 VDD.n291 VSS 0.04987f
C799 VDD.n292 VSS 0.13385f
C800 VDD.n293 VSS 0.06538f
C801 VDD.n294 VSS 0.01276f
C802 VDD.n295 VSS 0.14308f
C803 VDD.n296 VSS 0.12152f
C804 VDD.t28 VSS 0.23612f
C805 VDD.t0 VSS 0.29145f
C806 VDD.t25 VSS 0.27169f
C807 VDD.t2 VSS 0.25687f
C808 VDD.t7 VSS 0.69008f
C809 VDD.n297 VSS 0.93657f
C810 VDD.n298 VSS 0.10172f
C811 VDD.n299 VSS 0.02649f
C812 VDD.n300 VSS 0.03828f
C813 VDD.n301 VSS 0.05298f
C814 VDD.n302 VSS 0.05298f
C815 VDD.n303 VSS 0.05298f
C816 VDD.n304 VSS 0.05298f
C817 VDD.n305 VSS 0.05298f
C818 VDD.n306 VSS 0.05298f
C819 VDD.n307 VSS 0.05298f
C820 VDD.n308 VSS 0.05298f
C821 VDD.n309 VSS 0.05298f
C822 VDD.n310 VSS 0.05298f
C823 VDD.n311 VSS 0.05298f
C824 VDD.n312 VSS 0.05298f
C825 VDD.n313 VSS 0.05298f
C826 VDD.n314 VSS 0.05298f
C827 VDD.n315 VSS 0.05298f
C828 VDD.n316 VSS 0.05298f
C829 VDD.n317 VSS 0.04451f
C830 VDD.n318 VSS 0.25053f
C831 VDD.n319 VSS 0.81144f
C832 VDD.n321 VSS 0.02852f
C833 VDD.n324 VSS 0.02852f
C834 VDD.n326 VSS 0.02852f
C835 VDD.n328 VSS 0.02848f
C836 VDD.n330 VSS 0.02852f
C837 VDD.n332 VSS 0.61614f
C838 VDD.n333 VSS 0.5685f
C839 VDD_LS.n0 VSS 0.00497f
C840 VDD_LS.n1 VSS 0.01515f
C841 VDD_LS.t1 VSS 0.00345f
C842 VDD_LS.t6 VSS 0.0021f
C843 VDD_LS.n2 VSS 0.01192f
C844 VDD_LS.n3 VSS 0.01515f
C845 VDD_LS.t8 VSS 0
C846 VDD_LS.t3 VSS 0
C847 VDD_LS.n4 VSS 0.0016f
C848 VDD_LS.t25 VSS 0.00169f
C849 VDD_LS.n5 VSS 0.01191f
C850 VDD_LS.n6 VSS 0.01515f
C851 VDD_LS.t15 VSS 0.0021f
C852 VDD_LS.t17 VSS 0
C853 VDD_LS.t12 VSS 0
C854 VDD_LS.n7 VSS 0.00266f
C855 VDD_LS.n8 VSS 0.01101f
C856 VDD_LS.n9 VSS 0.01515f
C857 VDD_LS.t19 VSS 0.00279f
C858 VDD_LS.t23 VSS 0.00409f
C859 VDD_LS.n10 VSS 0.01207f
C860 VDD_LS.t21 VSS 0.00143f
C861 VDD_LS.n11 VSS 0.13444f
C862 VDD_LS.t10 VSS 0.0021f
C863 VDD_LS.n12 VSS 0.02854f
C864 VDD_LS.n13 VSS 0.00958f
C865 VDD_LS.n14 VSS 0.07974f
C866 VDD_LS.n15 VSS 0.01515f
C867 VDD_LS.n16 VSS 0.012f
C868 VDD_LS.n17 VSS 0.01195f
C869 VDD_LS.n18 VSS 0.00805f
C870 VDD_LS.t26 VSS 0.07721f
C871 VDD_LS.t20 VSS 0.06898f
C872 VDD_LS.t9 VSS 0.06092f
C873 VDD_LS.t22 VSS 0.05099f
C874 VDD_LS.t18 VSS 0.04921f
C875 VDD_LS.t13 VSS 0.02263f
C876 VDD_LS.t0 VSS 0.05064f
C877 VDD_LS.t5 VSS 0.05019f
C878 VDD_LS.t2 VSS 0.02836f
C879 VDD_LS.t7 VSS 0.01503f
C880 VDD_LS.t4 VSS 0.02836f
C881 VDD_LS.t24 VSS 0.05591f
C882 VDD_LS.t14 VSS 0.05591f
C883 VDD_LS.t11 VSS 0.02836f
C884 VDD_LS.t16 VSS 0.01324f
C885 VDD_LS.n19 VSS -0.01454f
C886 VDD_LS.n20 VSS -0.01448f
C887 VDD_LS.n21 VSS 0.00401f
C888 VDD_LS.n22 VSS 0.01515f
C889 VDD_LS.n23 VSS 0.01515f
C890 VDD_LS.n24 VSS 0.00888f
C891 VDD_LS.n25 VSS 0.01192f
C892 VDD_LS.n26 VSS 0.01036f
C893 VDD_LS.n27 VSS 0.01513f
C894 VDD_LS.n28 VSS 0.01515f
C895 VDD_LS.n29 VSS 0.01515f
C896 VDD_LS.n30 VSS 0.00759f
C897 VDD_LS.n31 VSS 0.01204f
C898 VDD_LS.n32 VSS 0.01135f
C899 VDD_LS.n33 VSS 0.00888f
C900 VDD_LS.n34 VSS 0.01515f
C901 VDD_LS.n35 VSS 0.01515f
C902 VDD_LS.n36 VSS 0.00937f
C903 VDD_LS.n37 VSS 0.01369f
C904 VDD_LS.n38 VSS 0.01644f
C905 VDD_LS.n39 VSS 0.05579f
C906 VDD_LS.n40 VSS 0.00279f
C907 VDD_LS.t27 VSS 1.15577f
C908 VDD_LS.n41 VSS 0.39006f
C909 VDD_LS.n42 VSS 0.00191f
C910 VDD_LS.n43 VSS 0.00505f
C911 VDD_LS.n44 VSS 0.00213f
C912 VDD_LS.n45 VSS 0.00505f
C913 VDD_LS.n46 VSS 0.00505f
C914 VDD_LS.n47 VSS 0.00193f
C915 VDD_LS.t28 VSS 1.15577f
C916 VDD_LS.n48 VSS 0.00239f
C917 VDD_LS.n49 VSS 0.00151f
C918 VDD_LS.n50 VSS 0.0016f
C919 VDD_LS.n51 VSS 0.00505f
C920 VDD_LS.n52 VSS 0.00244f
C921 VDD_LS.n53 VSS 0.00151f
C922 VDD_LS.n54 VSS 0.00239f
C923 VDD_LS.n55 VSS 0.00181f
C924 VDD_LS.n56 VSS 0.00505f
C925 VDD_LS.n57 VSS 0.00505f
C926 VDD_LS.n58 VSS 0.00223f
C927 VDD_LS.n59 VSS 0.00173f
C928 VDD_LS.t29 VSS 1.15577f
C929 VDD_LS.n60 VSS 0.39006f
C930 VDD_LS.n61 VSS 0.00151f
C931 VDD_LS.n62 VSS 0.00616f
C932 VDD_LS.n63 VSS 0.00505f
C933 VDD_LS.n64 VSS 0.00523f
C934 VDD_LS.n65 VSS 0.00153f
C935 VDD_LS.t30 VSS 1.15577f
C936 VDD_LS.n66 VSS 0.00525f
C937 VDD_LS.n67 VSS 0.00151f
C938 VDD_LS.n68 VSS 0.00505f
C939 VDD_LS.n69 VSS 0.00151f
C940 VDD_LS.n70 VSS 0.00239f
C941 VDD_LS.t31 VSS 1.15577f
C942 VDD_LS.n71 VSS 0.39123f
C943 VDD_LS.n72 VSS 0.02111f
C944 VDD_LS.n73 VSS 0.02576f
C945 VDD_LS.n74 VSS 0.00375f
C946 VDD_LS.n75 VSS 0.0017f
C947 VDD_LS.n76 VSS 0.00384f
C948 VDD_LS.n77 VSS 0.00505f
C949 VDD_LS.n78 VSS 0.00372f
C950 VDD_LS.n79 VSS 0.00615f
C951 VDD_LS.n80 VSS 0.00505f
C952 VDD_LS.n81 VSS 0.00505f
C953 VDD_LS.n82 VSS 0.00243f
C954 VDD_LS.n83 VSS 0.00252f
C955 VDD_LS.n84 VSS 0.00352f
C956 VDD_LS.n85 VSS 0.39006f
C957 VDD_LS.n86 VSS 0.00352f
C958 VDD_LS.n87 VSS 0.00251f
C959 VDD_LS.n88 VSS 0.00241f
C960 VDD_LS.n89 VSS 0.00505f
C961 VDD_LS.n90 VSS 0.00505f
C962 VDD_LS.n91 VSS 0.00505f
C963 VDD_LS.n92 VSS 0.00375f
C964 VDD_LS.n93 VSS 0.00505f
C965 VDD_LS.n94 VSS 0.00384f
C966 VDD_LS.n95 VSS 0.00239f
C967 VDD_LS.n96 VSS 0.00231f
C968 VDD_LS.n97 VSS 0.00151f
C969 VDD_LS.n98 VSS 0.00505f
C970 VDD_LS.n99 VSS 0.00505f
C971 VDD_LS.n100 VSS 0.00151f
C972 VDD_LS.n101 VSS 0.00252f
C973 VDD_LS.n102 VSS 0.00384f
C974 VDD_LS.n103 VSS 0.00505f
C975 VDD_LS.n104 VSS 0.00424f
C976 VDD_LS.n105 VSS 0.00384f
C977 VDD_LS.n106 VSS 0.00505f
C978 VDD_LS.n107 VSS 0.00151f
C979 VDD_LS.n108 VSS 0.00505f
C980 VDD_LS.n109 VSS 0.00505f
C981 VDD_LS.n110 VSS 0.00151f
C982 VDD_LS.n111 VSS 0.00252f
C983 VDD_LS.n112 VSS 0.39006f
C984 VDD_LS.n113 VSS 0.00239f
C985 VDD_LS.n114 VSS 0.00384f
C986 VDD_LS.n115 VSS 0.00211f
C987 VDD_LS.n116 VSS 0.00151f
C988 VDD_LS.n117 VSS 0.00505f
C989 VDD_LS.n118 VSS 0.00505f
C990 VDD_LS.n119 VSS 0.00413f
C991 VDD_LS.n120 VSS 0.00641f
C992 VDD_LS.n121 VSS 0.00352f
C993 VDD_LS.n122 VSS 0.00474f
C994 VDD_LS.n123 VSS 0.00227f
C995 VDD_LS.n124 VSS 0.00505f
C996 VDD_LS.n125 VSS 0.00505f
C997 VDD_LS.n126 VSS 0.00151f
C998 VDD_LS.n127 VSS 0.00252f
C999 VDD_LS.n128 VSS 0.00352f
C1000 VDD_LS.n129 VSS 0.01152f
C1001 VDD_LS.n130 VSS 0.07434f
C1002 vbn.t0 VSS 0.03398f
C1003 vbn.n0 VSS 0.06559f
C1004 vbn.t35 VSS 0.20032f
C1005 vbn.t49 VSS 0.26168f
C1006 vbn.t63 VSS 0.26168f
C1007 vbn.t77 VSS 0.26168f
C1008 vbn.t91 VSS 0.26168f
C1009 vbn.t105 VSS 0.26168f
C1010 vbn.t119 VSS 0.26168f
C1011 vbn.t133 VSS 0.26168f
C1012 vbn.t147 VSS 0.26168f
C1013 vbn.t161 VSS 0.26168f
C1014 vbn.t175 VSS 0.26168f
C1015 vbn.t189 VSS 0.26168f
C1016 vbn.t203 VSS 0.26168f
C1017 vbn.t217 VSS 0.22378f
C1018 vbn.t36 VSS 0.20032f
C1019 vbn.t50 VSS 0.26168f
C1020 vbn.t64 VSS 0.26168f
C1021 vbn.t78 VSS 0.26168f
C1022 vbn.t92 VSS 0.26168f
C1023 vbn.t106 VSS 0.26168f
C1024 vbn.t120 VSS 0.26168f
C1025 vbn.t134 VSS 0.26168f
C1026 vbn.t148 VSS 0.26168f
C1027 vbn.t162 VSS 0.26168f
C1028 vbn.t176 VSS 0.26168f
C1029 vbn.t190 VSS 0.26168f
C1030 vbn.t204 VSS 0.26168f
C1031 vbn.t218 VSS 0.22378f
C1032 vbn.n1 VSS 0.05349f
C1033 vbn.t37 VSS 0.20032f
C1034 vbn.t51 VSS 0.26168f
C1035 vbn.t65 VSS 0.26168f
C1036 vbn.t79 VSS 0.26168f
C1037 vbn.t93 VSS 0.26168f
C1038 vbn.t107 VSS 0.26168f
C1039 vbn.t121 VSS 0.26168f
C1040 vbn.t135 VSS 0.26168f
C1041 vbn.t149 VSS 0.26168f
C1042 vbn.t163 VSS 0.26168f
C1043 vbn.t177 VSS 0.26168f
C1044 vbn.t191 VSS 0.26168f
C1045 vbn.t205 VSS 0.26168f
C1046 vbn.t219 VSS 0.22378f
C1047 vbn.n2 VSS 0.05349f
C1048 vbn.t38 VSS 0.20032f
C1049 vbn.t52 VSS 0.26168f
C1050 vbn.t66 VSS 0.26168f
C1051 vbn.t80 VSS 0.26168f
C1052 vbn.t94 VSS 0.26168f
C1053 vbn.t108 VSS 0.26168f
C1054 vbn.t122 VSS 0.26168f
C1055 vbn.t136 VSS 0.26168f
C1056 vbn.t150 VSS 0.26168f
C1057 vbn.t164 VSS 0.26168f
C1058 vbn.t178 VSS 0.26168f
C1059 vbn.t192 VSS 0.26168f
C1060 vbn.t206 VSS 0.26168f
C1061 vbn.t220 VSS 0.22378f
C1062 vbn.n3 VSS 0.05349f
C1063 vbn.t39 VSS 0.20032f
C1064 vbn.t53 VSS 0.26168f
C1065 vbn.t67 VSS 0.26168f
C1066 vbn.t81 VSS 0.26168f
C1067 vbn.t95 VSS 0.26168f
C1068 vbn.t109 VSS 0.26168f
C1069 vbn.t123 VSS 0.26168f
C1070 vbn.t137 VSS 0.26168f
C1071 vbn.t151 VSS 0.26168f
C1072 vbn.t165 VSS 0.26168f
C1073 vbn.t179 VSS 0.26168f
C1074 vbn.t193 VSS 0.26168f
C1075 vbn.t207 VSS 0.26168f
C1076 vbn.t221 VSS 0.22378f
C1077 vbn.n4 VSS 0.05349f
C1078 vbn.t40 VSS 0.20032f
C1079 vbn.t54 VSS 0.26168f
C1080 vbn.t68 VSS 0.26168f
C1081 vbn.t82 VSS 0.26168f
C1082 vbn.t96 VSS 0.26168f
C1083 vbn.t110 VSS 0.26168f
C1084 vbn.t124 VSS 0.26168f
C1085 vbn.t138 VSS 0.26168f
C1086 vbn.t152 VSS 0.26168f
C1087 vbn.t166 VSS 0.26168f
C1088 vbn.t180 VSS 0.26168f
C1089 vbn.t194 VSS 0.26168f
C1090 vbn.t208 VSS 0.26168f
C1091 vbn.t222 VSS 0.22378f
C1092 vbn.n5 VSS 0.05349f
C1093 vbn.t41 VSS 0.20032f
C1094 vbn.t55 VSS 0.26168f
C1095 vbn.t69 VSS 0.26168f
C1096 vbn.t83 VSS 0.26168f
C1097 vbn.t97 VSS 0.26168f
C1098 vbn.t111 VSS 0.26168f
C1099 vbn.t125 VSS 0.26168f
C1100 vbn.t139 VSS 0.26168f
C1101 vbn.t153 VSS 0.26168f
C1102 vbn.t167 VSS 0.26168f
C1103 vbn.t181 VSS 0.26168f
C1104 vbn.t195 VSS 0.26168f
C1105 vbn.t209 VSS 0.26168f
C1106 vbn.t223 VSS 0.22378f
C1107 vbn.n6 VSS 0.05349f
C1108 vbn.t42 VSS 0.20032f
C1109 vbn.t56 VSS 0.26168f
C1110 vbn.t70 VSS 0.26168f
C1111 vbn.t84 VSS 0.26168f
C1112 vbn.t98 VSS 0.26168f
C1113 vbn.t112 VSS 0.26168f
C1114 vbn.t126 VSS 0.26168f
C1115 vbn.t140 VSS 0.26168f
C1116 vbn.t154 VSS 0.26168f
C1117 vbn.t168 VSS 0.26168f
C1118 vbn.t182 VSS 0.26168f
C1119 vbn.t196 VSS 0.26168f
C1120 vbn.t210 VSS 0.26168f
C1121 vbn.t224 VSS 0.22378f
C1122 vbn.n7 VSS 0.03943f
C1123 vbn.t43 VSS 0.20032f
C1124 vbn.t57 VSS 0.26168f
C1125 vbn.t71 VSS 0.26168f
C1126 vbn.t85 VSS 0.26168f
C1127 vbn.t99 VSS 0.26168f
C1128 vbn.t113 VSS 0.26168f
C1129 vbn.t127 VSS 0.26168f
C1130 vbn.t141 VSS 0.26168f
C1131 vbn.t155 VSS 0.26168f
C1132 vbn.t169 VSS 0.26168f
C1133 vbn.t183 VSS 0.26168f
C1134 vbn.t197 VSS 0.26168f
C1135 vbn.t211 VSS 0.26168f
C1136 vbn.t225 VSS 0.22378f
C1137 vbn.t2 VSS 0.17686f
C1138 vbn.t4 VSS 0.17686f
C1139 vbn.n8 VSS 0.84332f
C1140 vbn.n9 VSS 0.09861f
C1141 vbn.n10 VSS 0.0408f
C1142 vbn.t44 VSS 0.20032f
C1143 vbn.t58 VSS 0.26168f
C1144 vbn.t72 VSS 0.26168f
C1145 vbn.t86 VSS 0.26168f
C1146 vbn.t100 VSS 0.26168f
C1147 vbn.t114 VSS 0.26168f
C1148 vbn.t128 VSS 0.26168f
C1149 vbn.t142 VSS 0.26168f
C1150 vbn.t156 VSS 0.26168f
C1151 vbn.t170 VSS 0.26168f
C1152 vbn.t184 VSS 0.26168f
C1153 vbn.t198 VSS 0.26168f
C1154 vbn.t212 VSS 0.26168f
C1155 vbn.t226 VSS 0.22378f
C1156 vbn.n11 VSS 0.05349f
C1157 vbn.t45 VSS 0.20032f
C1158 vbn.t59 VSS 0.26168f
C1159 vbn.t73 VSS 0.26168f
C1160 vbn.t87 VSS 0.26168f
C1161 vbn.t101 VSS 0.26168f
C1162 vbn.t115 VSS 0.26168f
C1163 vbn.t129 VSS 0.26168f
C1164 vbn.t143 VSS 0.26168f
C1165 vbn.t157 VSS 0.26168f
C1166 vbn.t171 VSS 0.26168f
C1167 vbn.t185 VSS 0.26168f
C1168 vbn.t199 VSS 0.26168f
C1169 vbn.t213 VSS 0.26168f
C1170 vbn.t227 VSS 0.22378f
C1171 vbn.n12 VSS 0.05349f
C1172 vbn.t46 VSS 0.20032f
C1173 vbn.t60 VSS 0.26168f
C1174 vbn.t74 VSS 0.26168f
C1175 vbn.t88 VSS 0.26168f
C1176 vbn.t102 VSS 0.26168f
C1177 vbn.t116 VSS 0.26168f
C1178 vbn.t130 VSS 0.26168f
C1179 vbn.t144 VSS 0.26168f
C1180 vbn.t158 VSS 0.26168f
C1181 vbn.t172 VSS 0.26168f
C1182 vbn.t186 VSS 0.26168f
C1183 vbn.t200 VSS 0.26168f
C1184 vbn.t214 VSS 0.26168f
C1185 vbn.t228 VSS 0.22378f
C1186 vbn.n13 VSS 0.05349f
C1187 vbn.t47 VSS 0.20032f
C1188 vbn.t61 VSS 0.26168f
C1189 vbn.t75 VSS 0.26168f
C1190 vbn.t89 VSS 0.26168f
C1191 vbn.t103 VSS 0.26168f
C1192 vbn.t117 VSS 0.26168f
C1193 vbn.t131 VSS 0.26168f
C1194 vbn.t145 VSS 0.26168f
C1195 vbn.t159 VSS 0.26168f
C1196 vbn.t173 VSS 0.26168f
C1197 vbn.t187 VSS 0.26168f
C1198 vbn.t201 VSS 0.26168f
C1199 vbn.t215 VSS 0.26168f
C1200 vbn.t229 VSS 0.22378f
C1201 vbn.n14 VSS 0.07989f
C1202 vbn.t48 VSS 0.20032f
C1203 vbn.t62 VSS 0.26168f
C1204 vbn.t76 VSS 0.26168f
C1205 vbn.t90 VSS 0.26168f
C1206 vbn.t104 VSS 0.26168f
C1207 vbn.t118 VSS 0.26168f
C1208 vbn.t132 VSS 0.26168f
C1209 vbn.t146 VSS 0.26168f
C1210 vbn.t160 VSS 0.26168f
C1211 vbn.t174 VSS 0.26168f
C1212 vbn.t188 VSS 0.26168f
C1213 vbn.t202 VSS 0.26168f
C1214 vbn.t216 VSS 0.26168f
C1215 vbn.t230 VSS 0.22378f
C1216 vbn.n15 VSS 0.06531f
C1217 vbn.t231 VSS 0.20032f
C1218 vbn.t238 VSS 0.26168f
C1219 vbn.t245 VSS 0.26168f
C1220 vbn.t252 VSS 0.26168f
C1221 vbn.t259 VSS 0.26168f
C1222 vbn.t266 VSS 0.26168f
C1223 vbn.t273 VSS 0.26168f
C1224 vbn.t280 VSS 0.26168f
C1225 vbn.t287 VSS 0.26168f
C1226 vbn.t294 VSS 0.26168f
C1227 vbn.t301 VSS 0.26168f
C1228 vbn.t308 VSS 0.26168f
C1229 vbn.t315 VSS 0.26168f
C1230 vbn.t32 VSS 0.22378f
C1231 vbn.t33 VSS 0.02527f
C1232 vbn.t31 VSS 0.02527f
C1233 vbn.n16 VSS 0.05946f
C1234 vbn.n17 VSS 0.12861f
C1235 vbn.n18 VSS 0.10452f
C1236 vbn.t232 VSS 0.20032f
C1237 vbn.t239 VSS 0.26168f
C1238 vbn.t246 VSS 0.26168f
C1239 vbn.t253 VSS 0.26168f
C1240 vbn.t260 VSS 0.26168f
C1241 vbn.t267 VSS 0.26168f
C1242 vbn.t274 VSS 0.26168f
C1243 vbn.t281 VSS 0.26168f
C1244 vbn.t288 VSS 0.26168f
C1245 vbn.t295 VSS 0.26168f
C1246 vbn.t302 VSS 0.26168f
C1247 vbn.t309 VSS 0.26168f
C1248 vbn.t316 VSS 0.26168f
C1249 vbn.t30 VSS 0.22378f
C1250 vbn.n19 VSS 0.10452f
C1251 vbn.t233 VSS 0.20032f
C1252 vbn.t240 VSS 0.26168f
C1253 vbn.t247 VSS 0.26168f
C1254 vbn.t254 VSS 0.26168f
C1255 vbn.t261 VSS 0.26168f
C1256 vbn.t268 VSS 0.26168f
C1257 vbn.t275 VSS 0.26168f
C1258 vbn.t282 VSS 0.26168f
C1259 vbn.t289 VSS 0.26168f
C1260 vbn.t296 VSS 0.26168f
C1261 vbn.t303 VSS 0.26168f
C1262 vbn.t310 VSS 0.26168f
C1263 vbn.t317 VSS 0.26168f
C1264 vbn.t28 VSS 0.22378f
C1265 vbn.t29 VSS 0.02527f
C1266 vbn.t27 VSS 0.02527f
C1267 vbn.n20 VSS 0.05946f
C1268 vbn.n21 VSS 0.13841f
C1269 vbn.n22 VSS 0.10452f
C1270 vbn.t234 VSS 0.20032f
C1271 vbn.t241 VSS 0.26168f
C1272 vbn.t248 VSS 0.26168f
C1273 vbn.t255 VSS 0.26168f
C1274 vbn.t262 VSS 0.26168f
C1275 vbn.t269 VSS 0.26168f
C1276 vbn.t276 VSS 0.26168f
C1277 vbn.t283 VSS 0.26168f
C1278 vbn.t290 VSS 0.26168f
C1279 vbn.t297 VSS 0.26168f
C1280 vbn.t304 VSS 0.26168f
C1281 vbn.t311 VSS 0.26168f
C1282 vbn.t318 VSS 0.26168f
C1283 vbn.t26 VSS 0.22378f
C1284 vbn.n23 VSS 0.10452f
C1285 vbn.t235 VSS 0.20032f
C1286 vbn.t242 VSS 0.26168f
C1287 vbn.t249 VSS 0.26168f
C1288 vbn.t256 VSS 0.26168f
C1289 vbn.t263 VSS 0.26168f
C1290 vbn.t270 VSS 0.26168f
C1291 vbn.t277 VSS 0.26168f
C1292 vbn.t284 VSS 0.26168f
C1293 vbn.t291 VSS 0.26168f
C1294 vbn.t298 VSS 0.26168f
C1295 vbn.t305 VSS 0.26168f
C1296 vbn.t312 VSS 0.26168f
C1297 vbn.t319 VSS 0.26168f
C1298 vbn.t24 VSS 0.22378f
C1299 vbn.t25 VSS 0.02527f
C1300 vbn.t23 VSS 0.02527f
C1301 vbn.n24 VSS 0.05946f
C1302 vbn.n25 VSS 0.13841f
C1303 vbn.n26 VSS 0.10452f
C1304 vbn.t236 VSS 0.20032f
C1305 vbn.t243 VSS 0.26168f
C1306 vbn.t250 VSS 0.26168f
C1307 vbn.t257 VSS 0.26168f
C1308 vbn.t264 VSS 0.26168f
C1309 vbn.t271 VSS 0.26168f
C1310 vbn.t278 VSS 0.26168f
C1311 vbn.t285 VSS 0.26168f
C1312 vbn.t292 VSS 0.26168f
C1313 vbn.t299 VSS 0.26168f
C1314 vbn.t306 VSS 0.26168f
C1315 vbn.t313 VSS 0.26168f
C1316 vbn.t320 VSS 0.26168f
C1317 vbn.t22 VSS 0.22378f
C1318 vbn.n27 VSS 0.10385f
C1319 vbn.t237 VSS 0.20032f
C1320 vbn.t244 VSS 0.26168f
C1321 vbn.t251 VSS 0.26168f
C1322 vbn.t258 VSS 0.26168f
C1323 vbn.t265 VSS 0.26168f
C1324 vbn.t272 VSS 0.26168f
C1325 vbn.t279 VSS 0.26168f
C1326 vbn.t286 VSS 0.26168f
C1327 vbn.t293 VSS 0.26168f
C1328 vbn.t300 VSS 0.26168f
C1329 vbn.t307 VSS 0.26168f
C1330 vbn.t314 VSS 0.26168f
C1331 vbn.t321 VSS 0.26168f
C1332 vbn.t20 VSS 0.22378f
C1333 vbn.t21 VSS 0.06973f
C1334 vbn.n28 VSS 0.17558f
C1335 vbn.n29 VSS 0.06501f
C1336 vbn.t322 VSS 0.20032f
C1337 vbn.t350 VSS 0.26168f
C1338 vbn.t378 VSS 0.26168f
C1339 vbn.t406 VSS 0.26168f
C1340 vbn.t434 VSS 0.26168f
C1341 vbn.t462 VSS 0.26168f
C1342 vbn.t490 VSS 0.26168f
C1343 vbn.t518 VSS 0.26168f
C1344 vbn.t546 VSS 0.26168f
C1345 vbn.t574 VSS 0.26168f
C1346 vbn.t602 VSS 0.26168f
C1347 vbn.t630 VSS 0.26168f
C1348 vbn.t658 VSS 0.26168f
C1349 vbn.t686 VSS 0.22378f
C1350 vbn.n30 VSS 0.05349f
C1351 vbn.t323 VSS 0.20032f
C1352 vbn.t351 VSS 0.26168f
C1353 vbn.t379 VSS 0.26168f
C1354 vbn.t407 VSS 0.26168f
C1355 vbn.t435 VSS 0.26168f
C1356 vbn.t463 VSS 0.26168f
C1357 vbn.t491 VSS 0.26168f
C1358 vbn.t519 VSS 0.26168f
C1359 vbn.t547 VSS 0.26168f
C1360 vbn.t575 VSS 0.26168f
C1361 vbn.t603 VSS 0.26168f
C1362 vbn.t631 VSS 0.26168f
C1363 vbn.t659 VSS 0.26168f
C1364 vbn.t687 VSS 0.22378f
C1365 vbn.n31 VSS 0.05349f
C1366 vbn.t324 VSS 0.20032f
C1367 vbn.t352 VSS 0.26168f
C1368 vbn.t380 VSS 0.26168f
C1369 vbn.t408 VSS 0.26168f
C1370 vbn.t436 VSS 0.26168f
C1371 vbn.t464 VSS 0.26168f
C1372 vbn.t492 VSS 0.26168f
C1373 vbn.t520 VSS 0.26168f
C1374 vbn.t548 VSS 0.26168f
C1375 vbn.t576 VSS 0.26168f
C1376 vbn.t604 VSS 0.26168f
C1377 vbn.t632 VSS 0.26168f
C1378 vbn.t660 VSS 0.26168f
C1379 vbn.t688 VSS 0.22378f
C1380 vbn.n32 VSS 0.05349f
C1381 vbn.t325 VSS 0.20032f
C1382 vbn.t353 VSS 0.26168f
C1383 vbn.t381 VSS 0.26168f
C1384 vbn.t409 VSS 0.26168f
C1385 vbn.t437 VSS 0.26168f
C1386 vbn.t465 VSS 0.26168f
C1387 vbn.t493 VSS 0.26168f
C1388 vbn.t521 VSS 0.26168f
C1389 vbn.t549 VSS 0.26168f
C1390 vbn.t577 VSS 0.26168f
C1391 vbn.t605 VSS 0.26168f
C1392 vbn.t633 VSS 0.26168f
C1393 vbn.t661 VSS 0.26168f
C1394 vbn.t689 VSS 0.22378f
C1395 vbn.n33 VSS 0.05349f
C1396 vbn.t326 VSS 0.20032f
C1397 vbn.t354 VSS 0.26168f
C1398 vbn.t382 VSS 0.26168f
C1399 vbn.t410 VSS 0.26168f
C1400 vbn.t438 VSS 0.26168f
C1401 vbn.t466 VSS 0.26168f
C1402 vbn.t494 VSS 0.26168f
C1403 vbn.t522 VSS 0.26168f
C1404 vbn.t550 VSS 0.26168f
C1405 vbn.t578 VSS 0.26168f
C1406 vbn.t606 VSS 0.26168f
C1407 vbn.t634 VSS 0.26168f
C1408 vbn.t662 VSS 0.26168f
C1409 vbn.t690 VSS 0.22378f
C1410 vbn.n34 VSS 0.05349f
C1411 vbn.t327 VSS 0.20032f
C1412 vbn.t355 VSS 0.26168f
C1413 vbn.t383 VSS 0.26168f
C1414 vbn.t411 VSS 0.26168f
C1415 vbn.t439 VSS 0.26168f
C1416 vbn.t467 VSS 0.26168f
C1417 vbn.t495 VSS 0.26168f
C1418 vbn.t523 VSS 0.26168f
C1419 vbn.t551 VSS 0.26168f
C1420 vbn.t579 VSS 0.26168f
C1421 vbn.t607 VSS 0.26168f
C1422 vbn.t635 VSS 0.26168f
C1423 vbn.t663 VSS 0.26168f
C1424 vbn.t691 VSS 0.22378f
C1425 vbn.n35 VSS 0.05349f
C1426 vbn.t328 VSS 0.20032f
C1427 vbn.t356 VSS 0.26168f
C1428 vbn.t384 VSS 0.26168f
C1429 vbn.t412 VSS 0.26168f
C1430 vbn.t440 VSS 0.26168f
C1431 vbn.t468 VSS 0.26168f
C1432 vbn.t496 VSS 0.26168f
C1433 vbn.t524 VSS 0.26168f
C1434 vbn.t552 VSS 0.26168f
C1435 vbn.t580 VSS 0.26168f
C1436 vbn.t608 VSS 0.26168f
C1437 vbn.t636 VSS 0.26168f
C1438 vbn.t664 VSS 0.26168f
C1439 vbn.t692 VSS 0.22378f
C1440 vbn.n36 VSS 0.05349f
C1441 vbn.t329 VSS 0.20032f
C1442 vbn.t357 VSS 0.26168f
C1443 vbn.t385 VSS 0.26168f
C1444 vbn.t413 VSS 0.26168f
C1445 vbn.t441 VSS 0.26168f
C1446 vbn.t469 VSS 0.26168f
C1447 vbn.t497 VSS 0.26168f
C1448 vbn.t525 VSS 0.26168f
C1449 vbn.t553 VSS 0.26168f
C1450 vbn.t581 VSS 0.26168f
C1451 vbn.t609 VSS 0.26168f
C1452 vbn.t637 VSS 0.26168f
C1453 vbn.t665 VSS 0.26168f
C1454 vbn.t693 VSS 0.22378f
C1455 vbn.n37 VSS 0.05349f
C1456 vbn.t330 VSS 0.20032f
C1457 vbn.t358 VSS 0.26168f
C1458 vbn.t386 VSS 0.26168f
C1459 vbn.t414 VSS 0.26168f
C1460 vbn.t442 VSS 0.26168f
C1461 vbn.t470 VSS 0.26168f
C1462 vbn.t498 VSS 0.26168f
C1463 vbn.t526 VSS 0.26168f
C1464 vbn.t554 VSS 0.26168f
C1465 vbn.t582 VSS 0.26168f
C1466 vbn.t610 VSS 0.26168f
C1467 vbn.t638 VSS 0.26168f
C1468 vbn.t666 VSS 0.26168f
C1469 vbn.t694 VSS 0.22378f
C1470 vbn.n38 VSS 0.05349f
C1471 vbn.t331 VSS 0.20032f
C1472 vbn.t359 VSS 0.26168f
C1473 vbn.t387 VSS 0.26168f
C1474 vbn.t415 VSS 0.26168f
C1475 vbn.t443 VSS 0.26168f
C1476 vbn.t471 VSS 0.26168f
C1477 vbn.t499 VSS 0.26168f
C1478 vbn.t527 VSS 0.26168f
C1479 vbn.t555 VSS 0.26168f
C1480 vbn.t583 VSS 0.26168f
C1481 vbn.t611 VSS 0.26168f
C1482 vbn.t639 VSS 0.26168f
C1483 vbn.t667 VSS 0.26168f
C1484 vbn.t695 VSS 0.22378f
C1485 vbn.n39 VSS 0.05349f
C1486 vbn.t332 VSS 0.20032f
C1487 vbn.t360 VSS 0.26168f
C1488 vbn.t388 VSS 0.26168f
C1489 vbn.t416 VSS 0.26168f
C1490 vbn.t444 VSS 0.26168f
C1491 vbn.t472 VSS 0.26168f
C1492 vbn.t500 VSS 0.26168f
C1493 vbn.t528 VSS 0.26168f
C1494 vbn.t556 VSS 0.26168f
C1495 vbn.t584 VSS 0.26168f
C1496 vbn.t612 VSS 0.26168f
C1497 vbn.t640 VSS 0.26168f
C1498 vbn.t668 VSS 0.26168f
C1499 vbn.t696 VSS 0.22378f
C1500 vbn.n40 VSS 0.05349f
C1501 vbn.t333 VSS 0.20032f
C1502 vbn.t361 VSS 0.26168f
C1503 vbn.t389 VSS 0.26168f
C1504 vbn.t417 VSS 0.26168f
C1505 vbn.t445 VSS 0.26168f
C1506 vbn.t473 VSS 0.26168f
C1507 vbn.t501 VSS 0.26168f
C1508 vbn.t529 VSS 0.26168f
C1509 vbn.t557 VSS 0.26168f
C1510 vbn.t585 VSS 0.26168f
C1511 vbn.t613 VSS 0.26168f
C1512 vbn.t641 VSS 0.26168f
C1513 vbn.t669 VSS 0.26168f
C1514 vbn.t697 VSS 0.22378f
C1515 vbn.n41 VSS 0.05349f
C1516 vbn.t334 VSS 0.20032f
C1517 vbn.t362 VSS 0.26168f
C1518 vbn.t390 VSS 0.26168f
C1519 vbn.t418 VSS 0.26168f
C1520 vbn.t446 VSS 0.26168f
C1521 vbn.t474 VSS 0.26168f
C1522 vbn.t502 VSS 0.26168f
C1523 vbn.t530 VSS 0.26168f
C1524 vbn.t558 VSS 0.26168f
C1525 vbn.t586 VSS 0.26168f
C1526 vbn.t614 VSS 0.26168f
C1527 vbn.t642 VSS 0.26168f
C1528 vbn.t670 VSS 0.26168f
C1529 vbn.t698 VSS 0.22378f
C1530 vbn.n42 VSS 0.05349f
C1531 vbn.t335 VSS 0.20032f
C1532 vbn.t363 VSS 0.26168f
C1533 vbn.t391 VSS 0.26168f
C1534 vbn.t419 VSS 0.26168f
C1535 vbn.t447 VSS 0.26168f
C1536 vbn.t475 VSS 0.26168f
C1537 vbn.t503 VSS 0.26168f
C1538 vbn.t531 VSS 0.26168f
C1539 vbn.t559 VSS 0.26168f
C1540 vbn.t587 VSS 0.26168f
C1541 vbn.t615 VSS 0.26168f
C1542 vbn.t643 VSS 0.26168f
C1543 vbn.t671 VSS 0.26168f
C1544 vbn.t699 VSS 0.22378f
C1545 vbn.n43 VSS 0.05349f
C1546 vbn.t336 VSS 0.20032f
C1547 vbn.t364 VSS 0.26168f
C1548 vbn.t392 VSS 0.26168f
C1549 vbn.t420 VSS 0.26168f
C1550 vbn.t448 VSS 0.26168f
C1551 vbn.t476 VSS 0.26168f
C1552 vbn.t504 VSS 0.26168f
C1553 vbn.t532 VSS 0.26168f
C1554 vbn.t560 VSS 0.26168f
C1555 vbn.t588 VSS 0.26168f
C1556 vbn.t616 VSS 0.26168f
C1557 vbn.t644 VSS 0.26168f
C1558 vbn.t672 VSS 0.26168f
C1559 vbn.t700 VSS 0.22378f
C1560 vbn.n44 VSS 0.05349f
C1561 vbn.t337 VSS 0.20032f
C1562 vbn.t365 VSS 0.26168f
C1563 vbn.t393 VSS 0.26168f
C1564 vbn.t421 VSS 0.26168f
C1565 vbn.t449 VSS 0.26168f
C1566 vbn.t477 VSS 0.26168f
C1567 vbn.t505 VSS 0.26168f
C1568 vbn.t533 VSS 0.26168f
C1569 vbn.t561 VSS 0.26168f
C1570 vbn.t589 VSS 0.26168f
C1571 vbn.t617 VSS 0.26168f
C1572 vbn.t645 VSS 0.26168f
C1573 vbn.t673 VSS 0.26168f
C1574 vbn.t701 VSS 0.22378f
C1575 vbn.n45 VSS 0.05349f
C1576 vbn.t338 VSS 0.20032f
C1577 vbn.t366 VSS 0.26168f
C1578 vbn.t394 VSS 0.26168f
C1579 vbn.t422 VSS 0.26168f
C1580 vbn.t450 VSS 0.26168f
C1581 vbn.t478 VSS 0.26168f
C1582 vbn.t506 VSS 0.26168f
C1583 vbn.t534 VSS 0.26168f
C1584 vbn.t562 VSS 0.26168f
C1585 vbn.t590 VSS 0.26168f
C1586 vbn.t618 VSS 0.26168f
C1587 vbn.t646 VSS 0.26168f
C1588 vbn.t674 VSS 0.26168f
C1589 vbn.t702 VSS 0.22378f
C1590 vbn.n46 VSS 0.05349f
C1591 vbn.t339 VSS 0.20032f
C1592 vbn.t367 VSS 0.26168f
C1593 vbn.t395 VSS 0.26168f
C1594 vbn.t423 VSS 0.26168f
C1595 vbn.t451 VSS 0.26168f
C1596 vbn.t479 VSS 0.26168f
C1597 vbn.t507 VSS 0.26168f
C1598 vbn.t535 VSS 0.26168f
C1599 vbn.t563 VSS 0.26168f
C1600 vbn.t591 VSS 0.26168f
C1601 vbn.t619 VSS 0.26168f
C1602 vbn.t647 VSS 0.26168f
C1603 vbn.t675 VSS 0.26168f
C1604 vbn.t703 VSS 0.22378f
C1605 vbn.n47 VSS 0.05349f
C1606 vbn.t340 VSS 0.20032f
C1607 vbn.t368 VSS 0.26168f
C1608 vbn.t396 VSS 0.26168f
C1609 vbn.t424 VSS 0.26168f
C1610 vbn.t452 VSS 0.26168f
C1611 vbn.t480 VSS 0.26168f
C1612 vbn.t508 VSS 0.26168f
C1613 vbn.t536 VSS 0.26168f
C1614 vbn.t564 VSS 0.26168f
C1615 vbn.t592 VSS 0.26168f
C1616 vbn.t620 VSS 0.26168f
C1617 vbn.t648 VSS 0.26168f
C1618 vbn.t676 VSS 0.26168f
C1619 vbn.t704 VSS 0.22378f
C1620 vbn.n48 VSS 0.05349f
C1621 vbn.t341 VSS 0.20032f
C1622 vbn.t369 VSS 0.26168f
C1623 vbn.t397 VSS 0.26168f
C1624 vbn.t425 VSS 0.26168f
C1625 vbn.t453 VSS 0.26168f
C1626 vbn.t481 VSS 0.26168f
C1627 vbn.t509 VSS 0.26168f
C1628 vbn.t537 VSS 0.26168f
C1629 vbn.t565 VSS 0.26168f
C1630 vbn.t593 VSS 0.26168f
C1631 vbn.t621 VSS 0.26168f
C1632 vbn.t649 VSS 0.26168f
C1633 vbn.t677 VSS 0.26168f
C1634 vbn.t705 VSS 0.22378f
C1635 vbn.n49 VSS 0.05349f
C1636 vbn.t342 VSS 0.20032f
C1637 vbn.t370 VSS 0.26168f
C1638 vbn.t398 VSS 0.26168f
C1639 vbn.t426 VSS 0.26168f
C1640 vbn.t454 VSS 0.26168f
C1641 vbn.t482 VSS 0.26168f
C1642 vbn.t510 VSS 0.26168f
C1643 vbn.t538 VSS 0.26168f
C1644 vbn.t566 VSS 0.26168f
C1645 vbn.t594 VSS 0.26168f
C1646 vbn.t622 VSS 0.26168f
C1647 vbn.t650 VSS 0.26168f
C1648 vbn.t678 VSS 0.26168f
C1649 vbn.t706 VSS 0.22378f
C1650 vbn.n50 VSS 0.05349f
C1651 vbn.t343 VSS 0.20032f
C1652 vbn.t371 VSS 0.26168f
C1653 vbn.t399 VSS 0.26168f
C1654 vbn.t427 VSS 0.26168f
C1655 vbn.t455 VSS 0.26168f
C1656 vbn.t483 VSS 0.26168f
C1657 vbn.t511 VSS 0.26168f
C1658 vbn.t539 VSS 0.26168f
C1659 vbn.t567 VSS 0.26168f
C1660 vbn.t595 VSS 0.26168f
C1661 vbn.t623 VSS 0.26168f
C1662 vbn.t651 VSS 0.26168f
C1663 vbn.t679 VSS 0.26168f
C1664 vbn.t707 VSS 0.22378f
C1665 vbn.n51 VSS 0.05349f
C1666 vbn.t344 VSS 0.20032f
C1667 vbn.t372 VSS 0.26168f
C1668 vbn.t400 VSS 0.26168f
C1669 vbn.t428 VSS 0.26168f
C1670 vbn.t456 VSS 0.26168f
C1671 vbn.t484 VSS 0.26168f
C1672 vbn.t512 VSS 0.26168f
C1673 vbn.t540 VSS 0.26168f
C1674 vbn.t568 VSS 0.26168f
C1675 vbn.t596 VSS 0.26168f
C1676 vbn.t624 VSS 0.26168f
C1677 vbn.t652 VSS 0.26168f
C1678 vbn.t680 VSS 0.26168f
C1679 vbn.t708 VSS 0.22378f
C1680 vbn.n52 VSS 0.05349f
C1681 vbn.t345 VSS 0.20032f
C1682 vbn.t373 VSS 0.26168f
C1683 vbn.t401 VSS 0.26168f
C1684 vbn.t429 VSS 0.26168f
C1685 vbn.t457 VSS 0.26168f
C1686 vbn.t485 VSS 0.26168f
C1687 vbn.t513 VSS 0.26168f
C1688 vbn.t541 VSS 0.26168f
C1689 vbn.t569 VSS 0.26168f
C1690 vbn.t597 VSS 0.26168f
C1691 vbn.t625 VSS 0.26168f
C1692 vbn.t653 VSS 0.26168f
C1693 vbn.t681 VSS 0.26168f
C1694 vbn.t709 VSS 0.22378f
C1695 vbn.n53 VSS 0.05349f
C1696 vbn.t346 VSS 0.20032f
C1697 vbn.t374 VSS 0.26168f
C1698 vbn.t402 VSS 0.26168f
C1699 vbn.t430 VSS 0.26168f
C1700 vbn.t458 VSS 0.26168f
C1701 vbn.t486 VSS 0.26168f
C1702 vbn.t514 VSS 0.26168f
C1703 vbn.t542 VSS 0.26168f
C1704 vbn.t570 VSS 0.26168f
C1705 vbn.t598 VSS 0.26168f
C1706 vbn.t626 VSS 0.26168f
C1707 vbn.t654 VSS 0.26168f
C1708 vbn.t682 VSS 0.26168f
C1709 vbn.t710 VSS 0.22378f
C1710 vbn.n54 VSS 0.05349f
C1711 vbn.t347 VSS 0.20032f
C1712 vbn.t375 VSS 0.26168f
C1713 vbn.t403 VSS 0.26168f
C1714 vbn.t431 VSS 0.26168f
C1715 vbn.t459 VSS 0.26168f
C1716 vbn.t487 VSS 0.26168f
C1717 vbn.t515 VSS 0.26168f
C1718 vbn.t543 VSS 0.26168f
C1719 vbn.t571 VSS 0.26168f
C1720 vbn.t599 VSS 0.26168f
C1721 vbn.t627 VSS 0.26168f
C1722 vbn.t655 VSS 0.26168f
C1723 vbn.t683 VSS 0.26168f
C1724 vbn.t711 VSS 0.22378f
C1725 vbn.n55 VSS 0.05349f
C1726 vbn.t348 VSS 0.20032f
C1727 vbn.t376 VSS 0.26168f
C1728 vbn.t404 VSS 0.26168f
C1729 vbn.t432 VSS 0.26168f
C1730 vbn.t460 VSS 0.26168f
C1731 vbn.t488 VSS 0.26168f
C1732 vbn.t516 VSS 0.26168f
C1733 vbn.t544 VSS 0.26168f
C1734 vbn.t572 VSS 0.26168f
C1735 vbn.t600 VSS 0.26168f
C1736 vbn.t628 VSS 0.26168f
C1737 vbn.t656 VSS 0.26168f
C1738 vbn.t684 VSS 0.26168f
C1739 vbn.t712 VSS 0.22378f
C1740 vbn.n56 VSS 0.07989f
C1741 vbn.t349 VSS 0.20032f
C1742 vbn.t377 VSS 0.26168f
C1743 vbn.t405 VSS 0.26168f
C1744 vbn.t433 VSS 0.26168f
C1745 vbn.t461 VSS 0.26168f
C1746 vbn.t489 VSS 0.26168f
C1747 vbn.t517 VSS 0.26168f
C1748 vbn.t545 VSS 0.26168f
C1749 vbn.t573 VSS 0.26168f
C1750 vbn.t601 VSS 0.26168f
C1751 vbn.t629 VSS 0.26168f
C1752 vbn.t657 VSS 0.26168f
C1753 vbn.t685 VSS 0.26168f
C1754 vbn.t713 VSS 0.22378f
C1755 vbn.n57 VSS 0.06531f
C1756 vbn.t714 VSS 0.20032f
C1757 vbn.t721 VSS 0.26168f
C1758 vbn.t728 VSS 0.26168f
C1759 vbn.t735 VSS 0.26168f
C1760 vbn.t742 VSS 0.26168f
C1761 vbn.t749 VSS 0.26168f
C1762 vbn.t756 VSS 0.26168f
C1763 vbn.t763 VSS 0.26168f
C1764 vbn.t770 VSS 0.26168f
C1765 vbn.t777 VSS 0.26168f
C1766 vbn.t784 VSS 0.26168f
C1767 vbn.t791 VSS 0.26168f
C1768 vbn.t798 VSS 0.26168f
C1769 vbn.t18 VSS 0.22378f
C1770 vbn.t19 VSS 0.02527f
C1771 vbn.t17 VSS 0.02527f
C1772 vbn.n58 VSS 0.05946f
C1773 vbn.n59 VSS 0.12861f
C1774 vbn.n60 VSS 0.10452f
C1775 vbn.t715 VSS 0.20032f
C1776 vbn.t722 VSS 0.26168f
C1777 vbn.t729 VSS 0.26168f
C1778 vbn.t736 VSS 0.26168f
C1779 vbn.t743 VSS 0.26168f
C1780 vbn.t750 VSS 0.26168f
C1781 vbn.t757 VSS 0.26168f
C1782 vbn.t764 VSS 0.26168f
C1783 vbn.t771 VSS 0.26168f
C1784 vbn.t778 VSS 0.26168f
C1785 vbn.t785 VSS 0.26168f
C1786 vbn.t792 VSS 0.26168f
C1787 vbn.t799 VSS 0.26168f
C1788 vbn.t16 VSS 0.22378f
C1789 vbn.n61 VSS 0.10452f
C1790 vbn.t716 VSS 0.20032f
C1791 vbn.t723 VSS 0.26168f
C1792 vbn.t730 VSS 0.26168f
C1793 vbn.t737 VSS 0.26168f
C1794 vbn.t744 VSS 0.26168f
C1795 vbn.t751 VSS 0.26168f
C1796 vbn.t758 VSS 0.26168f
C1797 vbn.t765 VSS 0.26168f
C1798 vbn.t772 VSS 0.26168f
C1799 vbn.t779 VSS 0.26168f
C1800 vbn.t786 VSS 0.26168f
C1801 vbn.t793 VSS 0.26168f
C1802 vbn.t800 VSS 0.26168f
C1803 vbn.t14 VSS 0.22378f
C1804 vbn.t15 VSS 0.02527f
C1805 vbn.t13 VSS 0.02527f
C1806 vbn.n62 VSS 0.05946f
C1807 vbn.n63 VSS 0.13841f
C1808 vbn.n64 VSS 0.10452f
C1809 vbn.t717 VSS 0.20032f
C1810 vbn.t724 VSS 0.26168f
C1811 vbn.t731 VSS 0.26168f
C1812 vbn.t738 VSS 0.26168f
C1813 vbn.t745 VSS 0.26168f
C1814 vbn.t752 VSS 0.26168f
C1815 vbn.t759 VSS 0.26168f
C1816 vbn.t766 VSS 0.26168f
C1817 vbn.t773 VSS 0.26168f
C1818 vbn.t780 VSS 0.26168f
C1819 vbn.t787 VSS 0.26168f
C1820 vbn.t794 VSS 0.26168f
C1821 vbn.t801 VSS 0.26168f
C1822 vbn.t12 VSS 0.22378f
C1823 vbn.n65 VSS 0.10452f
C1824 vbn.t718 VSS 0.20032f
C1825 vbn.t725 VSS 0.26168f
C1826 vbn.t732 VSS 0.26168f
C1827 vbn.t739 VSS 0.26168f
C1828 vbn.t746 VSS 0.26168f
C1829 vbn.t753 VSS 0.26168f
C1830 vbn.t760 VSS 0.26168f
C1831 vbn.t767 VSS 0.26168f
C1832 vbn.t774 VSS 0.26168f
C1833 vbn.t781 VSS 0.26168f
C1834 vbn.t788 VSS 0.26168f
C1835 vbn.t795 VSS 0.26168f
C1836 vbn.t802 VSS 0.26168f
C1837 vbn.t10 VSS 0.22378f
C1838 vbn.t11 VSS 0.02527f
C1839 vbn.t9 VSS 0.02527f
C1840 vbn.n66 VSS 0.05946f
C1841 vbn.n67 VSS 0.13841f
C1842 vbn.n68 VSS 0.10452f
C1843 vbn.t719 VSS 0.20032f
C1844 vbn.t726 VSS 0.26168f
C1845 vbn.t733 VSS 0.26168f
C1846 vbn.t740 VSS 0.26168f
C1847 vbn.t747 VSS 0.26168f
C1848 vbn.t754 VSS 0.26168f
C1849 vbn.t761 VSS 0.26168f
C1850 vbn.t768 VSS 0.26168f
C1851 vbn.t775 VSS 0.26168f
C1852 vbn.t782 VSS 0.26168f
C1853 vbn.t789 VSS 0.26168f
C1854 vbn.t796 VSS 0.26168f
C1855 vbn.t803 VSS 0.26168f
C1856 vbn.t8 VSS 0.22378f
C1857 vbn.n69 VSS 0.10385f
C1858 vbn.t720 VSS 0.20032f
C1859 vbn.t727 VSS 0.26168f
C1860 vbn.t734 VSS 0.26168f
C1861 vbn.t741 VSS 0.26168f
C1862 vbn.t748 VSS 0.26168f
C1863 vbn.t755 VSS 0.26168f
C1864 vbn.t762 VSS 0.26168f
C1865 vbn.t769 VSS 0.26168f
C1866 vbn.t776 VSS 0.26168f
C1867 vbn.t783 VSS 0.26168f
C1868 vbn.t790 VSS 0.26168f
C1869 vbn.t797 VSS 0.26168f
C1870 vbn.t804 VSS 0.26168f
C1871 vbn.t6 VSS 0.22378f
C1872 vbn.t7 VSS 0.06973f
C1873 vbn.n70 VSS 0.17558f
C1874 vbn.n71 VSS 0.06501f
C1875 vbn.t805 VSS 0.20032f
C1876 vbn.t819 VSS 0.26168f
C1877 vbn.t833 VSS 0.26168f
C1878 vbn.t847 VSS 0.26168f
C1879 vbn.t861 VSS 0.26168f
C1880 vbn.t875 VSS 0.26168f
C1881 vbn.t889 VSS 0.26168f
C1882 vbn.t903 VSS 0.26168f
C1883 vbn.t917 VSS 0.26168f
C1884 vbn.t931 VSS 0.26168f
C1885 vbn.t945 VSS 0.26168f
C1886 vbn.t959 VSS 0.26168f
C1887 vbn.t973 VSS 0.26168f
C1888 vbn.t987 VSS 0.22378f
C1889 vbn.n72 VSS 0.05349f
C1890 vbn.t806 VSS 0.20032f
C1891 vbn.t820 VSS 0.26168f
C1892 vbn.t834 VSS 0.26168f
C1893 vbn.t848 VSS 0.26168f
C1894 vbn.t862 VSS 0.26168f
C1895 vbn.t876 VSS 0.26168f
C1896 vbn.t890 VSS 0.26168f
C1897 vbn.t904 VSS 0.26168f
C1898 vbn.t918 VSS 0.26168f
C1899 vbn.t932 VSS 0.26168f
C1900 vbn.t946 VSS 0.26168f
C1901 vbn.t960 VSS 0.26168f
C1902 vbn.t974 VSS 0.26168f
C1903 vbn.t988 VSS 0.22378f
C1904 vbn.n73 VSS 0.05349f
C1905 vbn.t807 VSS 0.20032f
C1906 vbn.t821 VSS 0.26168f
C1907 vbn.t835 VSS 0.26168f
C1908 vbn.t849 VSS 0.26168f
C1909 vbn.t863 VSS 0.26168f
C1910 vbn.t877 VSS 0.26168f
C1911 vbn.t891 VSS 0.26168f
C1912 vbn.t905 VSS 0.26168f
C1913 vbn.t919 VSS 0.26168f
C1914 vbn.t933 VSS 0.26168f
C1915 vbn.t947 VSS 0.26168f
C1916 vbn.t961 VSS 0.26168f
C1917 vbn.t975 VSS 0.26168f
C1918 vbn.t989 VSS 0.22378f
C1919 vbn.n74 VSS 0.05349f
C1920 vbn.t808 VSS 0.20032f
C1921 vbn.t822 VSS 0.26168f
C1922 vbn.t836 VSS 0.26168f
C1923 vbn.t850 VSS 0.26168f
C1924 vbn.t864 VSS 0.26168f
C1925 vbn.t878 VSS 0.26168f
C1926 vbn.t892 VSS 0.26168f
C1927 vbn.t906 VSS 0.26168f
C1928 vbn.t920 VSS 0.26168f
C1929 vbn.t934 VSS 0.26168f
C1930 vbn.t948 VSS 0.26168f
C1931 vbn.t962 VSS 0.26168f
C1932 vbn.t976 VSS 0.26168f
C1933 vbn.t990 VSS 0.22378f
C1934 vbn.n75 VSS 0.0408f
C1935 vbn.t809 VSS 0.20032f
C1936 vbn.t823 VSS 0.26168f
C1937 vbn.t837 VSS 0.26168f
C1938 vbn.t851 VSS 0.26168f
C1939 vbn.t865 VSS 0.26168f
C1940 vbn.t879 VSS 0.26168f
C1941 vbn.t893 VSS 0.26168f
C1942 vbn.t907 VSS 0.26168f
C1943 vbn.t921 VSS 0.26168f
C1944 vbn.t935 VSS 0.26168f
C1945 vbn.t949 VSS 0.26168f
C1946 vbn.t963 VSS 0.26168f
C1947 vbn.t977 VSS 0.26168f
C1948 vbn.t991 VSS 0.22378f
C1949 vbn.t5 VSS 0.17686f
C1950 vbn.t3 VSS 0.17686f
C1951 vbn.n76 VSS 0.84332f
C1952 vbn.n77 VSS 0.09861f
C1953 vbn.n78 VSS 0.03943f
C1954 vbn.t810 VSS 0.20032f
C1955 vbn.t824 VSS 0.26168f
C1956 vbn.t838 VSS 0.26168f
C1957 vbn.t852 VSS 0.26168f
C1958 vbn.t866 VSS 0.26168f
C1959 vbn.t880 VSS 0.26168f
C1960 vbn.t894 VSS 0.26168f
C1961 vbn.t908 VSS 0.26168f
C1962 vbn.t922 VSS 0.26168f
C1963 vbn.t936 VSS 0.26168f
C1964 vbn.t950 VSS 0.26168f
C1965 vbn.t964 VSS 0.26168f
C1966 vbn.t978 VSS 0.26168f
C1967 vbn.t992 VSS 0.22378f
C1968 vbn.n79 VSS 0.05349f
C1969 vbn.t811 VSS 0.20032f
C1970 vbn.t825 VSS 0.26168f
C1971 vbn.t839 VSS 0.26168f
C1972 vbn.t853 VSS 0.26168f
C1973 vbn.t867 VSS 0.26168f
C1974 vbn.t881 VSS 0.26168f
C1975 vbn.t895 VSS 0.26168f
C1976 vbn.t909 VSS 0.26168f
C1977 vbn.t923 VSS 0.26168f
C1978 vbn.t937 VSS 0.26168f
C1979 vbn.t951 VSS 0.26168f
C1980 vbn.t965 VSS 0.26168f
C1981 vbn.t979 VSS 0.26168f
C1982 vbn.t993 VSS 0.22378f
C1983 vbn.n80 VSS 0.05349f
C1984 vbn.t812 VSS 0.20032f
C1985 vbn.t826 VSS 0.26168f
C1986 vbn.t840 VSS 0.26168f
C1987 vbn.t854 VSS 0.26168f
C1988 vbn.t868 VSS 0.26168f
C1989 vbn.t882 VSS 0.26168f
C1990 vbn.t896 VSS 0.26168f
C1991 vbn.t910 VSS 0.26168f
C1992 vbn.t924 VSS 0.26168f
C1993 vbn.t938 VSS 0.26168f
C1994 vbn.t952 VSS 0.26168f
C1995 vbn.t966 VSS 0.26168f
C1996 vbn.t980 VSS 0.26168f
C1997 vbn.t994 VSS 0.22378f
C1998 vbn.n81 VSS 0.05349f
C1999 vbn.t813 VSS 0.20032f
C2000 vbn.t827 VSS 0.26168f
C2001 vbn.t841 VSS 0.26168f
C2002 vbn.t855 VSS 0.26168f
C2003 vbn.t869 VSS 0.26168f
C2004 vbn.t883 VSS 0.26168f
C2005 vbn.t897 VSS 0.26168f
C2006 vbn.t911 VSS 0.26168f
C2007 vbn.t925 VSS 0.26168f
C2008 vbn.t939 VSS 0.26168f
C2009 vbn.t953 VSS 0.26168f
C2010 vbn.t967 VSS 0.26168f
C2011 vbn.t981 VSS 0.26168f
C2012 vbn.t995 VSS 0.22378f
C2013 vbn.n82 VSS 0.05349f
C2014 vbn.t814 VSS 0.20032f
C2015 vbn.t828 VSS 0.26168f
C2016 vbn.t842 VSS 0.26168f
C2017 vbn.t856 VSS 0.26168f
C2018 vbn.t870 VSS 0.26168f
C2019 vbn.t884 VSS 0.26168f
C2020 vbn.t898 VSS 0.26168f
C2021 vbn.t912 VSS 0.26168f
C2022 vbn.t926 VSS 0.26168f
C2023 vbn.t940 VSS 0.26168f
C2024 vbn.t954 VSS 0.26168f
C2025 vbn.t968 VSS 0.26168f
C2026 vbn.t982 VSS 0.26168f
C2027 vbn.t996 VSS 0.22378f
C2028 vbn.n83 VSS 0.05349f
C2029 vbn.t815 VSS 0.20032f
C2030 vbn.t829 VSS 0.26168f
C2031 vbn.t843 VSS 0.26168f
C2032 vbn.t857 VSS 0.26168f
C2033 vbn.t871 VSS 0.26168f
C2034 vbn.t885 VSS 0.26168f
C2035 vbn.t899 VSS 0.26168f
C2036 vbn.t913 VSS 0.26168f
C2037 vbn.t927 VSS 0.26168f
C2038 vbn.t941 VSS 0.26168f
C2039 vbn.t955 VSS 0.26168f
C2040 vbn.t969 VSS 0.26168f
C2041 vbn.t983 VSS 0.26168f
C2042 vbn.t997 VSS 0.22378f
C2043 vbn.n84 VSS 0.05349f
C2044 vbn.t816 VSS 0.20032f
C2045 vbn.t830 VSS 0.26168f
C2046 vbn.t844 VSS 0.26168f
C2047 vbn.t858 VSS 0.26168f
C2048 vbn.t872 VSS 0.26168f
C2049 vbn.t886 VSS 0.26168f
C2050 vbn.t900 VSS 0.26168f
C2051 vbn.t914 VSS 0.26168f
C2052 vbn.t928 VSS 0.26168f
C2053 vbn.t942 VSS 0.26168f
C2054 vbn.t956 VSS 0.26168f
C2055 vbn.t970 VSS 0.26168f
C2056 vbn.t984 VSS 0.26168f
C2057 vbn.t998 VSS 0.22378f
C2058 vbn.n85 VSS 0.06559f
C2059 vbn.t817 VSS 0.20032f
C2060 vbn.t831 VSS 0.26168f
C2061 vbn.t845 VSS 0.26168f
C2062 vbn.t859 VSS 0.26168f
C2063 vbn.t873 VSS 0.26168f
C2064 vbn.t887 VSS 0.26168f
C2065 vbn.t901 VSS 0.26168f
C2066 vbn.t915 VSS 0.26168f
C2067 vbn.t929 VSS 0.26168f
C2068 vbn.t943 VSS 0.26168f
C2069 vbn.t957 VSS 0.26168f
C2070 vbn.t971 VSS 0.26168f
C2071 vbn.t985 VSS 0.26168f
C2072 vbn.t999 VSS 0.22378f
C2073 vbn.t1 VSS 0.31402f
C2074 vbn.n86 VSS 2.75195f
C2075 vbn.t818 VSS 0.20032f
C2076 vbn.t832 VSS 0.26168f
C2077 vbn.t846 VSS 0.26168f
C2078 vbn.t860 VSS 0.26168f
C2079 vbn.t874 VSS 0.26168f
C2080 vbn.t888 VSS 0.26168f
C2081 vbn.t902 VSS 0.26168f
C2082 vbn.t916 VSS 0.26168f
C2083 vbn.t930 VSS 0.26168f
C2084 vbn.t944 VSS 0.26168f
C2085 vbn.t958 VSS 0.26168f
C2086 vbn.t972 VSS 0.26168f
C2087 vbn.t986 VSS 0.26168f
C2088 vbn.t1000 VSS 0.22378f
C2089 vbn.n87 VSS 1.68972f
C2090 vbn.n88 VSS 0.12833f
C2091 vbn.n89 VSS 0.12833f
C2092 vbn.n90 VSS 0.12833f
C2093 vbn.n91 VSS 0.12833f
C2094 vbn.n92 VSS 0.12833f
C2095 vbn.n93 VSS 0.12833f
C2096 vbn.n94 VSS 0.12833f
C2097 vbn.n95 VSS 0.12833f
C2098 vbn.n96 VSS 0.12833f
C2099 vbn.n97 VSS 0.12833f
C2100 vbn.n98 VSS 0.12833f
C2101 vbn.n99 VSS 0.12833f
C2102 vbn.n100 VSS 0.15404f
C2103 vbn.n101 VSS 0.15404f
C2104 vbn.n102 VSS 0.12833f
C2105 vbn.n103 VSS 0.12833f
C2106 vbn.n104 VSS 0.12833f
C2107 vbn.n105 VSS 0.12833f
C2108 vbn.n106 VSS 0.12833f
C2109 vbn.n107 VSS 0.15404f
C2110 vbn.n108 VSS 0.15404f
C2111 vbn.n109 VSS 0.12833f
C2112 vbn.n110 VSS 0.12833f
C2113 vbn.n111 VSS 0.12833f
C2114 vbn.n112 VSS 0.12833f
C2115 vbn.n113 VSS 0.12833f
C2116 vbn.n114 VSS 0.12833f
C2117 vbn.n115 VSS 0.12833f
C2118 vbn.n116 VSS 0.12833f
C2119 vbn.n117 VSS 0.12833f
C2120 vbn.n118 VSS 0.12833f
C2121 vbn.n119 VSS 0.12833f
C2122 vbn.n120 VSS 0.12833f
C2123 vbn.n121 VSS 0.12833f
C2124 vbn.n122 VSS 0.12833f
C2125 vbn.n123 VSS 0.12833f
C2126 vbn.n124 VSS 0.12833f
C2127 vbn.n125 VSS 0.12833f
C2128 vbn.n126 VSS 0.12833f
C2129 vbn.n127 VSS 0.12833f
C2130 vbn.n128 VSS 0.12833f
C2131 vbn.n129 VSS 0.12833f
C2132 vbn.n130 VSS 0.12833f
C2133 vbn.n131 VSS 0.12833f
C2134 vbn.n132 VSS 0.12833f
C2135 vbn.n133 VSS 0.12833f
C2136 vbn.n134 VSS 0.12833f
C2137 vbn.n135 VSS 0.15404f
C2138 vbn.n136 VSS 0.15404f
C2139 vbn.n137 VSS 0.12833f
C2140 vbn.n138 VSS 0.12833f
C2141 vbn.n139 VSS 0.12833f
C2142 vbn.n140 VSS 0.12833f
C2143 vbn.n141 VSS 0.12833f
C2144 vbn.n142 VSS 0.15404f
C2145 vbn.n143 VSS 0.15404f
C2146 vbn.n144 VSS 0.12833f
C2147 vbn.n145 VSS 0.12833f
C2148 vbn.n146 VSS 0.12833f
C2149 vbn.n147 VSS 0.12833f
C2150 vbn.n148 VSS 0.12833f
C2151 vbn.n149 VSS 0.12833f
C2152 vbn.n150 VSS 0.12833f
C2153 vbn.n151 VSS 0.12833f
C2154 vbn.n152 VSS 0.12833f
C2155 vbn.n153 VSS 0.12833f
C2156 vbn.n154 VSS 0.12833f
C2157 vbn.n155 VSS 0.12833f
C2158 vbn.n156 VSS 1.68972f
C2159 vbn.n157 VSS 1.68575f
C2160 vbn.n158 VSS 0.74122f
C2161 vbn.t34 VSS 0.04571f
C2162 vbn.n159 VSS 0.17107f
C2163 ls.t2 VSS 0.5544f
C2164 ls.t1 VSS 0.19416f
C2165 ls.n0 VSS 0.90454f
C2166 ls.t6 VSS 0.10317f
C2167 ls.t4 VSS 0.05782f
C2168 ls.n1 VSS 0.41541f
C2169 ls.t5 VSS 0.12613f
C2170 ls.n2 VSS 0.4576f
C2171 ls.t0 VSS 0.1155f
C2172 ls.n3 VSS 1.5836f
C2173 ls.n4 VSS 0.24571f
C2174 ls.t3 VSS 0.05787f
C2175 ls.n5 VSS 0.18037f
C2176 ls.n6 VSS 0.01202f
C2177 vbnf.t11 VSS 3.60435f
C2178 vbnf.t12 VSS 3.55209f
C2179 vbnf.n0 VSS 2.01227f
C2180 vbnf.t13 VSS 3.55209f
C2181 vbnf.n1 VSS 1.03166f
C2182 vbnf.t14 VSS 3.55209f
C2183 vbnf.n2 VSS 1.03166f
C2184 vbnf.t15 VSS 3.55209f
C2185 vbnf.n3 VSS 1.03166f
C2186 vbnf.t16 VSS 3.55209f
C2187 vbnf.n4 VSS 1.03166f
C2188 vbnf.t17 VSS 3.55209f
C2189 vbnf.n5 VSS 1.03166f
C2190 vbnf.t18 VSS 3.55209f
C2191 vbnf.n6 VSS 1.03166f
C2192 vbnf.t19 VSS 3.55209f
C2193 vbnf.n7 VSS 1.03166f
C2194 vbnf.t20 VSS 3.55209f
C2195 vbnf.n8 VSS 1.00013f
C2196 vbnf.t1 VSS 0.00432f
C2197 vbnf.n9 VSS 0.04835f
C2198 vbnf.t9 VSS 0.01146f
C2199 vbnf.t4 VSS 0.01446f
C2200 vbnf.n10 VSS 0.0366f
C2201 vbnf.t8 VSS 0.01146f
C2202 vbnf.t3 VSS 0.01446f
C2203 vbnf.n11 VSS 0.03547f
C2204 vbnf.n12 VSS 0.0203f
C2205 vbnf.t7 VSS 0.01146f
C2206 vbnf.t6 VSS 0.01446f
C2207 vbnf.n13 VSS 0.03547f
C2208 vbnf.n14 VSS 0.01358f
C2209 vbnf.t0 VSS 0.01146f
C2210 vbnf.t5 VSS 0.01446f
C2211 vbnf.n15 VSS 0.03547f
C2212 vbnf.n16 VSS 0.01358f
C2213 vbnf.t10 VSS 0.01146f
C2214 vbnf.t2 VSS 0.01446f
C2215 vbnf.n17 VSS 0.03547f
C2216 vbnf.n18 VSS 0.00994f
C2217 vbnf.t22 VSS 0.07458f
C2218 vbnf.t21 VSS 0.07128f
C2219 vbnf.n19 VSS 0.1483f
C2220 vbnf.t23 VSS 0.09081f
C2221 vbnf.n20 VSS 0.15179f
C2222 vbnf.t24 VSS 0.07418f
C2223 vbnf.t25 VSS 0.07478f
C2224 vbnf.n21 VSS 0.14183f
C2225 vbnf.n22 VSS 0.02859f
C2226 vbnf.t26 VSS 0.09043f
C2227 vbnf.n23 VSS 0.17146f
C2228 vbnf.n24 VSS 0.02081f
C2229 vbnf.n25 VSS 0.05507f
C2230 ck.t0 VSS 0.2156f
C2231 ck.t1 VSS 0.068f
C2232 ck.n0 VSS 0.75642f
C2233 a0.t0 VSS 0.94203f
C2234 a0.t1 VSS 0.29501f
C2235 a0.n0 VSS 1.1122f
C2236 a0.t3 VSS 0.43176f
C2237 a0.t2 VSS 0.22188f
C2238 a0.n1 VSS 0.60841f
C2239 a0.n2 VSS 0.66761f
C2240 bitb0.t1 VSS 0.28144f
C2241 bitb0.t0 VSS 0.08575f
C2242 bitb0.n0 VSS 0.93404f
C2243 bitb1.t1 VSS 0.32651f
C2244 bitb1.t0 VSS 0.09948f
C2245 bitb1.n0 VSS 1.08359f
C2246 bitb2.t1 VSS 0.32639f
C2247 bitb2.t0 VSS 0.09945f
C2248 bitb2.n0 VSS 1.08319f
C2249 bitb3.t1 VSS 0.32644f
C2250 bitb3.t0 VSS 0.09946f
C2251 bitb3.n0 VSS 1.08337f
C2252 bitb4.t1 VSS 0.3254f
C2253 bitb4.t0 VSS 0.09914f
C2254 bitb4.n0 VSS 1.07991f
C2255 bit0.t0 VSS 0.33686f
C2256 bit1.t0 VSS 0.33779f
C2257 bit2.t0 VSS 0.33772f
C2258 bit3.t0 VSS 0.33786f
C2259 bit4.t0 VSS 0.24777f
C2260 vg.t34 VSS 0.00408f
C2261 vg.t18 VSS 0.00408f
C2262 vg.n0 VSS 0.03099f
C2263 vg.t15 VSS 0.00408f
C2264 vg.t20 VSS 0.00408f
C2265 vg.n1 VSS 0.01473f
C2266 vg.n2 VSS 0.15797f
C2267 vg.t5 VSS 0.00408f
C2268 vg.t19 VSS 0.00408f
C2269 vg.n3 VSS 0.01473f
C2270 vg.n4 VSS 0.11237f
C2271 vg.n5 VSS 0.05144f
C2272 vg.t22 VSS 0.00408f
C2273 vg.t41 VSS 0.00408f
C2274 vg.n6 VSS 0.03099f
C2275 vg.t21 VSS 0.00408f
C2276 vg.t0 VSS 0.00408f
C2277 vg.n7 VSS 0.01473f
C2278 vg.n8 VSS 0.15797f
C2279 vg.t24 VSS 0.00408f
C2280 vg.t8 VSS 0.00408f
C2281 vg.n9 VSS 0.01473f
C2282 vg.n10 VSS 0.11237f
C2283 vg.n11 VSS 0.04304f
C2284 vg.t11 VSS 0.00408f
C2285 vg.t23 VSS 0.00408f
C2286 vg.n12 VSS 0.03099f
C2287 vg.t9 VSS 0.00408f
C2288 vg.t36 VSS 0.00408f
C2289 vg.n13 VSS 0.01473f
C2290 vg.n14 VSS 0.15797f
C2291 vg.t16 VSS 0.00408f
C2292 vg.t26 VSS 0.00408f
C2293 vg.n15 VSS 0.01473f
C2294 vg.n16 VSS 0.11237f
C2295 vg.n17 VSS 0.04618f
C2296 vg.t12 VSS 0.00408f
C2297 vg.t40 VSS 0.00408f
C2298 vg.n18 VSS 0.05537f
C2299 vg.n19 VSS 0.10023f
C2300 vg.t25 VSS 0.00408f
C2301 vg.t42 VSS 0.00408f
C2302 vg.n20 VSS 0.03099f
C2303 vg.t35 VSS 0.00408f
C2304 vg.t4 VSS 0.00408f
C2305 vg.n21 VSS 0.01473f
C2306 vg.n22 VSS 0.15797f
C2307 vg.t28 VSS 0.00408f
C2308 vg.t10 VSS 0.00408f
C2309 vg.n23 VSS 0.01473f
C2310 vg.n24 VSS 0.11237f
C2311 vg.n25 VSS 0.04304f
C2312 vg.t6 VSS 0.00408f
C2313 vg.t27 VSS 0.00408f
C2314 vg.n26 VSS 0.03099f
C2315 vg.t1 VSS 0.00408f
C2316 vg.t30 VSS 0.00408f
C2317 vg.n27 VSS 0.01473f
C2318 vg.n28 VSS 0.15797f
C2319 vg.t17 VSS 0.00408f
C2320 vg.t29 VSS 0.00408f
C2321 vg.n29 VSS 0.01473f
C2322 vg.n30 VSS 0.11237f
C2323 vg.n31 VSS 0.04304f
C2324 vg.t32 VSS 0.00408f
C2325 vg.t7 VSS 0.00408f
C2326 vg.n32 VSS 0.03099f
C2327 vg.t31 VSS 0.00408f
C2328 vg.t39 VSS 0.00408f
C2329 vg.n33 VSS 0.01473f
C2330 vg.n34 VSS 0.15797f
C2331 vg.t33 VSS 0.00408f
C2332 vg.t37 VSS 0.00408f
C2333 vg.n35 VSS 0.01473f
C2334 vg.n36 VSS 0.11237f
C2335 vg.n37 VSS 0.05668f
C2336 vg.n38 VSS 0.07289f
C2337 vg.n39 VSS 0.03172f
C2338 vg.t43 VSS 2.21595f
C2339 vg.n40 VSS 0.02909f
C2340 vg.n41 VSS 0.07289f
C2341 vg.n42 VSS 0.03657f
C2342 vg.t45 VSS 2.21595f
C2343 vg.t13 VSS 0.01886f
C2344 vg.n43 VSS 0.05399f
C2345 vg.n44 VSS 0.07289f
C2346 vg.n45 VSS 0.07289f
C2347 vg.n46 VSS 0.02116f
C2348 vg.n47 VSS 0.02187f
C2349 vg.t46 VSS 2.21595f
C2350 vg.t3 VSS 0.01886f
C2351 vg.n48 VSS 0.02791f
C2352 vg.n49 VSS 0.07289f
C2353 vg.t14 VSS 0.01886f
C2354 vg.n50 VSS 0.04615f
C2355 vg.n51 VSS 0.02214f
C2356 vg.t2 VSS 0.01886f
C2357 vg.n52 VSS 0.03316f
C2358 vg.t48 VSS 2.21595f
C2359 vg.t38 VSS 0.01886f
C2360 vg.n53 VSS 0.04524f
C2361 vg.n54 VSS 0.12201f
C2362 vg.n55 VSS 0.06952f
C2363 vg.n56 VSS 0.78012f
C2364 vg.n57 VSS 0.02554f
C2365 vg.n58 VSS 0.06076f
C2366 vg.n59 VSS 0.04998f
C2367 vg.t47 VSS 2.21595f
C2368 vg.n60 VSS 0.78012f
C2369 vg.n61 VSS 0.02955f
C2370 vg.n62 VSS 0.02187f
C2371 vg.n63 VSS 0.07289f
C2372 vg.n64 VSS 0.07289f
C2373 vg.n65 VSS 0.03653f
C2374 vg.n66 VSS 0.06018f
C2375 vg.n67 VSS 0.01697f
C2376 vg.n68 VSS 0.78012f
C2377 vg.n69 VSS 0.03644f
C2378 vg.n70 VSS 0.02187f
C2379 vg.n71 VSS 0.07289f
C2380 vg.n72 VSS 0.07289f
C2381 vg.n73 VSS 0.06676f
C2382 vg.n74 VSS 0.02898f
C2383 vg.n75 VSS 0.78012f
C2384 vg.n76 VSS 0.05004f
C2385 vg.n77 VSS 0.03936f
C2386 vg.t44 VSS 2.21595f
C2387 vg.n78 VSS 0.78012f
C2388 vg.n79 VSS 0.05004f
C2389 vg.n80 VSS 0.03629f
C2390 vg.n81 VSS 0.07289f
C2391 vg.n82 VSS 0.07289f
C2392 vg.n83 VSS 0.06776f
C2393 vg.n84 VSS 0.05004f
C2394 vg.n85 VSS 0.78013f
C2395 vg.n86 VSS 0.10669f
C2396 vg.n87 VSS 0.14478f
C2397 vg.n88 VSS 0.19708f
C2398 vctrl.t0 VSS 13.3195f
.ends
