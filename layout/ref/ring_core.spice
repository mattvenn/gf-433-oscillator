* ring core exported from sim/vco/vco_bias.py netlist() by layout/gen/export_core.py
* dropped (reference/filter/wiring C): XMN1 XMN2 XRBW XRBN XMP1 XMP2 XMS1 XMS2 XMS3 Rvbn Cw0 Cw1 Cw2 Cw3 Cw4
.subckt ring_core VDD VSS vbn vctrl bit0 bit1 bit2 bit3 bit4 bitb0 bitb1 bitb2 bitb3 bitb4 a0 a1 a2 a3 a4
XTN0 g0 bit0 vbn VSS nfet_03v3 w=2u l=0.28u ad=1.0p as=1.0p pd=5.0u ps=5.0u m=1
XTP0 g0 bitb0 vbn VDD pfet_03v3 w=5u l=0.28u ad=2.5p as=2.5p pd=11.0u ps=11.0u m=1
XTD0 g0 bitb0 VSS VSS nfet_03v3 w=1u l=0.28u ad=0.5p as=0.5p pd=3.0u ps=3.0u m=1
XTN1 g1 bit1 vbn VSS nfet_03v3 w=2u l=0.28u ad=1.0p as=1.0p pd=5.0u ps=5.0u m=1
XTP1 g1 bitb1 vbn VDD pfet_03v3 w=5u l=0.28u ad=2.5p as=2.5p pd=11.0u ps=11.0u m=1
XTD1 g1 bitb1 VSS VSS nfet_03v3 w=1u l=0.28u ad=0.5p as=0.5p pd=3.0u ps=3.0u m=1
XTN2 g2 bit2 vbn VSS nfet_03v3 w=2u l=0.28u ad=1.0p as=1.0p pd=5.0u ps=5.0u m=1
XTP2 g2 bitb2 vbn VDD pfet_03v3 w=5u l=0.28u ad=2.5p as=2.5p pd=11.0u ps=11.0u m=1
XTD2 g2 bitb2 VSS VSS nfet_03v3 w=1u l=0.28u ad=0.5p as=0.5p pd=3.0u ps=3.0u m=1
XTN3 g3 bit3 vbn VSS nfet_03v3 w=2u l=0.28u ad=1.0p as=1.0p pd=5.0u ps=5.0u m=1
XTP3 g3 bitb3 vbn VDD pfet_03v3 w=5u l=0.28u ad=2.5p as=2.5p pd=11.0u ps=11.0u m=1
XTD3 g3 bitb3 VSS VSS nfet_03v3 w=1u l=0.28u ad=0.5p as=0.5p pd=3.0u ps=3.0u m=1
XTN4 g4 bit4 vbn VSS nfet_03v3 w=2u l=0.28u ad=1.0p as=1.0p pd=5.0u ps=5.0u m=1
XTP4 g4 bitb4 vbn VDD pfet_03v3 w=5u l=0.28u ad=2.5p as=2.5p pd=11.0u ps=11.0u m=1
XTD4 g4 bitb4 VSS VSS nfet_03v3 w=1u l=0.28u ad=0.5p as=0.5p pd=3.0u ps=3.0u m=1
XMPB vbp vbp VDD VDD pfet_03v3 w=1.0u l=1.0u ad=0.5p as=0.5p pd=3.0u ps=3.0u m=12
XFM vbp vbn VSS VSS nfet_03v3 w=0.25u l=1.0u ad=0.125p as=0.125p pd=1.5u ps=1.5u m=16
XFM_0 vbp g0 VSS VSS nfet_03v3 w=0.25u l=1.0u ad=0.125p as=0.125p pd=1.5u ps=1.5u m=1
XFM_1 vbp g1 VSS VSS nfet_03v3 w=0.25u l=1.0u ad=0.125p as=0.125p pd=1.5u ps=1.5u m=2
XFM_2 vbp g2 VSS VSS nfet_03v3 w=0.25u l=1.0u ad=0.125p as=0.125p pd=1.5u ps=1.5u m=4
XFM_3 vbp g3 VSS VSS nfet_03v3 w=0.25u l=1.0u ad=0.125p as=0.125p pd=1.5u ps=1.5u m=8
XFM_4 vbp g4 VSS VSS nfet_03v3 w=0.25u l=1.0u ad=0.125p as=0.125p pd=1.5u ps=1.5u m=16
XFFM vbp vctrl VSS VSS nfet_03v3 w=0.25u l=4.0u ad=0.125p as=0.125p pd=1.5u ps=1.5u m=1
XH0 h0 vbp VDD VDD pfet_03v3 w=6.0u l=1.0u ad=3.0p as=3.0p pd=13.0u ps=13.0u m=1
XP0 a1 a0 h0 VDD pfet_03v3 w=5.0u l=0.28u ad=2.5p as=2.5p pd=11.0u ps=11.0u m=1
XN0 a1 a0 f0 VSS nfet_03v3 w=2.0u l=0.28u ad=1.0p as=1.0p pd=5.0u ps=5.0u m=1
XFs0 f0 vbn VSS VSS nfet_03v3 w=0.25u l=1.0u ad=0.125p as=0.125p pd=1.5u ps=1.5u m=16
XFs0_0 f0 g0 VSS VSS nfet_03v3 w=0.25u l=1.0u ad=0.125p as=0.125p pd=1.5u ps=1.5u m=1
XFs0_1 f0 g1 VSS VSS nfet_03v3 w=0.25u l=1.0u ad=0.125p as=0.125p pd=1.5u ps=1.5u m=2
XFs0_2 f0 g2 VSS VSS nfet_03v3 w=0.25u l=1.0u ad=0.125p as=0.125p pd=1.5u ps=1.5u m=4
XFs0_3 f0 g3 VSS VSS nfet_03v3 w=0.25u l=1.0u ad=0.125p as=0.125p pd=1.5u ps=1.5u m=8
XFs0_4 f0 g4 VSS VSS nfet_03v3 w=0.25u l=1.0u ad=0.125p as=0.125p pd=1.5u ps=1.5u m=16
XFFs0 f0 vctrl VSS VSS nfet_03v3 w=0.25u l=4.0u ad=0.125p as=0.125p pd=1.5u ps=1.5u m=1
XH1 h1 vbp VDD VDD pfet_03v3 w=6.0u l=1.0u ad=3.0p as=3.0p pd=13.0u ps=13.0u m=1
XP1 a2 a1 h1 VDD pfet_03v3 w=5.0u l=0.28u ad=2.5p as=2.5p pd=11.0u ps=11.0u m=1
XN1 a2 a1 f1 VSS nfet_03v3 w=2.0u l=0.28u ad=1.0p as=1.0p pd=5.0u ps=5.0u m=1
XFs1 f1 vbn VSS VSS nfet_03v3 w=0.25u l=1.0u ad=0.125p as=0.125p pd=1.5u ps=1.5u m=16
XFs1_0 f1 g0 VSS VSS nfet_03v3 w=0.25u l=1.0u ad=0.125p as=0.125p pd=1.5u ps=1.5u m=1
XFs1_1 f1 g1 VSS VSS nfet_03v3 w=0.25u l=1.0u ad=0.125p as=0.125p pd=1.5u ps=1.5u m=2
XFs1_2 f1 g2 VSS VSS nfet_03v3 w=0.25u l=1.0u ad=0.125p as=0.125p pd=1.5u ps=1.5u m=4
XFs1_3 f1 g3 VSS VSS nfet_03v3 w=0.25u l=1.0u ad=0.125p as=0.125p pd=1.5u ps=1.5u m=8
XFs1_4 f1 g4 VSS VSS nfet_03v3 w=0.25u l=1.0u ad=0.125p as=0.125p pd=1.5u ps=1.5u m=16
XFFs1 f1 vctrl VSS VSS nfet_03v3 w=0.25u l=4.0u ad=0.125p as=0.125p pd=1.5u ps=1.5u m=1
XH2 h2 vbp VDD VDD pfet_03v3 w=6.0u l=1.0u ad=3.0p as=3.0p pd=13.0u ps=13.0u m=1
XP2 a3 a2 h2 VDD pfet_03v3 w=5.0u l=0.28u ad=2.5p as=2.5p pd=11.0u ps=11.0u m=1
XN2 a3 a2 f2 VSS nfet_03v3 w=2.0u l=0.28u ad=1.0p as=1.0p pd=5.0u ps=5.0u m=1
XFs2 f2 vbn VSS VSS nfet_03v3 w=0.25u l=1.0u ad=0.125p as=0.125p pd=1.5u ps=1.5u m=16
XFs2_0 f2 g0 VSS VSS nfet_03v3 w=0.25u l=1.0u ad=0.125p as=0.125p pd=1.5u ps=1.5u m=1
XFs2_1 f2 g1 VSS VSS nfet_03v3 w=0.25u l=1.0u ad=0.125p as=0.125p pd=1.5u ps=1.5u m=2
XFs2_2 f2 g2 VSS VSS nfet_03v3 w=0.25u l=1.0u ad=0.125p as=0.125p pd=1.5u ps=1.5u m=4
XFs2_3 f2 g3 VSS VSS nfet_03v3 w=0.25u l=1.0u ad=0.125p as=0.125p pd=1.5u ps=1.5u m=8
XFs2_4 f2 g4 VSS VSS nfet_03v3 w=0.25u l=1.0u ad=0.125p as=0.125p pd=1.5u ps=1.5u m=16
XFFs2 f2 vctrl VSS VSS nfet_03v3 w=0.25u l=4.0u ad=0.125p as=0.125p pd=1.5u ps=1.5u m=1
XH3 h3 vbp VDD VDD pfet_03v3 w=6.0u l=1.0u ad=3.0p as=3.0p pd=13.0u ps=13.0u m=1
XP3 a4 a3 h3 VDD pfet_03v3 w=5.0u l=0.28u ad=2.5p as=2.5p pd=11.0u ps=11.0u m=1
XN3 a4 a3 f3 VSS nfet_03v3 w=2.0u l=0.28u ad=1.0p as=1.0p pd=5.0u ps=5.0u m=1
XFs3 f3 vbn VSS VSS nfet_03v3 w=0.25u l=1.0u ad=0.125p as=0.125p pd=1.5u ps=1.5u m=16
XFs3_0 f3 g0 VSS VSS nfet_03v3 w=0.25u l=1.0u ad=0.125p as=0.125p pd=1.5u ps=1.5u m=1
XFs3_1 f3 g1 VSS VSS nfet_03v3 w=0.25u l=1.0u ad=0.125p as=0.125p pd=1.5u ps=1.5u m=2
XFs3_2 f3 g2 VSS VSS nfet_03v3 w=0.25u l=1.0u ad=0.125p as=0.125p pd=1.5u ps=1.5u m=4
XFs3_3 f3 g3 VSS VSS nfet_03v3 w=0.25u l=1.0u ad=0.125p as=0.125p pd=1.5u ps=1.5u m=8
XFs3_4 f3 g4 VSS VSS nfet_03v3 w=0.25u l=1.0u ad=0.125p as=0.125p pd=1.5u ps=1.5u m=16
XFFs3 f3 vctrl VSS VSS nfet_03v3 w=0.25u l=4.0u ad=0.125p as=0.125p pd=1.5u ps=1.5u m=1
XH4 h4 vbp VDD VDD pfet_03v3 w=6.0u l=1.0u ad=3.0p as=3.0p pd=13.0u ps=13.0u m=1
XP4 a0 a4 h4 VDD pfet_03v3 w=5.0u l=0.28u ad=2.5p as=2.5p pd=11.0u ps=11.0u m=1
XN4 a0 a4 f4 VSS nfet_03v3 w=2.0u l=0.28u ad=1.0p as=1.0p pd=5.0u ps=5.0u m=1
XFs4 f4 vbn VSS VSS nfet_03v3 w=0.25u l=1.0u ad=0.125p as=0.125p pd=1.5u ps=1.5u m=16
XFs4_0 f4 g0 VSS VSS nfet_03v3 w=0.25u l=1.0u ad=0.125p as=0.125p pd=1.5u ps=1.5u m=1
XFs4_1 f4 g1 VSS VSS nfet_03v3 w=0.25u l=1.0u ad=0.125p as=0.125p pd=1.5u ps=1.5u m=2
XFs4_2 f4 g2 VSS VSS nfet_03v3 w=0.25u l=1.0u ad=0.125p as=0.125p pd=1.5u ps=1.5u m=4
XFs4_3 f4 g3 VSS VSS nfet_03v3 w=0.25u l=1.0u ad=0.125p as=0.125p pd=1.5u ps=1.5u m=8
XFs4_4 f4 g4 VSS VSS nfet_03v3 w=0.25u l=1.0u ad=0.125p as=0.125p pd=1.5u ps=1.5u m=16
XFFs4 f4 vctrl VSS VSS nfet_03v3 w=0.25u l=4.0u ad=0.125p as=0.125p pd=1.5u ps=1.5u m=1
.ends
