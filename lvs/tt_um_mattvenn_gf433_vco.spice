* LVS source for tt_um_mattvenn_gf433_vco (Tiny Tapeout gf180mcuD analog 2x2), generated by lvs/make_source.py
* from xschem/vco_top.sch (edits: lsdiv Cc removed, XRBW L snapped 5.023 -> 5.025 um), xschem/tx_drv.sch
* and the PDK's
* gf180mcu_fd_sc_mcu7t5v0 spice (inv_1, tiel, antenna). Do not edit by hand.

.subckt tt_um_mattvenn_gf433_vco VGND VDPWR ui_in[0] ui_in[1] ui_in[2] ui_in[3] ui_in[4] ui_in[5] ui_in[6] ui_in[7] uo_out[0] uo_out[1] uo_out[2] uo_out[3] uo_out[4] uo_out[5] uo_out[6] uo_out[7] uio_in[0] uio_in[1] uio_in[2] uio_in[3] uio_in[4] uio_in[5] uio_in[6] uio_in[7] uio_out[0] uio_out[1] uio_out[2] uio_out[3] uio_out[4] uio_out[5] uio_out[6] uio_out[7] uio_oe[0] uio_oe[1] uio_oe[2] uio_oe[3] uio_oe[4] uio_oe[5] uio_oe[6] uio_oe[7] ua[0] ua[1] ua[2] ua[3] ua[4] ua[5] ua[6] ua[7] ena clk rst_n
xvco VDPWR VDPWR VGND ua[0] ui_in[0] ui_in[1] ui_in[2] ui_in[3] ui_in[4] bitb0 bitb1 bitb2 bitb3 bitb4 uo_out[0] a0 ua[1] vg ls vco_top
xinv0 ui_in[0] bitb0 VDPWR VDPWR VGND VGND gf180mcu_fd_sc_mcu7t5v0__inv_1
xinv1 ui_in[1] bitb1 VDPWR VDPWR VGND VGND gf180mcu_fd_sc_mcu7t5v0__inv_1
xinv2 ui_in[2] bitb2 VDPWR VDPWR VGND VGND gf180mcu_fd_sc_mcu7t5v0__inv_1
xinv3 ui_in[3] bitb3 VDPWR VDPWR VGND VGND gf180mcu_fd_sc_mcu7t5v0__inv_1
xinv4 ui_in[4] bitb4 VDPWR VDPWR VGND VGND gf180mcu_fd_sc_mcu7t5v0__inv_1
xant0 ui_in[0] VDPWR VDPWR VGND VGND gf180mcu_fd_sc_mcu7t5v0__antenna
xant1 ui_in[1] VDPWR VDPWR VGND VGND gf180mcu_fd_sc_mcu7t5v0__antenna
xant2 ui_in[2] VDPWR VDPWR VGND VGND gf180mcu_fd_sc_mcu7t5v0__antenna
xant3 ui_in[3] VDPWR VDPWR VGND VGND gf180mcu_fd_sc_mcu7t5v0__antenna
xant4 ui_in[4] VDPWR VDPWR VGND VGND gf180mcu_fd_sc_mcu7t5v0__antenna
xtx VDPWR VGND ls ui_in[5] ui_in[6] ua[3] ua[2] tx_drv
xant5 ui_in[5] VDPWR VDPWR VGND VGND gf180mcu_fd_sc_mcu7t5v0__antenna
xant6 ui_in[6] VDPWR VDPWR VGND VGND gf180mcu_fd_sc_mcu7t5v0__antenna
xtie_uo_out_1 uo_out[1] VDPWR VDPWR VGND VGND gf180mcu_fd_sc_mcu7t5v0__tiel
xtie_uo_out_2 uo_out[2] VDPWR VDPWR VGND VGND gf180mcu_fd_sc_mcu7t5v0__tiel
xtie_uo_out_3 uo_out[3] VDPWR VDPWR VGND VGND gf180mcu_fd_sc_mcu7t5v0__tiel
xtie_uo_out_4 uo_out[4] VDPWR VDPWR VGND VGND gf180mcu_fd_sc_mcu7t5v0__tiel
xtie_uo_out_5 uo_out[5] VDPWR VDPWR VGND VGND gf180mcu_fd_sc_mcu7t5v0__tiel
xtie_uo_out_6 uo_out[6] VDPWR VDPWR VGND VGND gf180mcu_fd_sc_mcu7t5v0__tiel
xtie_uo_out_7 uo_out[7] VDPWR VDPWR VGND VGND gf180mcu_fd_sc_mcu7t5v0__tiel
xtie_uio_out_0 uio_out[0] VDPWR VDPWR VGND VGND gf180mcu_fd_sc_mcu7t5v0__tiel
xtie_uio_out_1 uio_out[1] VDPWR VDPWR VGND VGND gf180mcu_fd_sc_mcu7t5v0__tiel
xtie_uio_out_2 uio_out[2] VDPWR VDPWR VGND VGND gf180mcu_fd_sc_mcu7t5v0__tiel
xtie_uio_out_3 uio_out[3] VDPWR VDPWR VGND VGND gf180mcu_fd_sc_mcu7t5v0__tiel
xtie_uio_out_4 uio_out[4] VDPWR VDPWR VGND VGND gf180mcu_fd_sc_mcu7t5v0__tiel
xtie_uio_out_5 uio_out[5] VDPWR VDPWR VGND VGND gf180mcu_fd_sc_mcu7t5v0__tiel
xtie_uio_out_6 uio_out[6] VDPWR VDPWR VGND VGND gf180mcu_fd_sc_mcu7t5v0__tiel
xtie_uio_out_7 uio_out[7] VDPWR VDPWR VGND VGND gf180mcu_fd_sc_mcu7t5v0__tiel
xtie_uio_oe_0 uio_oe[0] VDPWR VDPWR VGND VGND gf180mcu_fd_sc_mcu7t5v0__tiel
xtie_uio_oe_1 uio_oe[1] VDPWR VDPWR VGND VGND gf180mcu_fd_sc_mcu7t5v0__tiel
xtie_uio_oe_2 uio_oe[2] VDPWR VDPWR VGND VGND gf180mcu_fd_sc_mcu7t5v0__tiel
xtie_uio_oe_3 uio_oe[3] VDPWR VDPWR VGND VGND gf180mcu_fd_sc_mcu7t5v0__tiel
xtie_uio_oe_4 uio_oe[4] VDPWR VDPWR VGND VGND gf180mcu_fd_sc_mcu7t5v0__tiel
xtie_uio_oe_5 uio_oe[5] VDPWR VDPWR VGND VGND gf180mcu_fd_sc_mcu7t5v0__tiel
xtie_uio_oe_6 uio_oe[6] VDPWR VDPWR VGND VGND gf180mcu_fd_sc_mcu7t5v0__tiel
xtie_uio_oe_7 uio_oe[7] VDPWR VDPWR VGND VGND gf180mcu_fd_sc_mcu7t5v0__tiel
.ends

.subckt vco_top VDD VDD_LS VSS vctrl bit0 bit1 bit2 bit3 bit4 bitb0 bitb1 bitb2 bitb3 bitb4 ck a0 vbn vg ls
*.iopin VDD
*.iopin VDD_LS
*.iopin VSS
*.ipin vctrl
*.ipin bit0
*.ipin bit1
*.ipin bit2
*.ipin bit3
*.ipin bit4
*.ipin bitb0
*.ipin bitb1
*.ipin bitb2
*.ipin bitb3
*.ipin bitb4
*.opin ck
*.opin a0
*.opin vbn
*.iopin vg
*.opin ls
xcore VDD VSS net1 vctrl bit0 bit1 bit2 bit3 bit4 bitb0 bitb1 bitb2 bitb3 bitb4 vg a0 net2 net3 net4 net5 ring_core_v3
xref VDD VSS vbn net1 cgm_ref
xls VDD_LS VSS a0 ck ls lsdiv
XDCLS VSS VDD_LS VSS VSS nfet_03v3 L=10.0u W=49.14u nf=1 ad=0 as=0 pd=0 ps=0 nrd=0 nrs=0 sa=0 sb=0 sd=0 m=5
.ends

* expanding   symbol:  ring_core_v3.sym # of pins=20
.subckt ring_core_v3 VDD VSS vbn vctrl bit0 bit1 bit2 bit3 bit4 bitb0 bitb1 bitb2 bitb3 bitb4 vg a0 a1 a2 a3 a4
*.iopin VDD
*.iopin VSS
*.ipin vbn
*.ipin vctrl
*.ipin bit0
*.ipin bit1
*.ipin bit2
*.ipin bit3
*.ipin bit4
*.ipin bitb0
*.ipin bitb1
*.ipin bitb2
*.ipin bitb3
*.ipin bitb4
*.iopin vg
*.opin a0
*.opin a1
*.opin a2
*.opin a3
*.opin a4
xdac vg vbn vctrl bit0 bit1 bit2 bit3 bit4 bitb0 bitb1 bitb2 bitb3 bitb4 VDD VSS cfed_dac
xring VDD vg VSS a0 a1 a2 a3 a4 cfed_ring
XDC VSS vg VSS VSS nfet_03v3 L=4.0u W=30.71u nf=1 ad=0 as=0 pd=0 ps=0 nrd=0 nrs=0 sa=0 sb=0 sd=0 m=6
.ends

* expanding   symbol:  cgm_ref.sym # of pins=4
.subckt cgm_ref VDD VSS vbn vbnf
*.iopin VDD
*.iopin VSS
*.opin vbn
*.opin vbnf
XMP2 net1 net1 VDD VDD pfet_03v3 L=14.0u W=56.0u nf=1 ad=28.0p as=28.0p pd=113.0u ps=113.0u nrd=0 nrs=0 sa=0 sb=0 sd=0
XMP1 vbn net1 VDD VDD pfet_03v3 L=14.0u W=56.0u nf=1 ad=28.0p as=28.0p pd=113.0u ps=113.0u nrd=0 nrs=0 sa=0 sb=0 sd=0
XMN2 net1 vbn net5 VSS nfet_03v3 L=1.0u W=2.0u nf=1 ad=1.0p as=1.0p pd=5.0u ps=5.0u nrd=0 nrs=0 sa=0 sb=0 sd=0 m=56
XMN2s1 net5 vbn net6 VSS nfet_03v3 L=1.0u W=2.0u nf=1 ad=1.0p as=1.0p pd=5.0u ps=5.0u nrd=0 nrs=0 sa=0 sb=0 sd=0 m=56
XMN2s2 net6 vbn net7 VSS nfet_03v3 L=1.0u W=2.0u nf=1 ad=1.0p as=1.0p pd=5.0u ps=5.0u nrd=0 nrs=0 sa=0 sb=0 sd=0 m=56
XMN2s3 net7 vbn net8 VSS nfet_03v3 L=1.0u W=2.0u nf=1 ad=1.0p as=1.0p pd=5.0u ps=5.0u nrd=0 nrs=0 sa=0 sb=0 sd=0 m=56
XMN2s4 net8 vbn net9 VSS nfet_03v3 L=1.0u W=2.0u nf=1 ad=1.0p as=1.0p pd=5.0u ps=5.0u nrd=0 nrs=0 sa=0 sb=0 sd=0 m=56
XMN2s5 net9 vbn net10 VSS nfet_03v3 L=1.0u W=2.0u nf=1 ad=1.0p as=1.0p pd=5.0u ps=5.0u nrd=0 nrs=0 sa=0 sb=0 sd=0 m=56
XMN2s6 net10 vbn net11 VSS nfet_03v3 L=1.0u W=2.0u nf=1 ad=1.0p as=1.0p pd=5.0u ps=5.0u nrd=0 nrs=0 sa=0 sb=0 sd=0 m=56
XMN2s7 net11 vbn net12 VSS nfet_03v3 L=1.0u W=2.0u nf=1 ad=1.0p as=1.0p pd=5.0u ps=5.0u nrd=0 nrs=0 sa=0 sb=0 sd=0 m=56
XMN2s8 net12 vbn net13 VSS nfet_03v3 L=1.0u W=2.0u nf=1 ad=1.0p as=1.0p pd=5.0u ps=5.0u nrd=0 nrs=0 sa=0 sb=0 sd=0 m=56
XMN2s9 net13 vbn net14 VSS nfet_03v3 L=1.0u W=2.0u nf=1 ad=1.0p as=1.0p pd=5.0u ps=5.0u nrd=0 nrs=0 sa=0 sb=0 sd=0 m=56
XMN2s10 net14 vbn net15 VSS nfet_03v3 L=1.0u W=2.0u nf=1 ad=1.0p as=1.0p pd=5.0u ps=5.0u nrd=0 nrs=0 sa=0 sb=0 sd=0 m=56
XMN2s11 net15 vbn net16 VSS nfet_03v3 L=1.0u W=2.0u nf=1 ad=1.0p as=1.0p pd=5.0u ps=5.0u nrd=0 nrs=0 sa=0 sb=0 sd=0 m=56
XMN2s12 net16 vbn net17 VSS nfet_03v3 L=1.0u W=2.0u nf=1 ad=1.0p as=1.0p pd=5.0u ps=5.0u nrd=0 nrs=0 sa=0 sb=0 sd=0 m=56
XMN2s13 net17 vbn net3 VSS nfet_03v3 L=1.0u W=2.0u nf=1 ad=1.0p as=1.0p pd=5.0u ps=5.0u nrd=0 nrs=0 sa=0 sb=0 sd=0 m=56
XMN1 vbn vbn net18 VSS nfet_03v3 L=1.0u W=2.0u nf=1 ad=1.0p as=1.0p pd=5.0u ps=5.0u nrd=0 nrs=0 sa=0 sb=0 sd=0 m=14
XMN1s1 net18 vbn net19 VSS nfet_03v3 L=1.0u W=2.0u nf=1 ad=1.0p as=1.0p pd=5.0u ps=5.0u nrd=0 nrs=0 sa=0 sb=0 sd=0 m=14
XMN1s2 net19 vbn net20 VSS nfet_03v3 L=1.0u W=2.0u nf=1 ad=1.0p as=1.0p pd=5.0u ps=5.0u nrd=0 nrs=0 sa=0 sb=0 sd=0 m=14
XMN1s3 net20 vbn net21 VSS nfet_03v3 L=1.0u W=2.0u nf=1 ad=1.0p as=1.0p pd=5.0u ps=5.0u nrd=0 nrs=0 sa=0 sb=0 sd=0 m=14
XMN1s4 net21 vbn net22 VSS nfet_03v3 L=1.0u W=2.0u nf=1 ad=1.0p as=1.0p pd=5.0u ps=5.0u nrd=0 nrs=0 sa=0 sb=0 sd=0 m=14
XMN1s5 net22 vbn net23 VSS nfet_03v3 L=1.0u W=2.0u nf=1 ad=1.0p as=1.0p pd=5.0u ps=5.0u nrd=0 nrs=0 sa=0 sb=0 sd=0 m=14
XMN1s6 net23 vbn net24 VSS nfet_03v3 L=1.0u W=2.0u nf=1 ad=1.0p as=1.0p pd=5.0u ps=5.0u nrd=0 nrs=0 sa=0 sb=0 sd=0 m=14
XMN1s7 net24 vbn net25 VSS nfet_03v3 L=1.0u W=2.0u nf=1 ad=1.0p as=1.0p pd=5.0u ps=5.0u nrd=0 nrs=0 sa=0 sb=0 sd=0 m=14
XMN1s8 net25 vbn net26 VSS nfet_03v3 L=1.0u W=2.0u nf=1 ad=1.0p as=1.0p pd=5.0u ps=5.0u nrd=0 nrs=0 sa=0 sb=0 sd=0 m=14
XMN1s9 net26 vbn net27 VSS nfet_03v3 L=1.0u W=2.0u nf=1 ad=1.0p as=1.0p pd=5.0u ps=5.0u nrd=0 nrs=0 sa=0 sb=0 sd=0 m=14
XMN1s10 net27 vbn net28 VSS nfet_03v3 L=1.0u W=2.0u nf=1 ad=1.0p as=1.0p pd=5.0u ps=5.0u nrd=0 nrs=0 sa=0 sb=0 sd=0 m=14
XMN1s11 net28 vbn net29 VSS nfet_03v3 L=1.0u W=2.0u nf=1 ad=1.0p as=1.0p pd=5.0u ps=5.0u nrd=0 nrs=0 sa=0 sb=0 sd=0 m=14
XMN1s12 net29 vbn net30 VSS nfet_03v3 L=1.0u W=2.0u nf=1 ad=1.0p as=1.0p pd=5.0u ps=5.0u nrd=0 nrs=0 sa=0 sb=0 sd=0 m=14
XMN1s13 net30 vbn VSS VSS nfet_03v3 L=1.0u W=2.0u nf=1 ad=1.0p as=1.0p pd=5.0u ps=5.0u nrd=0 nrs=0 sa=0 sb=0 sd=0 m=14
XMS1 net2 VSS VDD VDD pfet_03v3 L=10.0u W=0.5u nf=1 ad=0.25p as=0.25p pd=2.0u ps=2.0u nrd=0 nrs=0 sa=0 sb=0 sd=0
XMS2 net2 vbn VSS VSS nfet_03v3 L=0.28u W=2.0u nf=1 ad=1.0p as=1.0p pd=5.0u ps=5.0u nrd=0 nrs=0 sa=0 sb=0 sd=0
XMS3 net1 net2 vbn VSS nfet_03v3 L=0.28u W=1.0u nf=1 ad=0.5p as=0.5p pd=3.0u ps=3.0u nrd=0 nrs=0 sa=0 sb=0 sd=0
XRBW net3 net4 VSS nwell r_width=2.0e-6 r_length=5.025e-6
XRBN net4 VSS VSS nplus_u r_width=2.0e-6 r_length=100.0e-6
XRF vbn vbnf VSS ppolyf_u_1k r_width=1.0e-6 r_length=970.2289999999999e-6
XCF VSS vbnf VSS VSS nfet_03v3 L=10.0u W=49.14u nf=1 ad=24.57p as=24.57p pd=99.28u ps=99.28u nrd=0 nrs=0 sa=0 sb=0 sd=0 m=10
.ends

* expanding   symbol:  lsdiv.sym # of pins=5
.subckt lsdiv VDD VSS a0 ck ls
*.iopin VDD
*.iopin VSS
*.ipin a0
*.opin ck
*.opin ls
xls VDD VSS a0 ls ls_ac
xd1 VDD VSS ls net1 tspc_t1
xd2 VDD VSS net1 net2 tspc_t2
XB1p ck net2 VDD VDD pfet_03v3 L=0.28u W=2.5u nf=1 ad=1.25p as=1.25p pd=6.0u ps=6.0u nrd=0 nrs=0 sa=0 sb=0 sd=0
XB1n ck net2 VSS VSS nfet_03v3 L=0.28u W=1.0u nf=1 ad=0.5p as=0.5p pd=3.0u ps=3.0u nrd=0 nrs=0 sa=0 sb=0 sd=0
.ends

* expanding   symbol:  cfed_dac.sym # of pins=15
.subckt cfed_dac vg vbnf vctrl bit0 bit1 bit2 bit3 bit4 bitb0 bitb1 bitb2 bitb3 bitb4 VDD VSS
*.iopin vg
*.ipin vbnf
*.ipin vctrl
*.ipin bit0
*.ipin bit1
*.ipin bit2
*.ipin bit3
*.ipin bit4
*.ipin bitb0
*.ipin bitb1
*.ipin bitb2
*.ipin bitb3
*.ipin bitb4
*.iopin VDD
*.iopin VSS
XFFC vg vctrl VSS VSS nfet_03v3 L=21.333333333333332u W=1.2u nf=1 ad=0.6p as=0.6p pd=3.4u ps=3.4u nrd=0 nrs=0 sa=0 sb=0 sd=0
XFC vg vbnf VSS VSS nfet_03v3 L=5.333333333333333u W=1.2u nf=1 ad=0.6p as=0.6p pd=3.4u ps=3.4u nrd=0 nrs=0 sa=0 sb=0 sd=0 m=6
XFC_0 vg net1 VSS VSS nfet_03v3 L=5.333333333333333u W=1.2u nf=1 ad=0.6p as=0.6p pd=3.4u ps=3.4u nrd=0 nrs=0 sa=0 sb=0 sd=0
XFC_1 vg net2 VSS VSS nfet_03v3 L=5.333333333333333u W=1.2u nf=1 ad=0.6p as=0.6p pd=3.4u ps=3.4u nrd=0 nrs=0 sa=0 sb=0 sd=0 m=2
XFC_2 vg net3 VSS VSS nfet_03v3 L=5.333333333333333u W=1.2u nf=1 ad=0.6p as=0.6p pd=3.4u ps=3.4u nrd=0 nrs=0 sa=0 sb=0 sd=0 m=4
XFC_3 vg net4 VSS VSS nfet_03v3 L=5.333333333333333u W=1.2u nf=1 ad=0.6p as=0.6p pd=3.4u ps=3.4u nrd=0 nrs=0 sa=0 sb=0 sd=0 m=8
XFC_4 vg net5 VSS VSS nfet_03v3 L=5.333333333333333u W=1.2u nf=1 ad=0.6p as=0.6p pd=3.4u ps=3.4u nrd=0 nrs=0 sa=0 sb=0 sd=0 m=16
XTP0 net1 bitb0 vbnf VDD pfet_03v3 L=0.28u W=5.0u nf=1 ad=2.5p as=2.5p pd=11.0u ps=11.0u nrd=0 nrs=0 sa=0 sb=0 sd=0
XTN0 net1 bit0 vbnf VSS nfet_03v3 L=0.28u W=2.0u nf=1 ad=1.0p as=1.0p pd=5.0u ps=5.0u nrd=0 nrs=0 sa=0 sb=0 sd=0
XTD0 net1 bitb0 VSS VSS nfet_03v3 L=0.28u W=1.0u nf=1 ad=0.5p as=0.5p pd=3.0u ps=3.0u nrd=0 nrs=0 sa=0 sb=0 sd=0
XTP1 net2 bitb1 vbnf VDD pfet_03v3 L=0.28u W=5.0u nf=1 ad=2.5p as=2.5p pd=11.0u ps=11.0u nrd=0 nrs=0 sa=0 sb=0 sd=0
XTN1 net2 bit1 vbnf VSS nfet_03v3 L=0.28u W=2.0u nf=1 ad=1.0p as=1.0p pd=5.0u ps=5.0u nrd=0 nrs=0 sa=0 sb=0 sd=0
XTD1 net2 bitb1 VSS VSS nfet_03v3 L=0.28u W=1.0u nf=1 ad=0.5p as=0.5p pd=3.0u ps=3.0u nrd=0 nrs=0 sa=0 sb=0 sd=0
XTP2 net3 bitb2 vbnf VDD pfet_03v3 L=0.28u W=5.0u nf=1 ad=2.5p as=2.5p pd=11.0u ps=11.0u nrd=0 nrs=0 sa=0 sb=0 sd=0
XTN2 net3 bit2 vbnf VSS nfet_03v3 L=0.28u W=2.0u nf=1 ad=1.0p as=1.0p pd=5.0u ps=5.0u nrd=0 nrs=0 sa=0 sb=0 sd=0
XTD2 net3 bitb2 VSS VSS nfet_03v3 L=0.28u W=1.0u nf=1 ad=0.5p as=0.5p pd=3.0u ps=3.0u nrd=0 nrs=0 sa=0 sb=0 sd=0
XTP3 net4 bitb3 vbnf VDD pfet_03v3 L=0.28u W=5.0u nf=1 ad=2.5p as=2.5p pd=11.0u ps=11.0u nrd=0 nrs=0 sa=0 sb=0 sd=0
XTN3 net4 bit3 vbnf VSS nfet_03v3 L=0.28u W=2.0u nf=1 ad=1.0p as=1.0p pd=5.0u ps=5.0u nrd=0 nrs=0 sa=0 sb=0 sd=0
XTD3 net4 bitb3 VSS VSS nfet_03v3 L=0.28u W=1.0u nf=1 ad=0.5p as=0.5p pd=3.0u ps=3.0u nrd=0 nrs=0 sa=0 sb=0 sd=0
XTP4 net5 bitb4 vbnf VDD pfet_03v3 L=0.28u W=5.0u nf=1 ad=2.5p as=2.5p pd=11.0u ps=11.0u nrd=0 nrs=0 sa=0 sb=0 sd=0
XTN4 net5 bit4 vbnf VSS nfet_03v3 L=0.28u W=2.0u nf=1 ad=1.0p as=1.0p pd=5.0u ps=5.0u nrd=0 nrs=0 sa=0 sb=0 sd=0
XTD4 net5 bitb4 VSS VSS nfet_03v3 L=0.28u W=1.0u nf=1 ad=0.5p as=0.5p pd=3.0u ps=3.0u nrd=0 nrs=0 sa=0 sb=0 sd=0
.ends

* expanding   symbol:  cfed_ring.sym # of pins=8
.subckt cfed_ring VDD vg VSS a0 a1 a2 a3 a4
*.iopin VDD
*.iopin vg
*.iopin VSS
*.opin a0
*.opin a1
*.opin a2
*.opin a3
*.opin a4
XP0 a1 a0 VDD VDD pfet_03v3 L=0.28u W=5.0u nf=1 ad=2.5p as=2.5p pd=11.0u ps=11.0u nrd=0 nrs=0 sa=0 sb=0 sd=0
XN0 a1 a0 vg VSS nfet_03v3 L=0.28u W=2.0u nf=1 ad=1.0p as=1.0p pd=5.0u ps=5.0u nrd=0 nrs=0 sa=0 sb=0 sd=0
XP1 a2 a1 VDD VDD pfet_03v3 L=0.28u W=5.0u nf=1 ad=2.5p as=2.5p pd=11.0u ps=11.0u nrd=0 nrs=0 sa=0 sb=0 sd=0
XN1 a2 a1 vg VSS nfet_03v3 L=0.28u W=2.0u nf=1 ad=1.0p as=1.0p pd=5.0u ps=5.0u nrd=0 nrs=0 sa=0 sb=0 sd=0
XP2 a3 a2 VDD VDD pfet_03v3 L=0.28u W=5.0u nf=1 ad=2.5p as=2.5p pd=11.0u ps=11.0u nrd=0 nrs=0 sa=0 sb=0 sd=0
XN2 a3 a2 vg VSS nfet_03v3 L=0.28u W=2.0u nf=1 ad=1.0p as=1.0p pd=5.0u ps=5.0u nrd=0 nrs=0 sa=0 sb=0 sd=0
XP3 a4 a3 VDD VDD pfet_03v3 L=0.28u W=5.0u nf=1 ad=2.5p as=2.5p pd=11.0u ps=11.0u nrd=0 nrs=0 sa=0 sb=0 sd=0
XN3 a4 a3 vg VSS nfet_03v3 L=0.28u W=2.0u nf=1 ad=1.0p as=1.0p pd=5.0u ps=5.0u nrd=0 nrs=0 sa=0 sb=0 sd=0
XP4 a0 a4 VDD VDD pfet_03v3 L=0.28u W=5.0u nf=1 ad=2.5p as=2.5p pd=11.0u ps=11.0u nrd=0 nrs=0 sa=0 sb=0 sd=0
XN4 a0 a4 vg VSS nfet_03v3 L=0.28u W=2.0u nf=1 ad=1.0p as=1.0p pd=5.0u ps=5.0u nrd=0 nrs=0 sa=0 sb=0 sd=0
.ends

* expanding   symbol:  ls_ac.sym # of pins=4
.subckt ls_ac VDD VSS a0 ls
*.iopin VDD
*.iopin VSS
*.ipin a0
*.opin ls
XL1p net2 net1 VDD VDD pfet_03v3 L=0.28u W=0.5u nf=1 ad=0.25p as=0.25p pd=2.0u ps=2.0u nrd=0 nrs=0 sa=0 sb=0 sd=0
XL1n net2 net1 VSS VSS nfet_03v3 L=0.28u W=0.21999999999999997u nf=1 ad=0.10999999999999999p as=0.10999999999999999p pd=1.44u
+ ps=1.44u nrd=0 nrs=0 sa=0 sb=0 sd=0
XL2p net3 net2 VDD VDD pfet_03v3 L=0.28u W=1.5u nf=1 ad=0.75p as=0.75p pd=4.0u ps=4.0u nrd=0 nrs=0 sa=0 sb=0 sd=0
XL2n net3 net2 VSS VSS nfet_03v3 L=0.28u W=0.6u nf=1 ad=0.3p as=0.3p pd=2.2u ps=2.2u nrd=0 nrs=0 sa=0 sb=0 sd=0
XL3p ls net3 VDD VDD pfet_03v3 L=0.28u W=3.0u nf=1 ad=1.5p as=1.5p pd=7.0u ps=7.0u nrd=0 nrs=0 sa=0 sb=0 sd=0
XL3n ls net3 VSS VSS nfet_03v3 L=0.28u W=1.2u nf=1 ad=0.6p as=0.6p pd=3.4u ps=3.4u nrd=0 nrs=0 sa=0 sb=0 sd=0
XLRB net1 VSS net4 VDD pfet_03v3 L=2.0u W=0.21999999999999997u nf=1 ad=0.10999999999999999p as=0.10999999999999999p pd=1.44u
+ ps=1.44u nrd=0 nrs=0 sa=0 sb=0 sd=0
XR1 ls net4 VSS ppolyf_u_1k r_width=1.0e-6 r_length=159.125e-6
XC1 VSS net4 VSS VSS nfet_03v3 L=16.0u W=16.0u nf=1 ad=8.0p as=8.0p pd=33.0u ps=33.0u nrd=0 nrs=0 sa=0 sb=0 sd=0
.ends

* expanding   symbol:  tspc_t1.sym # of pins=4
.subckt tspc_t1 VDD VSS clk q
*.iopin VDD
*.iopin VSS
*.ipin clk
*.opin q
Xp1 net1 net6 VDD VDD pfet_03v3 L=0.28u W=2.0u nf=1 ad=1.0p as=1.0p pd=5.0u ps=5.0u nrd=0 nrs=0 sa=0 sb=0 sd=0
Xp2 net4 clk net1 VDD pfet_03v3 L=0.28u W=2.0u nf=1 ad=1.0p as=1.0p pd=5.0u ps=5.0u nrd=0 nrs=0 sa=0 sb=0 sd=0
Xn1 net4 net6 VSS VSS nfet_03v3 L=0.28u W=1.0u nf=1 ad=0.5p as=0.5p pd=3.0u ps=3.0u nrd=0 nrs=0 sa=0 sb=0 sd=0
Xp3 net5 clk VDD VDD pfet_03v3 L=0.28u W=2.0u nf=1 ad=1.0p as=1.0p pd=5.0u ps=5.0u nrd=0 nrs=0 sa=0 sb=0 sd=0
Xn2 net5 net4 net2 VSS nfet_03v3 L=0.28u W=1.0u nf=1 ad=0.5p as=0.5p pd=3.0u ps=3.0u nrd=0 nrs=0 sa=0 sb=0 sd=0
Xn3 net2 clk VSS VSS nfet_03v3 L=0.28u W=1.0u nf=1 ad=0.5p as=0.5p pd=3.0u ps=3.0u nrd=0 nrs=0 sa=0 sb=0 sd=0
Xp4 net6 net5 VDD VDD pfet_03v3 L=0.28u W=2.0u nf=1 ad=1.0p as=1.0p pd=5.0u ps=5.0u nrd=0 nrs=0 sa=0 sb=0 sd=0
Xn4 net6 clk net3 VSS nfet_03v3 L=0.28u W=1.0u nf=1 ad=0.5p as=0.5p pd=3.0u ps=3.0u nrd=0 nrs=0 sa=0 sb=0 sd=0
Xn5 net3 net5 VSS VSS nfet_03v3 L=0.28u W=1.0u nf=1 ad=0.5p as=0.5p pd=3.0u ps=3.0u nrd=0 nrs=0 sa=0 sb=0 sd=0
Xqp q net6 VDD VDD pfet_03v3 L=0.28u W=1.5u nf=1 ad=0.75p as=0.75p pd=4.0u ps=4.0u nrd=0 nrs=0 sa=0 sb=0 sd=0
Xqn q net6 VSS VSS nfet_03v3 L=0.28u W=0.6u nf=1 ad=0.3p as=0.3p pd=2.2u ps=2.2u nrd=0 nrs=0 sa=0 sb=0 sd=0
.ends

* expanding   symbol:  tspc_t2.sym # of pins=4
.subckt tspc_t2 VDD VSS clk q
*.iopin VDD
*.iopin VSS
*.ipin clk
*.opin q
Xp1 net1 net6 VDD VDD pfet_03v3 L=0.28u W=1.2u nf=1 ad=0.6p as=0.6p pd=3.4u ps=3.4u nrd=0 nrs=0 sa=0 sb=0 sd=0
Xp2 net4 clk net1 VDD pfet_03v3 L=0.28u W=1.2u nf=1 ad=0.6p as=0.6p pd=3.4u ps=3.4u nrd=0 nrs=0 sa=0 sb=0 sd=0
Xn1 net4 net6 VSS VSS nfet_03v3 L=0.28u W=0.6u nf=1 ad=0.3p as=0.3p pd=2.2u ps=2.2u nrd=0 nrs=0 sa=0 sb=0 sd=0
Xp3 net5 clk VDD VDD pfet_03v3 L=0.28u W=1.2u nf=1 ad=0.6p as=0.6p pd=3.4u ps=3.4u nrd=0 nrs=0 sa=0 sb=0 sd=0
Xn2 net5 net4 net2 VSS nfet_03v3 L=0.28u W=0.6u nf=1 ad=0.3p as=0.3p pd=2.2u ps=2.2u nrd=0 nrs=0 sa=0 sb=0 sd=0
Xn3 net2 clk VSS VSS nfet_03v3 L=0.28u W=0.6u nf=1 ad=0.3p as=0.3p pd=2.2u ps=2.2u nrd=0 nrs=0 sa=0 sb=0 sd=0
Xp4 net6 net5 VDD VDD pfet_03v3 L=0.28u W=1.2u nf=1 ad=0.6p as=0.6p pd=3.4u ps=3.4u nrd=0 nrs=0 sa=0 sb=0 sd=0
Xn4 net6 clk net3 VSS nfet_03v3 L=0.28u W=0.6u nf=1 ad=0.3p as=0.3p pd=2.2u ps=2.2u nrd=0 nrs=0 sa=0 sb=0 sd=0
Xn5 net3 net5 VSS VSS nfet_03v3 L=0.28u W=0.6u nf=1 ad=0.3p as=0.3p pd=2.2u ps=2.2u nrd=0 nrs=0 sa=0 sb=0 sd=0
Xqp q net6 VDD VDD pfet_03v3 L=0.28u W=1.5u nf=1 ad=0.75p as=0.75p pd=4.0u ps=4.0u nrd=0 nrs=0 sa=0 sb=0 sd=0
Xqn q net6 VSS VSS nfet_03v3 L=0.28u W=0.6u nf=1 ad=0.3p as=0.3p pd=2.2u ps=2.2u nrd=0 nrs=0 sa=0 sb=0 sd=0
.ends

.subckt tx_drv VDD VSS ls en_p en_n out_p out_n
*.iopin VDD
*.iopin VSS
*.ipin ls
*.ipin en_p
*.ipin en_n
*.opin out_p
*.opin out_n
xsp VDD VSS ls net1 net2 tx_split
xap VDD VSS net1 en_p out_p tx_arm
xan VDD VSS net2 en_n out_n tx_arm
XDC VSS VDD VSS VSS nfet_03v3 L=10.0u W=10.0u nf=1 ad=5.0p as=5.0p pd=21.0u ps=21.0u nrd=0 nrs=0 sa=0 sb=0 sd=0 m=24
.ends

* expanding   symbol:  tx_split.sym # of pins=5
.subckt tx_split VDD VSS ls a b
*.iopin VDD
*.iopin VSS
*.ipin ls
*.opin a
*.opin b
XTp net1 ls VDD VDD pfet_03v3 L=0.28u W=1.0499999999999998u nf=1 ad=0.5249999999999999p as=0.5249999999999999p
+ pd=3.0999999999999996u ps=3.0999999999999996u nrd=0 nrs=0 sa=0 sb=0 sd=0
XTn net1 ls VSS VSS nfet_03v3 L=0.28u W=0.41999999999999993u nf=1 ad=0.20999999999999996p as=0.20999999999999996p
+ pd=1.8399999999999999u ps=1.8399999999999999u nrd=0 nrs=0 sa=0 sb=0 sd=0
XA1p net2 net1 VDD VDD pfet_03v3 L=0.28u W=1.25u nf=1 ad=0.625p as=0.625p pd=3.5u ps=3.5u nrd=0 nrs=0 sa=0 sb=0 sd=0
XA1n net2 net1 VSS VSS nfet_03v3 L=0.28u W=0.5u nf=1 ad=0.25p as=0.25p pd=2.0u ps=2.0u nrd=0 nrs=0 sa=0 sb=0 sd=0
XA2p a net2 VDD VDD pfet_03v3 L=0.28u W=2.5u nf=1 ad=1.25p as=1.25p pd=6.0u ps=6.0u nrd=0 nrs=0 sa=0 sb=0 sd=0
XA2n a net2 VSS VSS nfet_03v3 L=0.28u W=1.0u nf=1 ad=0.5p as=0.5p pd=3.0u ps=3.0u nrd=0 nrs=0 sa=0 sb=0 sd=0
XB1p net3 net1 VDD VDD pfet_03v3 L=0.28u W=3.7499999999999996u nf=1 ad=1.8749999999999998p as=1.8749999999999998p pd=8.5u ps=8.5u
+ nrd=0 nrs=0 sa=0 sb=0 sd=0
XB1n net3 net1 VSS VSS nfet_03v3 L=0.28u W=1.5u nf=1 ad=0.75p as=0.75p pd=4.0u ps=4.0u nrd=0 nrs=0 sa=0 sb=0 sd=0
XTGp b VSS net3 VDD pfet_03v3 L=0.28u W=2.5u nf=1 ad=1.25p as=1.25p pd=6.0u ps=6.0u nrd=0 nrs=0 sa=0 sb=0 sd=0
XTGn b VDD net3 VSS nfet_03v3 L=0.28u W=1.0u nf=1 ad=0.5p as=0.5p pd=3.0u ps=3.0u nrd=0 nrs=0 sa=0 sb=0 sd=0
XXBp b a VDD VDD pfet_03v3 L=0.28u W=1.0499999999999998u nf=1 ad=0.5249999999999999p as=0.5249999999999999p pd=3.0999999999999996u
+ ps=3.0999999999999996u nrd=0 nrs=0 sa=0 sb=0 sd=0
XXBn b a VSS VSS nfet_03v3 L=0.28u W=0.41999999999999993u nf=1 ad=0.20999999999999996p as=0.20999999999999996p
+ pd=1.8399999999999999u ps=1.8399999999999999u nrd=0 nrs=0 sa=0 sb=0 sd=0
XXAp a b VDD VDD pfet_03v3 L=0.28u W=1.0499999999999998u nf=1 ad=0.5249999999999999p as=0.5249999999999999p pd=3.0999999999999996u
+ ps=3.0999999999999996u nrd=0 nrs=0 sa=0 sb=0 sd=0
XXAn a b VSS VSS nfet_03v3 L=0.28u W=0.41999999999999993u nf=1 ad=0.20999999999999996p as=0.20999999999999996p
+ pd=1.8399999999999999u ps=1.8399999999999999u nrd=0 nrs=0 sa=0 sb=0 sd=0
.ends

* expanding   symbol:  tx_arm.sym # of pins=5
.subckt tx_arm VDD VSS in en out
*.iopin VDD
*.iopin VSS
*.ipin in
*.ipin en
*.opin out
XNAp net1 in VDD VDD pfet_03v3 L=0.28u W=1.25u nf=1 ad=0.625p as=0.625p pd=3.5u ps=3.5u nrd=0 nrs=0 sa=0 sb=0 sd=0
XNBp net1 en VDD VDD pfet_03v3 L=0.28u W=1.25u nf=1 ad=0.625p as=0.625p pd=3.5u ps=3.5u nrd=0 nrs=0 sa=0 sb=0 sd=0
XNAn net1 in net2 VSS nfet_03v3 L=0.28u W=1.0u nf=1 ad=0.5p as=0.5p pd=3.0u ps=3.0u nrd=0 nrs=0 sa=0 sb=0 sd=0
XNBn net2 en VSS VSS nfet_03v3 L=0.28u W=1.0u nf=1 ad=0.5p as=0.5p pd=3.0u ps=3.0u nrd=0 nrs=0 sa=0 sb=0 sd=0
XM1p net3 net1 VDD VDD pfet_03v3 L=0.28u W=1.0499999999999998u nf=1 ad=0.5249999999999999p as=0.5249999999999999p
+ pd=3.0999999999999996u ps=3.0999999999999996u nrd=0 nrs=0 sa=0 sb=0 sd=0
XM1n net3 net1 VSS VSS nfet_03v3 L=0.28u W=0.41999999999999993u nf=1 ad=0.20999999999999996p as=0.20999999999999996p
+ pd=1.8399999999999999u ps=1.8399999999999999u nrd=0 nrs=0 sa=0 sb=0 sd=0
XM2p net4 net3 VDD VDD pfet_03v3 L=0.28u W=1.5624999999999998u nf=1 ad=0.7812499999999999p as=0.7812499999999999p pd=4.125u
+ ps=4.125u nrd=0 nrs=0 sa=0 sb=0 sd=0
XM2n net4 net3 VSS VSS nfet_03v3 L=0.28u W=0.625u nf=1 ad=0.3125p as=0.3125p pd=2.25u ps=2.25u nrd=0 nrs=0 sa=0 sb=0 sd=0
XM3p net5 net4 VDD VDD pfet_03v3 L=0.28u W=6.249999999999999u nf=1 ad=3.1249999999999996p as=3.1249999999999996p
+ pd=13.499999999999998u ps=13.499999999999998u nrd=0 nrs=0 sa=0 sb=0 sd=0
XM3n net5 net4 VSS VSS nfet_03v3 L=0.28u W=2.5u nf=1 ad=1.25p as=1.25p pd=6.0u ps=6.0u nrd=0 nrs=0 sa=0 sb=0 sd=0
XM4p net6 net5 VDD VDD pfet_03v3 L=0.28u W=12.499999999999998u nf=1 ad=6.249999999999999p as=6.249999999999999p
+ pd=25.999999999999996u ps=25.999999999999996u nrd=0 nrs=0 sa=0 sb=0 sd=0 m=2
XM4n net6 net5 VSS VSS nfet_03v3 L=0.28u W=5.0u nf=1 ad=2.5p as=2.5p pd=11.0u ps=11.0u nrd=0 nrs=0 sa=0 sb=0 sd=0 m=2
XM5p out net6 VDD VDD pfet_03v3 L=0.28u W=20.0u nf=1 ad=10.0p as=10.0p pd=41.0u ps=41.0u nrd=0 nrs=0 sa=0 sb=0 sd=0 m=5
XM5n out net6 VSS VSS nfet_03v3 L=0.28u W=8.0u nf=1 ad=4.0p as=4.0p pd=17.0u ps=17.0u nrd=0 nrs=0 sa=0 sb=0 sd=0 m=5
.ends

.SUBCKT gf180mcu_fd_sc_mcu7t5v0__inv_1 I ZN VDD VNW VPW VSS
X_i_0 ZN I VSS VPW nfet_05v0 W=8.2e-07 L=6e-07
X_i_1 ZN I VDD VNW pfet_05v0 W=1.22e-06 L=5e-07
.ENDS

.SUBCKT gf180mcu_fd_sc_mcu7t5v0__tiel ZN VDD VNW VPW VSS
X_n_tran_1 VSS A ZN VPW nfet_05v0 W=8.2e-07 L=6e-07
X_transistor_0 VDD A A VNW pfet_05v0 W=1.22e-06 L=5e-07
.ENDS

.SUBCKT gf180mcu_fd_sc_mcu7t5v0__antenna I VDD VNW VPW VSS
D0 VPW I diode_nd2ps_06v0 AREA=0.2052p PJ=1.86u M=1
D1 I VNW diode_pd2nw_06v0 AREA=0.2052p PJ=1.86u M=1
.ENDS

.end
