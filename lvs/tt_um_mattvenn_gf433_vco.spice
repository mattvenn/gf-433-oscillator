* LVS source for tt_um_mattvenn_gf433_vco (Tiny Tapeout gf180mcuD analog 2x2), generated by lvs/make_source.py
* from xschem/vco_top.sch (edits: lsdiv Cc removed, XRBW L snapped 5.023 -> 5.025 um), xschem/tx_drv.sch
* and the PDK's
* gf180mcu_fd_sc_mcu7t5v0 spice (the cells used); macro/tx_fine/nl/tx_fine.pnl.v (lvs/verilog2spice.py);
* layout/gen/mdac.py lvs_source(); layout/gen/vctrl_pd.py. Do not edit by hand.

.subckt tt_um_mattvenn_gf433_vco VGND VDPWR ui_in[0] ui_in[1] ui_in[2] ui_in[3] ui_in[4] ui_in[5] ui_in[6] ui_in[7] uo_out[0] uo_out[1] uo_out[2] uo_out[3] uo_out[4] uo_out[5] uo_out[6] uo_out[7] uio_in[0] uio_in[1] uio_in[2] uio_in[3] uio_in[4] uio_in[5] uio_in[6] uio_in[7] uio_out[0] uio_out[1] uio_out[2] uio_out[3] uio_out[4] uio_out[5] uio_out[6] uio_out[7] uio_oe[0] uio_oe[1] uio_oe[2] uio_oe[3] uio_oe[4] uio_oe[5] uio_oe[6] uio_oe[7] ua[0] ua[1] ua[2] ua[3] ua[4] ua[5] ua[6] ua[7] ena clk rst_n
xvco VDPWR VDPWR VGND ua[0] ui_in[0] ui_in[1] ui_in[2] ui_in[3] ui_in[4] bitb0 bitb1 bitb2 bitb3 bitb4 ck a0 ua[1] vg ls vbnf vco_top
xinv0 ui_in[0] bitb0 VDPWR VDPWR VGND VGND gf180mcu_fd_sc_mcu7t5v0__inv_1
xinv1 ui_in[1] bitb1 VDPWR VDPWR VGND VGND gf180mcu_fd_sc_mcu7t5v0__inv_1
xinv2 ui_in[2] bitb2 VDPWR VDPWR VGND VGND gf180mcu_fd_sc_mcu7t5v0__inv_1
xinv3 ui_in[3] bitb3 VDPWR VDPWR VGND VGND gf180mcu_fd_sc_mcu7t5v0__inv_1
xinv4 ui_in[4] bitb4 VDPWR VDPWR VGND VGND gf180mcu_fd_sc_mcu7t5v0__inv_1
xant0 ui_in[0] VDPWR VDPWR VGND VGND gf180mcu_fd_sc_mcu7t5v0__antenna
xant1 ui_in[1] VDPWR VDPWR VGND VGND gf180mcu_fd_sc_mcu7t5v0__antenna
xant2 ui_in[2] VDPWR VDPWR VGND VGND gf180mcu_fd_sc_mcu7t5v0__antenna
xant3 ui_in[3] VDPWR VDPWR VGND VGND gf180mcu_fd_sc_mcu7t5v0__antenna
xant4 ui_in[4] VDPWR VDPWR VGND VGND gf180mcu_fd_sc_mcu7t5v0__antenna
xtx VDPWR VGND ls ui_in[5] ui_in[6] ua[3] ua[2] tx_drv
xant5 ui_in[5] VDPWR VDPWR VGND VGND gf180mcu_fd_sc_mcu7t5v0__antenna
xant6 ui_in[6] VDPWR VDPWR VGND VGND gf180mcu_fd_sc_mcu7t5v0__antenna
xmac ck uo_out[0] clk uio_in[2] dac_sdn uo_out[3] uo_out[1] uo_out[2] ui_in[7] uio_out[3] uio_in[1] rst_n uio_in[0] VDPWR VGND dac_bn[4] dac_bn[3] dac_bn[2] dac_bn[1] dac_bn[0] dac_tn[30] dac_tn[29] dac_tn[28] dac_tn[27] dac_tn[26] dac_tn[25] dac_tn[24] dac_tn[23] dac_tn[22] dac_tn[21] dac_tn[20] dac_tn[19] dac_tn[18] dac_tn[17] dac_tn[16] dac_tn[15] dac_tn[14] dac_tn[13] dac_tn[12] dac_tn[11] dac_tn[10] dac_tn[9] dac_tn[8] dac_tn[7] dac_tn[6] dac_tn[5] dac_tn[4] dac_tn[3] dac_tn[2] dac_tn[1] dac_tn[0] tx_fine
xmdac VDPWR VGND vg vbnf dac_tn[29] dac_tn[27] dac_tn[25] dac_tn[23] dac_tn[21] dac_tn[19] dac_tn[17] dac_tn[15] dac_tn[13] dac_tn[11] dac_tn[9] dac_tn[7] dac_tn[5] dac_tn[3] dac_tn[1] dac_bn[4] dac_bn[2] dac_bn[0] dac_sdn dac_bn[1] dac_bn[3] dac_tn[0] dac_tn[2] dac_tn[4] dac_tn[6] dac_tn[8] dac_tn[10] dac_tn[12] dac_tn[14] dac_tn[16] dac_tn[18] dac_tn[20] dac_tn[22] dac_tn[24] dac_tn[26] dac_tn[28] dac_tn[30] mdac
xvpd ua[0] VGND vctrl_pd
xtie_uo_out_4 uo_out[4] VDPWR VDPWR VGND VGND gf180mcu_fd_sc_mcu7t5v0__tiel
xtie_uo_out_5 uo_out[5] VDPWR VDPWR VGND VGND gf180mcu_fd_sc_mcu7t5v0__tiel
xtie_uo_out_6 uo_out[6] VDPWR VDPWR VGND VGND gf180mcu_fd_sc_mcu7t5v0__tiel
xtie_uo_out_7 uo_out[7] VDPWR VDPWR VGND VGND gf180mcu_fd_sc_mcu7t5v0__tiel
xtie_uio_out_0 uio_out[0] VDPWR VDPWR VGND VGND gf180mcu_fd_sc_mcu7t5v0__tiel
xtie_uio_out_1 uio_out[1] VDPWR VDPWR VGND VGND gf180mcu_fd_sc_mcu7t5v0__tiel
xtie_uio_out_2 uio_out[2] VDPWR VDPWR VGND VGND gf180mcu_fd_sc_mcu7t5v0__tiel
xtie_uio_out_4 uio_out[4] VDPWR VDPWR VGND VGND gf180mcu_fd_sc_mcu7t5v0__tiel
xtie_uio_out_5 uio_out[5] VDPWR VDPWR VGND VGND gf180mcu_fd_sc_mcu7t5v0__tiel
xtie_uio_out_6 uio_out[6] VDPWR VDPWR VGND VGND gf180mcu_fd_sc_mcu7t5v0__tiel
xtie_uio_out_7 uio_out[7] VDPWR VDPWR VGND VGND gf180mcu_fd_sc_mcu7t5v0__tiel
xtie_uio_oe_0 uio_oe[0] VDPWR VDPWR VGND VGND gf180mcu_fd_sc_mcu7t5v0__tiel
xtie_uio_oe_1 uio_oe[1] VDPWR VDPWR VGND VGND gf180mcu_fd_sc_mcu7t5v0__tiel
xtie_uio_oe_2 uio_oe[2] VDPWR VDPWR VGND VGND gf180mcu_fd_sc_mcu7t5v0__tiel
xtie_uio_oe_3 uio_oe[3] VDPWR VDPWR VGND VGND gf180mcu_fd_sc_mcu7t5v0__tieh
xtie_uio_oe_4 uio_oe[4] VDPWR VDPWR VGND VGND gf180mcu_fd_sc_mcu7t5v0__tiel
xtie_uio_oe_5 uio_oe[5] VDPWR VDPWR VGND VGND gf180mcu_fd_sc_mcu7t5v0__tiel
xtie_uio_oe_6 uio_oe[6] VDPWR VDPWR VGND VGND gf180mcu_fd_sc_mcu7t5v0__tiel
xtie_uio_oe_7 uio_oe[7] VDPWR VDPWR VGND VGND gf180mcu_fd_sc_mcu7t5v0__tiel
.ends

.subckt vco_top VDD VDD_LS VSS vctrl bit0 bit1 bit2 bit3 bit4 bitb0 bitb1 bitb2 bitb3 bitb4 ck a0 vbn vg ls vbnf
*.iopin VDD
*.iopin VDD_LS
*.iopin VSS
*.ipin vctrl
*.ipin bit0
*.ipin bit1
*.ipin bit2
*.ipin bit3
*.ipin bit4
*.ipin bitb0
*.ipin bitb1
*.ipin bitb2
*.ipin bitb3
*.ipin bitb4
*.opin ck
*.opin a0
*.opin vbn
*.iopin vg
*.opin ls
*.opin vbnf
xcore VDD VSS vbnf vctrl bit0 bit1 bit2 bit3 bit4 bitb0 bitb1 bitb2 bitb3 bitb4 vg a0 net1 net2 net3 net4 ring_core_v3
xref VDD VSS vbn vbnf cgm_ref
xls VDD_LS VSS a0 ck ls lsdiv
XDCLS VSS VDD_LS VSS VSS nfet_03v3 L=10.0u W=49.14u nf=1 ad=0 as=0 pd=0 ps=0 nrd=0 nrs=0 sa=0 sb=0 sd=0 m=5
.ends

* expanding   symbol:  ring_core_v3.sym # of pins=20
.subckt ring_core_v3 VDD VSS vbn vctrl bit0 bit1 bit2 bit3 bit4 bitb0 bitb1 bitb2 bitb3 bitb4 vg a0 a1 a2 a3 a4
*.iopin VDD
*.iopin VSS
*.ipin vbn
*.ipin vctrl
*.ipin bit0
*.ipin bit1
*.ipin bit2
*.ipin bit3
*.ipin bit4
*.ipin bitb0
*.ipin bitb1
*.ipin bitb2
*.ipin bitb3
*.ipin bitb4
*.iopin vg
*.opin a0
*.opin a1
*.opin a2
*.opin a3
*.opin a4
xdac vg vbn vctrl bit0 bit1 bit2 bit3 bit4 bitb0 bitb1 bitb2 bitb3 bitb4 VDD VSS cfed_dac
xring VDD vg VSS a0 a1 a2 a3 a4 cfed_ring
XDC VDD vg VDD VDD pfet_03v3 L=4.12u W=29.82u nf=1 ad=0 as=0 pd=0 ps=0 nrd=0 nrs=0 sa=0 sb=0 sd=0 m=6
.ends

* expanding   symbol:  cgm_ref.sym # of pins=4
.subckt cgm_ref VDD VSS vbn vbnf
*.iopin VDD
*.iopin VSS
*.opin vbn
*.opin vbnf
XMP2 net1 net1 VDD VDD pfet_03v3 L=14.0u W=56.0u nf=1 ad=28.0p as=28.0p pd=113.0u ps=113.0u nrd=0 nrs=0 sa=0 sb=0 sd=0
XMP1 vbn net1 VDD VDD pfet_03v3 L=14.0u W=56.0u nf=1 ad=28.0p as=28.0p pd=113.0u ps=113.0u nrd=0 nrs=0 sa=0 sb=0 sd=0
XMN2 net1 vbn net5 VSS nfet_03v3 L=1.0u W=2.0u nf=1 ad=1.0p as=1.0p pd=5.0u ps=5.0u nrd=0 nrs=0 sa=0 sb=0 sd=0 m=56
XMN2s1 net5 vbn net6 VSS nfet_03v3 L=1.0u W=2.0u nf=1 ad=1.0p as=1.0p pd=5.0u ps=5.0u nrd=0 nrs=0 sa=0 sb=0 sd=0 m=56
XMN2s2 net6 vbn net7 VSS nfet_03v3 L=1.0u W=2.0u nf=1 ad=1.0p as=1.0p pd=5.0u ps=5.0u nrd=0 nrs=0 sa=0 sb=0 sd=0 m=56
XMN2s3 net7 vbn net8 VSS nfet_03v3 L=1.0u W=2.0u nf=1 ad=1.0p as=1.0p pd=5.0u ps=5.0u nrd=0 nrs=0 sa=0 sb=0 sd=0 m=56
XMN2s4 net8 vbn net9 VSS nfet_03v3 L=1.0u W=2.0u nf=1 ad=1.0p as=1.0p pd=5.0u ps=5.0u nrd=0 nrs=0 sa=0 sb=0 sd=0 m=56
XMN2s5 net9 vbn net10 VSS nfet_03v3 L=1.0u W=2.0u nf=1 ad=1.0p as=1.0p pd=5.0u ps=5.0u nrd=0 nrs=0 sa=0 sb=0 sd=0 m=56
XMN2s6 net10 vbn net11 VSS nfet_03v3 L=1.0u W=2.0u nf=1 ad=1.0p as=1.0p pd=5.0u ps=5.0u nrd=0 nrs=0 sa=0 sb=0 sd=0 m=56
XMN2s7 net11 vbn net12 VSS nfet_03v3 L=1.0u W=2.0u nf=1 ad=1.0p as=1.0p pd=5.0u ps=5.0u nrd=0 nrs=0 sa=0 sb=0 sd=0 m=56
XMN2s8 net12 vbn net13 VSS nfet_03v3 L=1.0u W=2.0u nf=1 ad=1.0p as=1.0p pd=5.0u ps=5.0u nrd=0 nrs=0 sa=0 sb=0 sd=0 m=56
XMN2s9 net13 vbn net14 VSS nfet_03v3 L=1.0u W=2.0u nf=1 ad=1.0p as=1.0p pd=5.0u ps=5.0u nrd=0 nrs=0 sa=0 sb=0 sd=0 m=56
XMN2s10 net14 vbn net15 VSS nfet_03v3 L=1.0u W=2.0u nf=1 ad=1.0p as=1.0p pd=5.0u ps=5.0u nrd=0 nrs=0 sa=0 sb=0 sd=0 m=56
XMN2s11 net15 vbn net16 VSS nfet_03v3 L=1.0u W=2.0u nf=1 ad=1.0p as=1.0p pd=5.0u ps=5.0u nrd=0 nrs=0 sa=0 sb=0 sd=0 m=56
XMN2s12 net16 vbn net17 VSS nfet_03v3 L=1.0u W=2.0u nf=1 ad=1.0p as=1.0p pd=5.0u ps=5.0u nrd=0 nrs=0 sa=0 sb=0 sd=0 m=56
XMN2s13 net17 vbn net3 VSS nfet_03v3 L=1.0u W=2.0u nf=1 ad=1.0p as=1.0p pd=5.0u ps=5.0u nrd=0 nrs=0 sa=0 sb=0 sd=0 m=56
XMN1 vbn vbn net18 VSS nfet_03v3 L=1.0u W=2.0u nf=1 ad=1.0p as=1.0p pd=5.0u ps=5.0u nrd=0 nrs=0 sa=0 sb=0 sd=0 m=14
XMN1s1 net18 vbn net19 VSS nfet_03v3 L=1.0u W=2.0u nf=1 ad=1.0p as=1.0p pd=5.0u ps=5.0u nrd=0 nrs=0 sa=0 sb=0 sd=0 m=14
XMN1s2 net19 vbn net20 VSS nfet_03v3 L=1.0u W=2.0u nf=1 ad=1.0p as=1.0p pd=5.0u ps=5.0u nrd=0 nrs=0 sa=0 sb=0 sd=0 m=14
XMN1s3 net20 vbn net21 VSS nfet_03v3 L=1.0u W=2.0u nf=1 ad=1.0p as=1.0p pd=5.0u ps=5.0u nrd=0 nrs=0 sa=0 sb=0 sd=0 m=14
XMN1s4 net21 vbn net22 VSS nfet_03v3 L=1.0u W=2.0u nf=1 ad=1.0p as=1.0p pd=5.0u ps=5.0u nrd=0 nrs=0 sa=0 sb=0 sd=0 m=14
XMN1s5 net22 vbn net23 VSS nfet_03v3 L=1.0u W=2.0u nf=1 ad=1.0p as=1.0p pd=5.0u ps=5.0u nrd=0 nrs=0 sa=0 sb=0 sd=0 m=14
XMN1s6 net23 vbn net24 VSS nfet_03v3 L=1.0u W=2.0u nf=1 ad=1.0p as=1.0p pd=5.0u ps=5.0u nrd=0 nrs=0 sa=0 sb=0 sd=0 m=14
XMN1s7 net24 vbn net25 VSS nfet_03v3 L=1.0u W=2.0u nf=1 ad=1.0p as=1.0p pd=5.0u ps=5.0u nrd=0 nrs=0 sa=0 sb=0 sd=0 m=14
XMN1s8 net25 vbn net26 VSS nfet_03v3 L=1.0u W=2.0u nf=1 ad=1.0p as=1.0p pd=5.0u ps=5.0u nrd=0 nrs=0 sa=0 sb=0 sd=0 m=14
XMN1s9 net26 vbn net27 VSS nfet_03v3 L=1.0u W=2.0u nf=1 ad=1.0p as=1.0p pd=5.0u ps=5.0u nrd=0 nrs=0 sa=0 sb=0 sd=0 m=14
XMN1s10 net27 vbn net28 VSS nfet_03v3 L=1.0u W=2.0u nf=1 ad=1.0p as=1.0p pd=5.0u ps=5.0u nrd=0 nrs=0 sa=0 sb=0 sd=0 m=14
XMN1s11 net28 vbn net29 VSS nfet_03v3 L=1.0u W=2.0u nf=1 ad=1.0p as=1.0p pd=5.0u ps=5.0u nrd=0 nrs=0 sa=0 sb=0 sd=0 m=14
XMN1s12 net29 vbn net30 VSS nfet_03v3 L=1.0u W=2.0u nf=1 ad=1.0p as=1.0p pd=5.0u ps=5.0u nrd=0 nrs=0 sa=0 sb=0 sd=0 m=14
XMN1s13 net30 vbn VSS VSS nfet_03v3 L=1.0u W=2.0u nf=1 ad=1.0p as=1.0p pd=5.0u ps=5.0u nrd=0 nrs=0 sa=0 sb=0 sd=0 m=14
XMS1 net2 VSS VDD VDD pfet_03v3 L=10.0u W=0.5u nf=1 ad=0.25p as=0.25p pd=2.0u ps=2.0u nrd=0 nrs=0 sa=0 sb=0 sd=0
XMS2 net2 vbn VSS VSS nfet_03v3 L=0.28u W=2.0u nf=1 ad=1.0p as=1.0p pd=5.0u ps=5.0u nrd=0 nrs=0 sa=0 sb=0 sd=0
XMS3 net1 net2 vbn VSS nfet_03v3 L=0.28u W=1.0u nf=1 ad=0.5p as=0.5p pd=3.0u ps=3.0u nrd=0 nrs=0 sa=0 sb=0 sd=0
XRBW net3 net4 VSS nwell r_width=2.0e-6 r_length=5.025e-6
XRBN net4 VSS VSS nplus_u r_width=2.0e-6 r_length=100.0e-6
XRF vbn vbnf VSS ppolyf_u_1k r_width=1.0e-6 r_length=970.2289999999999e-6
XCF VSS vbnf VSS VSS nfet_03v3 L=10.0u W=49.14u nf=1 ad=24.57p as=24.57p pd=99.28u ps=99.28u nrd=0 nrs=0 sa=0 sb=0 sd=0 m=10
.ends

* expanding   symbol:  lsdiv.sym # of pins=5
.subckt lsdiv VDD VSS a0 ck ls
*.iopin VDD
*.iopin VSS
*.ipin a0
*.opin ck
*.opin ls
xls VDD VSS a0 ls ls_ac
xd1 VDD VSS ls net1 tspc_t1
xd2 VDD VSS net1 net2 tspc_t2
XB1p ck net2 VDD VDD pfet_03v3 L=0.28u W=2.5u nf=1 ad=1.25p as=1.25p pd=6.0u ps=6.0u nrd=0 nrs=0 sa=0 sb=0 sd=0
XB1n ck net2 VSS VSS nfet_03v3 L=0.28u W=1.0u nf=1 ad=0.5p as=0.5p pd=3.0u ps=3.0u nrd=0 nrs=0 sa=0 sb=0 sd=0
.ends

* expanding   symbol:  cfed_dac.sym # of pins=15
.subckt cfed_dac vg vbnf vctrl bit0 bit1 bit2 bit3 bit4 bitb0 bitb1 bitb2 bitb3 bitb4 VDD VSS
*.iopin vg
*.ipin vbnf
*.ipin vctrl
*.ipin bit0
*.ipin bit1
*.ipin bit2
*.ipin bit3
*.ipin bit4
*.ipin bitb0
*.ipin bitb1
*.ipin bitb2
*.ipin bitb3
*.ipin bitb4
*.iopin VDD
*.iopin VSS
XFFC vg vctrl VSS VSS nfet_03v3 L=21.333333333333332u W=1.2u nf=1 ad=0.6p as=0.6p pd=3.4u ps=3.4u nrd=0 nrs=0 sa=0 sb=0 sd=0
XFC vg vbnf VSS VSS nfet_03v3 L=5.333333333333333u W=1.2u nf=1 ad=0.6p as=0.6p pd=3.4u ps=3.4u nrd=0 nrs=0 sa=0 sb=0 sd=0 m=6
XFC_0 vg net1 VSS VSS nfet_03v3 L=5.333333333333333u W=1.2u nf=1 ad=0.6p as=0.6p pd=3.4u ps=3.4u nrd=0 nrs=0 sa=0 sb=0 sd=0
XFC_1 vg net2 VSS VSS nfet_03v3 L=5.333333333333333u W=1.2u nf=1 ad=0.6p as=0.6p pd=3.4u ps=3.4u nrd=0 nrs=0 sa=0 sb=0 sd=0 m=2
XFC_2 vg net3 VSS VSS nfet_03v3 L=5.333333333333333u W=1.2u nf=1 ad=0.6p as=0.6p pd=3.4u ps=3.4u nrd=0 nrs=0 sa=0 sb=0 sd=0 m=4
XFC_3 vg net4 VSS VSS nfet_03v3 L=5.333333333333333u W=1.2u nf=1 ad=0.6p as=0.6p pd=3.4u ps=3.4u nrd=0 nrs=0 sa=0 sb=0 sd=0 m=8
XFC_4 vg net5 VSS VSS nfet_03v3 L=5.333333333333333u W=1.2u nf=1 ad=0.6p as=0.6p pd=3.4u ps=3.4u nrd=0 nrs=0 sa=0 sb=0 sd=0 m=16
XTP0 net1 bitb0 vbnf VDD pfet_03v3 L=0.28u W=5.0u nf=1 ad=2.5p as=2.5p pd=11.0u ps=11.0u nrd=0 nrs=0 sa=0 sb=0 sd=0
XTN0 net1 bit0 vbnf VSS nfet_03v3 L=0.28u W=2.0u nf=1 ad=1.0p as=1.0p pd=5.0u ps=5.0u nrd=0 nrs=0 sa=0 sb=0 sd=0
XTD0 net1 bitb0 VSS VSS nfet_03v3 L=0.28u W=1.0u nf=1 ad=0.5p as=0.5p pd=3.0u ps=3.0u nrd=0 nrs=0 sa=0 sb=0 sd=0
XTP1 net2 bitb1 vbnf VDD pfet_03v3 L=0.28u W=5.0u nf=1 ad=2.5p as=2.5p pd=11.0u ps=11.0u nrd=0 nrs=0 sa=0 sb=0 sd=0
XTN1 net2 bit1 vbnf VSS nfet_03v3 L=0.28u W=2.0u nf=1 ad=1.0p as=1.0p pd=5.0u ps=5.0u nrd=0 nrs=0 sa=0 sb=0 sd=0
XTD1 net2 bitb1 VSS VSS nfet_03v3 L=0.28u W=1.0u nf=1 ad=0.5p as=0.5p pd=3.0u ps=3.0u nrd=0 nrs=0 sa=0 sb=0 sd=0
XTP2 net3 bitb2 vbnf VDD pfet_03v3 L=0.28u W=5.0u nf=1 ad=2.5p as=2.5p pd=11.0u ps=11.0u nrd=0 nrs=0 sa=0 sb=0 sd=0
XTN2 net3 bit2 vbnf VSS nfet_03v3 L=0.28u W=2.0u nf=1 ad=1.0p as=1.0p pd=5.0u ps=5.0u nrd=0 nrs=0 sa=0 sb=0 sd=0
XTD2 net3 bitb2 VSS VSS nfet_03v3 L=0.28u W=1.0u nf=1 ad=0.5p as=0.5p pd=3.0u ps=3.0u nrd=0 nrs=0 sa=0 sb=0 sd=0
XTP3 net4 bitb3 vbnf VDD pfet_03v3 L=0.28u W=5.0u nf=1 ad=2.5p as=2.5p pd=11.0u ps=11.0u nrd=0 nrs=0 sa=0 sb=0 sd=0
XTN3 net4 bit3 vbnf VSS nfet_03v3 L=0.28u W=2.0u nf=1 ad=1.0p as=1.0p pd=5.0u ps=5.0u nrd=0 nrs=0 sa=0 sb=0 sd=0
XTD3 net4 bitb3 VSS VSS nfet_03v3 L=0.28u W=1.0u nf=1 ad=0.5p as=0.5p pd=3.0u ps=3.0u nrd=0 nrs=0 sa=0 sb=0 sd=0
XTP4 net5 bitb4 vbnf VDD pfet_03v3 L=0.28u W=5.0u nf=1 ad=2.5p as=2.5p pd=11.0u ps=11.0u nrd=0 nrs=0 sa=0 sb=0 sd=0
XTN4 net5 bit4 vbnf VSS nfet_03v3 L=0.28u W=2.0u nf=1 ad=1.0p as=1.0p pd=5.0u ps=5.0u nrd=0 nrs=0 sa=0 sb=0 sd=0
XTD4 net5 bitb4 VSS VSS nfet_03v3 L=0.28u W=1.0u nf=1 ad=0.5p as=0.5p pd=3.0u ps=3.0u nrd=0 nrs=0 sa=0 sb=0 sd=0
.ends

* expanding   symbol:  cfed_ring.sym # of pins=8
.subckt cfed_ring VDD vg VSS a0 a1 a2 a3 a4
*.iopin VDD
*.iopin vg
*.iopin VSS
*.opin a0
*.opin a1
*.opin a2
*.opin a3
*.opin a4
XP0 a1 a0 VDD VDD pfet_03v3 L=0.28u W=5.0u nf=1 ad=2.5p as=2.5p pd=11.0u ps=11.0u nrd=0 nrs=0 sa=0 sb=0 sd=0
XN0 a1 a0 vg VSS nfet_03v3 L=0.28u W=2.0u nf=1 ad=1.0p as=1.0p pd=5.0u ps=5.0u nrd=0 nrs=0 sa=0 sb=0 sd=0
XP1 a2 a1 VDD VDD pfet_03v3 L=0.28u W=5.0u nf=1 ad=2.5p as=2.5p pd=11.0u ps=11.0u nrd=0 nrs=0 sa=0 sb=0 sd=0
XN1 a2 a1 vg VSS nfet_03v3 L=0.28u W=2.0u nf=1 ad=1.0p as=1.0p pd=5.0u ps=5.0u nrd=0 nrs=0 sa=0 sb=0 sd=0
XP2 a3 a2 VDD VDD pfet_03v3 L=0.28u W=5.0u nf=1 ad=2.5p as=2.5p pd=11.0u ps=11.0u nrd=0 nrs=0 sa=0 sb=0 sd=0
XN2 a3 a2 vg VSS nfet_03v3 L=0.28u W=2.0u nf=1 ad=1.0p as=1.0p pd=5.0u ps=5.0u nrd=0 nrs=0 sa=0 sb=0 sd=0
XP3 a4 a3 VDD VDD pfet_03v3 L=0.28u W=5.0u nf=1 ad=2.5p as=2.5p pd=11.0u ps=11.0u nrd=0 nrs=0 sa=0 sb=0 sd=0
XN3 a4 a3 vg VSS nfet_03v3 L=0.28u W=2.0u nf=1 ad=1.0p as=1.0p pd=5.0u ps=5.0u nrd=0 nrs=0 sa=0 sb=0 sd=0
XP4 a0 a4 VDD VDD pfet_03v3 L=0.28u W=5.0u nf=1 ad=2.5p as=2.5p pd=11.0u ps=11.0u nrd=0 nrs=0 sa=0 sb=0 sd=0
XN4 a0 a4 vg VSS nfet_03v3 L=0.28u W=2.0u nf=1 ad=1.0p as=1.0p pd=5.0u ps=5.0u nrd=0 nrs=0 sa=0 sb=0 sd=0
.ends

* expanding   symbol:  ls_ac.sym # of pins=4
.subckt ls_ac VDD VSS a0 ls
*.iopin VDD
*.iopin VSS
*.ipin a0
*.opin ls
XL1p net2 net1 VDD VDD pfet_03v3 L=0.28u W=0.5u nf=1 ad=0.25p as=0.25p pd=2.0u ps=2.0u nrd=0 nrs=0 sa=0 sb=0 sd=0
XL1n net2 net1 VSS VSS nfet_03v3 L=0.28u W=0.21999999999999997u nf=1 ad=0.10999999999999999p as=0.10999999999999999p pd=1.44u
+ ps=1.44u nrd=0 nrs=0 sa=0 sb=0 sd=0
XL2p net3 net2 VDD VDD pfet_03v3 L=0.28u W=1.5u nf=1 ad=0.75p as=0.75p pd=4.0u ps=4.0u nrd=0 nrs=0 sa=0 sb=0 sd=0
XL2n net3 net2 VSS VSS nfet_03v3 L=0.28u W=0.6u nf=1 ad=0.3p as=0.3p pd=2.2u ps=2.2u nrd=0 nrs=0 sa=0 sb=0 sd=0
XL3p ls net3 VDD VDD pfet_03v3 L=0.28u W=3.0u nf=1 ad=1.5p as=1.5p pd=7.0u ps=7.0u nrd=0 nrs=0 sa=0 sb=0 sd=0
XL3n ls net3 VSS VSS nfet_03v3 L=0.28u W=1.2u nf=1 ad=0.6p as=0.6p pd=3.4u ps=3.4u nrd=0 nrs=0 sa=0 sb=0 sd=0
XLRB net1 VSS net4 VDD pfet_03v3 L=2.0u W=0.21999999999999997u nf=1 ad=0.10999999999999999p as=0.10999999999999999p pd=1.44u
+ ps=1.44u nrd=0 nrs=0 sa=0 sb=0 sd=0
XR1 ls net4 VSS ppolyf_u_1k r_width=1.0e-6 r_length=159.125e-6
XC1 VSS net4 VSS VSS nfet_03v3 L=16.0u W=16.0u nf=1 ad=8.0p as=8.0p pd=33.0u ps=33.0u nrd=0 nrs=0 sa=0 sb=0 sd=0
.ends

* expanding   symbol:  tspc_t1.sym # of pins=4
.subckt tspc_t1 VDD VSS clk q
*.iopin VDD
*.iopin VSS
*.ipin clk
*.opin q
Xp1 net1 net6 VDD VDD pfet_03v3 L=0.28u W=2.0u nf=1 ad=1.0p as=1.0p pd=5.0u ps=5.0u nrd=0 nrs=0 sa=0 sb=0 sd=0
Xp2 net4 clk net1 VDD pfet_03v3 L=0.28u W=2.0u nf=1 ad=1.0p as=1.0p pd=5.0u ps=5.0u nrd=0 nrs=0 sa=0 sb=0 sd=0
Xn1 net4 net6 VSS VSS nfet_03v3 L=0.28u W=1.0u nf=1 ad=0.5p as=0.5p pd=3.0u ps=3.0u nrd=0 nrs=0 sa=0 sb=0 sd=0
Xp3 net5 clk VDD VDD pfet_03v3 L=0.28u W=2.0u nf=1 ad=1.0p as=1.0p pd=5.0u ps=5.0u nrd=0 nrs=0 sa=0 sb=0 sd=0
Xn2 net5 net4 net2 VSS nfet_03v3 L=0.28u W=1.0u nf=1 ad=0.5p as=0.5p pd=3.0u ps=3.0u nrd=0 nrs=0 sa=0 sb=0 sd=0
Xn3 net2 clk VSS VSS nfet_03v3 L=0.28u W=1.0u nf=1 ad=0.5p as=0.5p pd=3.0u ps=3.0u nrd=0 nrs=0 sa=0 sb=0 sd=0
Xp4 net6 net5 VDD VDD pfet_03v3 L=0.28u W=2.0u nf=1 ad=1.0p as=1.0p pd=5.0u ps=5.0u nrd=0 nrs=0 sa=0 sb=0 sd=0
Xn4 net6 clk net3 VSS nfet_03v3 L=0.28u W=1.0u nf=1 ad=0.5p as=0.5p pd=3.0u ps=3.0u nrd=0 nrs=0 sa=0 sb=0 sd=0
Xn5 net3 net5 VSS VSS nfet_03v3 L=0.28u W=1.0u nf=1 ad=0.5p as=0.5p pd=3.0u ps=3.0u nrd=0 nrs=0 sa=0 sb=0 sd=0
Xqp q net6 VDD VDD pfet_03v3 L=0.28u W=1.5u nf=1 ad=0.75p as=0.75p pd=4.0u ps=4.0u nrd=0 nrs=0 sa=0 sb=0 sd=0
Xqn q net6 VSS VSS nfet_03v3 L=0.28u W=0.6u nf=1 ad=0.3p as=0.3p pd=2.2u ps=2.2u nrd=0 nrs=0 sa=0 sb=0 sd=0
.ends

* expanding   symbol:  tspc_t2.sym # of pins=4
.subckt tspc_t2 VDD VSS clk q
*.iopin VDD
*.iopin VSS
*.ipin clk
*.opin q
Xp1 net1 net6 VDD VDD pfet_03v3 L=0.28u W=1.2u nf=1 ad=0.6p as=0.6p pd=3.4u ps=3.4u nrd=0 nrs=0 sa=0 sb=0 sd=0
Xp2 net4 clk net1 VDD pfet_03v3 L=0.28u W=1.2u nf=1 ad=0.6p as=0.6p pd=3.4u ps=3.4u nrd=0 nrs=0 sa=0 sb=0 sd=0
Xn1 net4 net6 VSS VSS nfet_03v3 L=0.28u W=0.6u nf=1 ad=0.3p as=0.3p pd=2.2u ps=2.2u nrd=0 nrs=0 sa=0 sb=0 sd=0
Xp3 net5 clk VDD VDD pfet_03v3 L=0.28u W=1.2u nf=1 ad=0.6p as=0.6p pd=3.4u ps=3.4u nrd=0 nrs=0 sa=0 sb=0 sd=0
Xn2 net5 net4 net2 VSS nfet_03v3 L=0.28u W=0.6u nf=1 ad=0.3p as=0.3p pd=2.2u ps=2.2u nrd=0 nrs=0 sa=0 sb=0 sd=0
Xn3 net2 clk VSS VSS nfet_03v3 L=0.28u W=0.6u nf=1 ad=0.3p as=0.3p pd=2.2u ps=2.2u nrd=0 nrs=0 sa=0 sb=0 sd=0
Xp4 net6 net5 VDD VDD pfet_03v3 L=0.28u W=1.2u nf=1 ad=0.6p as=0.6p pd=3.4u ps=3.4u nrd=0 nrs=0 sa=0 sb=0 sd=0
Xn4 net6 clk net3 VSS nfet_03v3 L=0.28u W=0.6u nf=1 ad=0.3p as=0.3p pd=2.2u ps=2.2u nrd=0 nrs=0 sa=0 sb=0 sd=0
Xn5 net3 net5 VSS VSS nfet_03v3 L=0.28u W=0.6u nf=1 ad=0.3p as=0.3p pd=2.2u ps=2.2u nrd=0 nrs=0 sa=0 sb=0 sd=0
Xqp q net6 VDD VDD pfet_03v3 L=0.28u W=1.5u nf=1 ad=0.75p as=0.75p pd=4.0u ps=4.0u nrd=0 nrs=0 sa=0 sb=0 sd=0
Xqn q net6 VSS VSS nfet_03v3 L=0.28u W=0.6u nf=1 ad=0.3p as=0.3p pd=2.2u ps=2.2u nrd=0 nrs=0 sa=0 sb=0 sd=0
.ends

.subckt tx_drv VDD VSS ls en_p en_n out_p out_n
*.iopin VDD
*.iopin VSS
*.ipin ls
*.ipin en_p
*.ipin en_n
*.opin out_p
*.opin out_n
xsp VDD VSS ls net1 net2 tx_split
xap VDD VSS net1 en_p out_p tx_arm
xan VDD VSS net2 en_n out_n tx_arm
XDC VSS VDD VSS VSS nfet_03v3 L=10.0u W=10.0u nf=1 ad=5.0p as=5.0p pd=21.0u ps=21.0u nrd=0 nrs=0 sa=0 sb=0 sd=0 m=24
.ends

* expanding   symbol:  tx_split.sym # of pins=5
.subckt tx_split VDD VSS ls a b
*.iopin VDD
*.iopin VSS
*.ipin ls
*.opin a
*.opin b
XTp net1 ls VDD VDD pfet_03v3 L=0.28u W=1.0499999999999998u nf=1 ad=0.5249999999999999p as=0.5249999999999999p
+ pd=3.0999999999999996u ps=3.0999999999999996u nrd=0 nrs=0 sa=0 sb=0 sd=0
XTn net1 ls VSS VSS nfet_03v3 L=0.28u W=0.41999999999999993u nf=1 ad=0.20999999999999996p as=0.20999999999999996p
+ pd=1.8399999999999999u ps=1.8399999999999999u nrd=0 nrs=0 sa=0 sb=0 sd=0
XA1p net2 net1 VDD VDD pfet_03v3 L=0.28u W=1.25u nf=1 ad=0.625p as=0.625p pd=3.5u ps=3.5u nrd=0 nrs=0 sa=0 sb=0 sd=0
XA1n net2 net1 VSS VSS nfet_03v3 L=0.28u W=0.5u nf=1 ad=0.25p as=0.25p pd=2.0u ps=2.0u nrd=0 nrs=0 sa=0 sb=0 sd=0
XA2p a net2 VDD VDD pfet_03v3 L=0.28u W=2.5u nf=1 ad=1.25p as=1.25p pd=6.0u ps=6.0u nrd=0 nrs=0 sa=0 sb=0 sd=0
XA2n a net2 VSS VSS nfet_03v3 L=0.28u W=1.0u nf=1 ad=0.5p as=0.5p pd=3.0u ps=3.0u nrd=0 nrs=0 sa=0 sb=0 sd=0
XB1p net3 net1 VDD VDD pfet_03v3 L=0.28u W=3.7499999999999996u nf=1 ad=1.8749999999999998p as=1.8749999999999998p pd=8.5u ps=8.5u
+ nrd=0 nrs=0 sa=0 sb=0 sd=0
XB1n net3 net1 VSS VSS nfet_03v3 L=0.28u W=1.5u nf=1 ad=0.75p as=0.75p pd=4.0u ps=4.0u nrd=0 nrs=0 sa=0 sb=0 sd=0
XTGp b VSS net3 VDD pfet_03v3 L=0.28u W=2.5u nf=1 ad=1.25p as=1.25p pd=6.0u ps=6.0u nrd=0 nrs=0 sa=0 sb=0 sd=0
XTGn b VDD net3 VSS nfet_03v3 L=0.28u W=1.0u nf=1 ad=0.5p as=0.5p pd=3.0u ps=3.0u nrd=0 nrs=0 sa=0 sb=0 sd=0
XXBp b a VDD VDD pfet_03v3 L=0.28u W=1.0499999999999998u nf=1 ad=0.5249999999999999p as=0.5249999999999999p pd=3.0999999999999996u
+ ps=3.0999999999999996u nrd=0 nrs=0 sa=0 sb=0 sd=0
XXBn b a VSS VSS nfet_03v3 L=0.28u W=0.41999999999999993u nf=1 ad=0.20999999999999996p as=0.20999999999999996p
+ pd=1.8399999999999999u ps=1.8399999999999999u nrd=0 nrs=0 sa=0 sb=0 sd=0
XXAp a b VDD VDD pfet_03v3 L=0.28u W=1.0499999999999998u nf=1 ad=0.5249999999999999p as=0.5249999999999999p pd=3.0999999999999996u
+ ps=3.0999999999999996u nrd=0 nrs=0 sa=0 sb=0 sd=0
XXAn a b VSS VSS nfet_03v3 L=0.28u W=0.41999999999999993u nf=1 ad=0.20999999999999996p as=0.20999999999999996p
+ pd=1.8399999999999999u ps=1.8399999999999999u nrd=0 nrs=0 sa=0 sb=0 sd=0
.ends

* expanding   symbol:  tx_arm.sym # of pins=5
.subckt tx_arm VDD VSS in en out
*.iopin VDD
*.iopin VSS
*.ipin in
*.ipin en
*.opin out
XNAp net1 in VDD VDD pfet_03v3 L=0.28u W=1.25u nf=1 ad=0.625p as=0.625p pd=3.5u ps=3.5u nrd=0 nrs=0 sa=0 sb=0 sd=0
XNBp net1 en VDD VDD pfet_03v3 L=0.28u W=1.25u nf=1 ad=0.625p as=0.625p pd=3.5u ps=3.5u nrd=0 nrs=0 sa=0 sb=0 sd=0
XNAn net1 in net2 VSS nfet_03v3 L=0.28u W=1.0u nf=1 ad=0.5p as=0.5p pd=3.0u ps=3.0u nrd=0 nrs=0 sa=0 sb=0 sd=0
XNBn net2 en VSS VSS nfet_03v3 L=0.28u W=1.0u nf=1 ad=0.5p as=0.5p pd=3.0u ps=3.0u nrd=0 nrs=0 sa=0 sb=0 sd=0
XM1p net3 net1 VDD VDD pfet_03v3 L=0.28u W=1.0499999999999998u nf=1 ad=0.5249999999999999p as=0.5249999999999999p
+ pd=3.0999999999999996u ps=3.0999999999999996u nrd=0 nrs=0 sa=0 sb=0 sd=0
XM1n net3 net1 VSS VSS nfet_03v3 L=0.28u W=0.41999999999999993u nf=1 ad=0.20999999999999996p as=0.20999999999999996p
+ pd=1.8399999999999999u ps=1.8399999999999999u nrd=0 nrs=0 sa=0 sb=0 sd=0
XM2p net4 net3 VDD VDD pfet_03v3 L=0.28u W=1.5624999999999998u nf=1 ad=0.7812499999999999p as=0.7812499999999999p pd=4.125u
+ ps=4.125u nrd=0 nrs=0 sa=0 sb=0 sd=0
XM2n net4 net3 VSS VSS nfet_03v3 L=0.28u W=0.625u nf=1 ad=0.3125p as=0.3125p pd=2.25u ps=2.25u nrd=0 nrs=0 sa=0 sb=0 sd=0
XM3p net5 net4 VDD VDD pfet_03v3 L=0.28u W=6.249999999999999u nf=1 ad=3.1249999999999996p as=3.1249999999999996p
+ pd=13.499999999999998u ps=13.499999999999998u nrd=0 nrs=0 sa=0 sb=0 sd=0
XM3n net5 net4 VSS VSS nfet_03v3 L=0.28u W=2.5u nf=1 ad=1.25p as=1.25p pd=6.0u ps=6.0u nrd=0 nrs=0 sa=0 sb=0 sd=0
XM4p net6 net5 VDD VDD pfet_03v3 L=0.28u W=12.499999999999998u nf=1 ad=6.249999999999999p as=6.249999999999999p
+ pd=25.999999999999996u ps=25.999999999999996u nrd=0 nrs=0 sa=0 sb=0 sd=0 m=2
XM4n net6 net5 VSS VSS nfet_03v3 L=0.28u W=5.0u nf=1 ad=2.5p as=2.5p pd=11.0u ps=11.0u nrd=0 nrs=0 sa=0 sb=0 sd=0 m=2
XM5p out net6 VDD VDD pfet_03v3 L=0.28u W=20.0u nf=1 ad=10.0p as=10.0p pd=41.0u ps=41.0u nrd=0 nrs=0 sa=0 sb=0 sd=0 m=5
XM5n out net6 VSS VSS nfet_03v3 L=0.28u W=8.0u nf=1 ad=4.0p as=4.0p pd=17.0u ps=17.0u nrd=0 nrs=0 sa=0 sb=0 sd=0 m=5
.ends

.subckt tx_fine ck ck_o clk cs_n dac_sdn div1024 div16 div64 fsk miso mosi rst_n sclk VDD VSS dac_bn[4] dac_bn[3] dac_bn[2] dac_bn[1] dac_bn[0] dac_tn[30] dac_tn[29] dac_tn[28] dac_tn[27] dac_tn[26] dac_tn[25] dac_tn[24] dac_tn[23] dac_tn[22] dac_tn[21] dac_tn[20] dac_tn[19] dac_tn[18] dac_tn[17] dac_tn[16] dac_tn[15] dac_tn[14] dac_tn[13] dac_tn[12] dac_tn[11] dac_tn[10] dac_tn[9] dac_tn[8] dac_tn[7] dac_tn[6] dac_tn[5] dac_tn[4] dac_tn[3] dac_tn[2] dac_tn[1] dac_tn[0]
XANTENNA_clkbuf_0_ck_I ck VDD VDD VSS VSS gf180mcu_fd_sc_mcu7t5v0__antenna
XANTENNA_clkbuf_0_clk_I clk VDD VDD VSS VSS gf180mcu_fd_sc_mcu7t5v0__antenna
XANTENNA_clkbuf_regs_1_ck_I ck VDD VDD VSS VSS gf180mcu_fd_sc_mcu7t5v0__antenna
XANTENNA_delaybuf_1_clk_I clk VDD VDD VSS VSS gf180mcu_fd_sc_mcu7t5v0__antenna
XANTENNA_hold92_I fsk VDD VDD VSS VSS gf180mcu_fd_sc_mcu7t5v0__antenna
XANTENNA_hold93_I sclk VDD VDD VSS VSS gf180mcu_fd_sc_mcu7t5v0__antenna
XANTENNA_hold94_I mosi VDD VDD VSS VSS gf180mcu_fd_sc_mcu7t5v0__antenna
XANTENNA_input1_I cs_n VDD VDD VSS VSS gf180mcu_fd_sc_mcu7t5v0__antenna
XANTENNA_input4_I rst_n VDD VDD VSS VSS gf180mcu_fd_sc_mcu7t5v0__antenna
XFILLER_0_104 VDD VDD VSS VSS gf180mcu_fd_sc_mcu7t5v0__fill_2
XFILLER_0_114 VDD VDD VSS VSS gf180mcu_fd_sc_mcu7t5v0__fillcap_16
XFILLER_0_130 VDD VDD VSS VSS gf180mcu_fd_sc_mcu7t5v0__fillcap_4
XFILLER_0_134 VDD VDD VSS VSS gf180mcu_fd_sc_mcu7t5v0__fill_2
XFILLER_0_138 VDD VDD VSS VSS gf180mcu_fd_sc_mcu7t5v0__fillcap_32
XFILLER_0_172 VDD VDD VSS VSS gf180mcu_fd_sc_mcu7t5v0__fillcap_4
XFILLER_0_192 VDD VDD VSS VSS gf180mcu_fd_sc_mcu7t5v0__fillcap_4
XFILLER_0_196 VDD VDD VSS VSS gf180mcu_fd_sc_mcu7t5v0__fill_1
XFILLER_0_2 VDD VDD VSS VSS gf180mcu_fd_sc_mcu7t5v0__fillcap_32
XFILLER_0_202 VDD VDD VSS VSS gf180mcu_fd_sc_mcu7t5v0__fill_2
XFILLER_0_206 VDD VDD VSS VSS gf180mcu_fd_sc_mcu7t5v0__fillcap_8
XFILLER_0_214 VDD VDD VSS VSS gf180mcu_fd_sc_mcu7t5v0__fillcap_4
XFILLER_0_223 VDD VDD VSS VSS gf180mcu_fd_sc_mcu7t5v0__fillcap_8
XFILLER_0_231 VDD VDD VSS VSS gf180mcu_fd_sc_mcu7t5v0__fillcap_4
XFILLER_0_235 VDD VDD VSS VSS gf180mcu_fd_sc_mcu7t5v0__fill_2
XFILLER_0_237 VDD VDD VSS VSS gf180mcu_fd_sc_mcu7t5v0__fill_1
XFILLER_0_240 VDD VDD VSS VSS gf180mcu_fd_sc_mcu7t5v0__fillcap_16
XFILLER_0_256 VDD VDD VSS VSS gf180mcu_fd_sc_mcu7t5v0__fillcap_4
XFILLER_0_274 VDD VDD VSS VSS gf180mcu_fd_sc_mcu7t5v0__fill_2
XFILLER_0_276 VDD VDD VSS VSS gf180mcu_fd_sc_mcu7t5v0__fill_1
XFILLER_0_36 VDD VDD VSS VSS gf180mcu_fd_sc_mcu7t5v0__fill_2
XFILLER_0_54 VDD VDD VSS VSS gf180mcu_fd_sc_mcu7t5v0__fillcap_8
XFILLER_0_62 VDD VDD VSS VSS gf180mcu_fd_sc_mcu7t5v0__fill_2
XFILLER_0_70 VDD VDD VSS VSS gf180mcu_fd_sc_mcu7t5v0__fillcap_8
XFILLER_0_78 VDD VDD VSS VSS gf180mcu_fd_sc_mcu7t5v0__fillcap_4
XFILLER_0_90 VDD VDD VSS VSS gf180mcu_fd_sc_mcu7t5v0__fillcap_8
XFILLER_0_98 VDD VDD VSS VSS gf180mcu_fd_sc_mcu7t5v0__fillcap_4
XFILLER_10_113 VDD VDD VSS VSS gf180mcu_fd_sc_mcu7t5v0__fill_1
XFILLER_10_138 VDD VDD VSS VSS gf180mcu_fd_sc_mcu7t5v0__fill_1
XFILLER_10_173 VDD VDD VSS VSS gf180mcu_fd_sc_mcu7t5v0__fill_2
XFILLER_10_2 VDD VDD VSS VSS gf180mcu_fd_sc_mcu7t5v0__fill_2
XFILLER_10_247 VDD VDD VSS VSS gf180mcu_fd_sc_mcu7t5v0__fillcap_16
XFILLER_10_263 VDD VDD VSS VSS gf180mcu_fd_sc_mcu7t5v0__fillcap_8
XFILLER_10_37 VDD VDD VSS VSS gf180mcu_fd_sc_mcu7t5v0__fillcap_4
XFILLER_10_4 VDD VDD VSS VSS gf180mcu_fd_sc_mcu7t5v0__fill_1
XFILLER_10_41 VDD VDD VSS VSS gf180mcu_fd_sc_mcu7t5v0__fill_2
XFILLER_10_43 VDD VDD VSS VSS gf180mcu_fd_sc_mcu7t5v0__fill_1
XFILLER_11_101 VDD VDD VSS VSS gf180mcu_fd_sc_mcu7t5v0__fill_2
XFILLER_11_115 VDD VDD VSS VSS gf180mcu_fd_sc_mcu7t5v0__fillcap_8
XFILLER_11_131 VDD VDD VSS VSS gf180mcu_fd_sc_mcu7t5v0__fillcap_8
XFILLER_11_139 VDD VDD VSS VSS gf180mcu_fd_sc_mcu7t5v0__fill_1
XFILLER_11_142 VDD VDD VSS VSS gf180mcu_fd_sc_mcu7t5v0__fill_1
XFILLER_11_177 VDD VDD VSS VSS gf180mcu_fd_sc_mcu7t5v0__fill_2
XFILLER_11_199 VDD VDD VSS VSS gf180mcu_fd_sc_mcu7t5v0__fill_2
XFILLER_11_2 VDD VDD VSS VSS gf180mcu_fd_sc_mcu7t5v0__fillcap_4
XFILLER_11_201 VDD VDD VSS VSS gf180mcu_fd_sc_mcu7t5v0__fill_1
XFILLER_11_212 VDD VDD VSS VSS gf180mcu_fd_sc_mcu7t5v0__fill_1
XFILLER_11_6 VDD VDD VSS VSS gf180mcu_fd_sc_mcu7t5v0__fill_2
XFILLER_11_77 VDD VDD VSS VSS gf180mcu_fd_sc_mcu7t5v0__fill_2
XFILLER_12_10 VDD VDD VSS VSS gf180mcu_fd_sc_mcu7t5v0__fill_2
XFILLER_12_107 VDD VDD VSS VSS gf180mcu_fd_sc_mcu7t5v0__fillcap_8
XFILLER_12_115 VDD VDD VSS VSS gf180mcu_fd_sc_mcu7t5v0__fillcap_4
XFILLER_12_119 VDD VDD VSS VSS gf180mcu_fd_sc_mcu7t5v0__fill_2
XFILLER_12_121 VDD VDD VSS VSS gf180mcu_fd_sc_mcu7t5v0__fill_1
XFILLER_12_130 VDD VDD VSS VSS gf180mcu_fd_sc_mcu7t5v0__fillcap_8
XFILLER_12_138 VDD VDD VSS VSS gf180mcu_fd_sc_mcu7t5v0__fillcap_4
XFILLER_12_142 VDD VDD VSS VSS gf180mcu_fd_sc_mcu7t5v0__fill_2
XFILLER_12_166 VDD VDD VSS VSS gf180mcu_fd_sc_mcu7t5v0__fillcap_8
XFILLER_12_174 VDD VDD VSS VSS gf180mcu_fd_sc_mcu7t5v0__fill_1
XFILLER_12_177 VDD VDD VSS VSS gf180mcu_fd_sc_mcu7t5v0__fillcap_4
XFILLER_12_181 VDD VDD VSS VSS gf180mcu_fd_sc_mcu7t5v0__fill_1
XFILLER_12_190 VDD VDD VSS VSS gf180mcu_fd_sc_mcu7t5v0__fill_2
XFILLER_12_192 VDD VDD VSS VSS gf180mcu_fd_sc_mcu7t5v0__fill_1
XFILLER_12_2 VDD VDD VSS VSS gf180mcu_fd_sc_mcu7t5v0__fillcap_8
XFILLER_12_239 VDD VDD VSS VSS gf180mcu_fd_sc_mcu7t5v0__fillcap_4
XFILLER_12_243 VDD VDD VSS VSS gf180mcu_fd_sc_mcu7t5v0__fill_2
XFILLER_12_247 VDD VDD VSS VSS gf180mcu_fd_sc_mcu7t5v0__fillcap_16
XFILLER_12_263 VDD VDD VSS VSS gf180mcu_fd_sc_mcu7t5v0__fillcap_8
XFILLER_12_27 VDD VDD VSS VSS gf180mcu_fd_sc_mcu7t5v0__fillcap_8
XFILLER_12_83 VDD VDD VSS VSS gf180mcu_fd_sc_mcu7t5v0__fill_2
XFILLER_13_105 VDD VDD VSS VSS gf180mcu_fd_sc_mcu7t5v0__fill_2
XFILLER_13_120 VDD VDD VSS VSS gf180mcu_fd_sc_mcu7t5v0__fillcap_16
XFILLER_13_136 VDD VDD VSS VSS gf180mcu_fd_sc_mcu7t5v0__fillcap_4
XFILLER_13_142 VDD VDD VSS VSS gf180mcu_fd_sc_mcu7t5v0__fillcap_8
XFILLER_13_150 VDD VDD VSS VSS gf180mcu_fd_sc_mcu7t5v0__fill_1
XFILLER_13_161 VDD VDD VSS VSS gf180mcu_fd_sc_mcu7t5v0__fillcap_16
XFILLER_13_177 VDD VDD VSS VSS gf180mcu_fd_sc_mcu7t5v0__fillcap_4
XFILLER_13_181 VDD VDD VSS VSS gf180mcu_fd_sc_mcu7t5v0__fill_1
XFILLER_13_190 VDD VDD VSS VSS gf180mcu_fd_sc_mcu7t5v0__fill_2
XFILLER_13_234 VDD VDD VSS VSS gf180mcu_fd_sc_mcu7t5v0__fillcap_8
XFILLER_13_242 VDD VDD VSS VSS gf180mcu_fd_sc_mcu7t5v0__fill_1
XFILLER_13_46 VDD VDD VSS VSS gf180mcu_fd_sc_mcu7t5v0__fillcap_4
XFILLER_13_50 VDD VDD VSS VSS gf180mcu_fd_sc_mcu7t5v0__fill_1
XFILLER_13_64 VDD VDD VSS VSS gf180mcu_fd_sc_mcu7t5v0__fill_1
XFILLER_13_86 VDD VDD VSS VSS gf180mcu_fd_sc_mcu7t5v0__fillcap_4
XFILLER_13_90 VDD VDD VSS VSS gf180mcu_fd_sc_mcu7t5v0__fill_2
XFILLER_13_92 VDD VDD VSS VSS gf180mcu_fd_sc_mcu7t5v0__fill_1
XFILLER_13_97 VDD VDD VSS VSS gf180mcu_fd_sc_mcu7t5v0__fillcap_8
XFILLER_14_141 VDD VDD VSS VSS gf180mcu_fd_sc_mcu7t5v0__fillcap_4
XFILLER_14_145 VDD VDD VSS VSS gf180mcu_fd_sc_mcu7t5v0__fill_1
XFILLER_14_168 VDD VDD VSS VSS gf180mcu_fd_sc_mcu7t5v0__fillcap_4
XFILLER_14_172 VDD VDD VSS VSS gf180mcu_fd_sc_mcu7t5v0__fill_2
XFILLER_14_174 VDD VDD VSS VSS gf180mcu_fd_sc_mcu7t5v0__fill_1
XFILLER_14_2 VDD VDD VSS VSS gf180mcu_fd_sc_mcu7t5v0__fillcap_32
XFILLER_14_247 VDD VDD VSS VSS gf180mcu_fd_sc_mcu7t5v0__fillcap_16
XFILLER_14_263 VDD VDD VSS VSS gf180mcu_fd_sc_mcu7t5v0__fill_2
XFILLER_14_34 VDD VDD VSS VSS gf180mcu_fd_sc_mcu7t5v0__fill_1
XFILLER_14_37 VDD VDD VSS VSS gf180mcu_fd_sc_mcu7t5v0__fill_1
XFILLER_14_43 VDD VDD VSS VSS gf180mcu_fd_sc_mcu7t5v0__fill_2
XFILLER_14_45 VDD VDD VSS VSS gf180mcu_fd_sc_mcu7t5v0__fill_1
XFILLER_14_54 VDD VDD VSS VSS gf180mcu_fd_sc_mcu7t5v0__fill_1
XFILLER_14_70 VDD VDD VSS VSS gf180mcu_fd_sc_mcu7t5v0__fill_2
XFILLER_15_138 VDD VDD VSS VSS gf180mcu_fd_sc_mcu7t5v0__fill_2
XFILLER_15_165 VDD VDD VSS VSS gf180mcu_fd_sc_mcu7t5v0__fill_1
XFILLER_15_18 VDD VDD VSS VSS gf180mcu_fd_sc_mcu7t5v0__fillcap_4
XFILLER_15_184 VDD VDD VSS VSS gf180mcu_fd_sc_mcu7t5v0__fillcap_4
XFILLER_15_188 VDD VDD VSS VSS gf180mcu_fd_sc_mcu7t5v0__fill_1
XFILLER_15_2 VDD VDD VSS VSS gf180mcu_fd_sc_mcu7t5v0__fillcap_16
XFILLER_15_208 VDD VDD VSS VSS gf180mcu_fd_sc_mcu7t5v0__fill_2
XFILLER_15_216 VDD VDD VSS VSS gf180mcu_fd_sc_mcu7t5v0__fillcap_8
XFILLER_15_22 VDD VDD VSS VSS gf180mcu_fd_sc_mcu7t5v0__fill_2
XFILLER_15_224 VDD VDD VSS VSS gf180mcu_fd_sc_mcu7t5v0__fillcap_4
XFILLER_15_228 VDD VDD VSS VSS gf180mcu_fd_sc_mcu7t5v0__fill_1
XFILLER_15_98 VDD VDD VSS VSS gf180mcu_fd_sc_mcu7t5v0__fill_1
XFILLER_16_169 VDD VDD VSS VSS gf180mcu_fd_sc_mcu7t5v0__fillcap_4
XFILLER_16_173 VDD VDD VSS VSS gf180mcu_fd_sc_mcu7t5v0__fill_2
XFILLER_16_2 VDD VDD VSS VSS gf180mcu_fd_sc_mcu7t5v0__fillcap_4
XFILLER_16_23 VDD VDD VSS VSS gf180mcu_fd_sc_mcu7t5v0__fillcap_4
XFILLER_16_261 VDD VDD VSS VSS gf180mcu_fd_sc_mcu7t5v0__fillcap_8
XFILLER_16_269 VDD VDD VSS VSS gf180mcu_fd_sc_mcu7t5v0__fill_2
XFILLER_16_37 VDD VDD VSS VSS gf180mcu_fd_sc_mcu7t5v0__fill_1
XFILLER_16_6 VDD VDD VSS VSS gf180mcu_fd_sc_mcu7t5v0__fill_2
XFILLER_16_70 VDD VDD VSS VSS gf180mcu_fd_sc_mcu7t5v0__fillcap_8
XFILLER_17_131 VDD VDD VSS VSS gf180mcu_fd_sc_mcu7t5v0__fill_1
XFILLER_17_175 VDD VDD VSS VSS gf180mcu_fd_sc_mcu7t5v0__fill_1
XFILLER_17_18 VDD VDD VSS VSS gf180mcu_fd_sc_mcu7t5v0__fillcap_8
XFILLER_17_2 VDD VDD VSS VSS gf180mcu_fd_sc_mcu7t5v0__fillcap_16
XFILLER_17_226 VDD VDD VSS VSS gf180mcu_fd_sc_mcu7t5v0__fill_2
XFILLER_17_228 VDD VDD VSS VSS gf180mcu_fd_sc_mcu7t5v0__fill_1
XFILLER_17_26 VDD VDD VSS VSS gf180mcu_fd_sc_mcu7t5v0__fill_2
XFILLER_17_28 VDD VDD VSS VSS gf180mcu_fd_sc_mcu7t5v0__fill_1
XFILLER_17_67 VDD VDD VSS VSS gf180mcu_fd_sc_mcu7t5v0__fill_2
XFILLER_17_69 VDD VDD VSS VSS gf180mcu_fd_sc_mcu7t5v0__fill_1
XFILLER_17_72 VDD VDD VSS VSS gf180mcu_fd_sc_mcu7t5v0__fill_2
XFILLER_17_74 VDD VDD VSS VSS gf180mcu_fd_sc_mcu7t5v0__fill_1
XFILLER_18_10 VDD VDD VSS VSS gf180mcu_fd_sc_mcu7t5v0__fill_2
XFILLER_18_102 VDD VDD VSS VSS gf180mcu_fd_sc_mcu7t5v0__fill_2
XFILLER_18_104 VDD VDD VSS VSS gf180mcu_fd_sc_mcu7t5v0__fill_1
XFILLER_18_112 VDD VDD VSS VSS gf180mcu_fd_sc_mcu7t5v0__fillcap_4
XFILLER_18_116 VDD VDD VSS VSS gf180mcu_fd_sc_mcu7t5v0__fill_2
XFILLER_18_170 VDD VDD VSS VSS gf180mcu_fd_sc_mcu7t5v0__fill_1
XFILLER_18_173 VDD VDD VSS VSS gf180mcu_fd_sc_mcu7t5v0__fill_2
XFILLER_18_177 VDD VDD VSS VSS gf180mcu_fd_sc_mcu7t5v0__fillcap_4
XFILLER_18_181 VDD VDD VSS VSS gf180mcu_fd_sc_mcu7t5v0__fill_2
XFILLER_18_2 VDD VDD VSS VSS gf180mcu_fd_sc_mcu7t5v0__fillcap_8
XFILLER_18_223 VDD VDD VSS VSS gf180mcu_fd_sc_mcu7t5v0__fillcap_4
XFILLER_18_243 VDD VDD VSS VSS gf180mcu_fd_sc_mcu7t5v0__fill_2
XFILLER_18_255 VDD VDD VSS VSS gf180mcu_fd_sc_mcu7t5v0__fillcap_16
XFILLER_18_271 VDD VDD VSS VSS gf180mcu_fd_sc_mcu7t5v0__fillcap_4
XFILLER_18_275 VDD VDD VSS VSS gf180mcu_fd_sc_mcu7t5v0__fill_2
XFILLER_18_84 VDD VDD VSS VSS gf180mcu_fd_sc_mcu7t5v0__fill_1
XFILLER_18_98 VDD VDD VSS VSS gf180mcu_fd_sc_mcu7t5v0__fillcap_4
XFILLER_19_111 VDD VDD VSS VSS gf180mcu_fd_sc_mcu7t5v0__fillcap_4
XFILLER_19_129 VDD VDD VSS VSS gf180mcu_fd_sc_mcu7t5v0__fill_2
XFILLER_19_131 VDD VDD VSS VSS gf180mcu_fd_sc_mcu7t5v0__fill_1
XFILLER_19_147 VDD VDD VSS VSS gf180mcu_fd_sc_mcu7t5v0__fill_2
XFILLER_19_201 VDD VDD VSS VSS gf180mcu_fd_sc_mcu7t5v0__fillcap_8
XFILLER_19_209 VDD VDD VSS VSS gf180mcu_fd_sc_mcu7t5v0__fill_1
XFILLER_19_256 VDD VDD VSS VSS gf180mcu_fd_sc_mcu7t5v0__fillcap_8
XFILLER_19_264 VDD VDD VSS VSS gf180mcu_fd_sc_mcu7t5v0__fillcap_4
XFILLER_19_268 VDD VDD VSS VSS gf180mcu_fd_sc_mcu7t5v0__fill_2
XFILLER_19_270 VDD VDD VSS VSS gf180mcu_fd_sc_mcu7t5v0__fill_1
XFILLER_19_81 VDD VDD VSS VSS gf180mcu_fd_sc_mcu7t5v0__fill_2
XFILLER_19_83 VDD VDD VSS VSS gf180mcu_fd_sc_mcu7t5v0__fill_1
XFILLER_19_94 VDD VDD VSS VSS gf180mcu_fd_sc_mcu7t5v0__fill_1
XFILLER_1_114 VDD VDD VSS VSS gf180mcu_fd_sc_mcu7t5v0__fillcap_8
XFILLER_1_122 VDD VDD VSS VSS gf180mcu_fd_sc_mcu7t5v0__fill_1
XFILLER_1_131 VDD VDD VSS VSS gf180mcu_fd_sc_mcu7t5v0__fillcap_8
XFILLER_1_139 VDD VDD VSS VSS gf180mcu_fd_sc_mcu7t5v0__fill_1
XFILLER_1_142 VDD VDD VSS VSS gf180mcu_fd_sc_mcu7t5v0__fillcap_32
XFILLER_1_174 VDD VDD VSS VSS gf180mcu_fd_sc_mcu7t5v0__fill_2
XFILLER_1_176 VDD VDD VSS VSS gf180mcu_fd_sc_mcu7t5v0__fill_1
XFILLER_1_185 VDD VDD VSS VSS gf180mcu_fd_sc_mcu7t5v0__fill_2
XFILLER_1_2 VDD VDD VSS VSS gf180mcu_fd_sc_mcu7t5v0__fill_2
XFILLER_1_232 VDD VDD VSS VSS gf180mcu_fd_sc_mcu7t5v0__fillcap_8
XFILLER_1_240 VDD VDD VSS VSS gf180mcu_fd_sc_mcu7t5v0__fill_1
XFILLER_1_38 VDD VDD VSS VSS gf180mcu_fd_sc_mcu7t5v0__fillcap_4
XFILLER_1_42 VDD VDD VSS VSS gf180mcu_fd_sc_mcu7t5v0__fill_1
XFILLER_20_103 VDD VDD VSS VSS gf180mcu_fd_sc_mcu7t5v0__fill_2
XFILLER_20_107 VDD VDD VSS VSS gf180mcu_fd_sc_mcu7t5v0__fillcap_4
XFILLER_20_111 VDD VDD VSS VSS gf180mcu_fd_sc_mcu7t5v0__fill_2
XFILLER_20_139 VDD VDD VSS VSS gf180mcu_fd_sc_mcu7t5v0__fill_2
XFILLER_20_141 VDD VDD VSS VSS gf180mcu_fd_sc_mcu7t5v0__fill_1
XFILLER_20_173 VDD VDD VSS VSS gf180mcu_fd_sc_mcu7t5v0__fill_2
XFILLER_20_177 VDD VDD VSS VSS gf180mcu_fd_sc_mcu7t5v0__fillcap_4
XFILLER_20_2 VDD VDD VSS VSS gf180mcu_fd_sc_mcu7t5v0__fillcap_4
XFILLER_20_219 VDD VDD VSS VSS gf180mcu_fd_sc_mcu7t5v0__fillcap_16
XFILLER_20_235 VDD VDD VSS VSS gf180mcu_fd_sc_mcu7t5v0__fillcap_8
XFILLER_20_24 VDD VDD VSS VSS gf180mcu_fd_sc_mcu7t5v0__fillcap_8
XFILLER_20_243 VDD VDD VSS VSS gf180mcu_fd_sc_mcu7t5v0__fill_2
XFILLER_20_247 VDD VDD VSS VSS gf180mcu_fd_sc_mcu7t5v0__fillcap_16
XFILLER_20_263 VDD VDD VSS VSS gf180mcu_fd_sc_mcu7t5v0__fillcap_8
XFILLER_20_32 VDD VDD VSS VSS gf180mcu_fd_sc_mcu7t5v0__fill_2
XFILLER_20_34 VDD VDD VSS VSS gf180mcu_fd_sc_mcu7t5v0__fill_1
XFILLER_20_6 VDD VDD VSS VSS gf180mcu_fd_sc_mcu7t5v0__fill_2
XFILLER_20_71 VDD VDD VSS VSS gf180mcu_fd_sc_mcu7t5v0__fillcap_4
XFILLER_20_75 VDD VDD VSS VSS gf180mcu_fd_sc_mcu7t5v0__fill_1
XFILLER_20_8 VDD VDD VSS VSS gf180mcu_fd_sc_mcu7t5v0__fill_1
XFILLER_20_92 VDD VDD VSS VSS gf180mcu_fd_sc_mcu7t5v0__fill_2
XFILLER_21_127 VDD VDD VSS VSS gf180mcu_fd_sc_mcu7t5v0__fill_1
XFILLER_21_137 VDD VDD VSS VSS gf180mcu_fd_sc_mcu7t5v0__fill_2
XFILLER_21_139 VDD VDD VSS VSS gf180mcu_fd_sc_mcu7t5v0__fill_1
XFILLER_21_154 VDD VDD VSS VSS gf180mcu_fd_sc_mcu7t5v0__fillcap_4
XFILLER_21_158 VDD VDD VSS VSS gf180mcu_fd_sc_mcu7t5v0__fill_1
XFILLER_21_197 VDD VDD VSS VSS gf180mcu_fd_sc_mcu7t5v0__fillcap_8
XFILLER_21_2 VDD VDD VSS VSS gf180mcu_fd_sc_mcu7t5v0__fill_1
XFILLER_21_205 VDD VDD VSS VSS gf180mcu_fd_sc_mcu7t5v0__fillcap_4
XFILLER_21_209 VDD VDD VSS VSS gf180mcu_fd_sc_mcu7t5v0__fill_1
XFILLER_21_246 VDD VDD VSS VSS gf180mcu_fd_sc_mcu7t5v0__fillcap_16
XFILLER_21_262 VDD VDD VSS VSS gf180mcu_fd_sc_mcu7t5v0__fillcap_8
XFILLER_21_270 VDD VDD VSS VSS gf180mcu_fd_sc_mcu7t5v0__fillcap_4
XFILLER_21_274 VDD VDD VSS VSS gf180mcu_fd_sc_mcu7t5v0__fill_2
XFILLER_21_276 VDD VDD VSS VSS gf180mcu_fd_sc_mcu7t5v0__fill_1
XFILLER_21_47 VDD VDD VSS VSS gf180mcu_fd_sc_mcu7t5v0__fillcap_8
XFILLER_21_72 VDD VDD VSS VSS gf180mcu_fd_sc_mcu7t5v0__fill_2
XFILLER_22_107 VDD VDD VSS VSS gf180mcu_fd_sc_mcu7t5v0__fillcap_4
XFILLER_22_119 VDD VDD VSS VSS gf180mcu_fd_sc_mcu7t5v0__fillcap_4
XFILLER_22_123 VDD VDD VSS VSS gf180mcu_fd_sc_mcu7t5v0__fill_1
XFILLER_22_174 VDD VDD VSS VSS gf180mcu_fd_sc_mcu7t5v0__fill_1
XFILLER_22_177 VDD VDD VSS VSS gf180mcu_fd_sc_mcu7t5v0__fillcap_4
XFILLER_22_18 VDD VDD VSS VSS gf180mcu_fd_sc_mcu7t5v0__fillcap_8
XFILLER_22_181 VDD VDD VSS VSS gf180mcu_fd_sc_mcu7t5v0__fill_2
XFILLER_22_2 VDD VDD VSS VSS gf180mcu_fd_sc_mcu7t5v0__fillcap_16
XFILLER_22_217 VDD VDD VSS VSS gf180mcu_fd_sc_mcu7t5v0__fillcap_8
XFILLER_22_230 VDD VDD VSS VSS gf180mcu_fd_sc_mcu7t5v0__fillcap_4
XFILLER_22_234 VDD VDD VSS VSS gf180mcu_fd_sc_mcu7t5v0__fill_2
XFILLER_22_236 VDD VDD VSS VSS gf180mcu_fd_sc_mcu7t5v0__fill_1
XFILLER_22_247 VDD VDD VSS VSS gf180mcu_fd_sc_mcu7t5v0__fillcap_16
XFILLER_22_26 VDD VDD VSS VSS gf180mcu_fd_sc_mcu7t5v0__fillcap_4
XFILLER_22_263 VDD VDD VSS VSS gf180mcu_fd_sc_mcu7t5v0__fillcap_8
XFILLER_23_103 VDD VDD VSS VSS gf180mcu_fd_sc_mcu7t5v0__fill_2
XFILLER_23_105 VDD VDD VSS VSS gf180mcu_fd_sc_mcu7t5v0__fill_1
XFILLER_23_158 VDD VDD VSS VSS gf180mcu_fd_sc_mcu7t5v0__fillcap_8
XFILLER_23_166 VDD VDD VSS VSS gf180mcu_fd_sc_mcu7t5v0__fill_1
XFILLER_23_176 VDD VDD VSS VSS gf180mcu_fd_sc_mcu7t5v0__fillcap_32
XFILLER_23_2 VDD VDD VSS VSS gf180mcu_fd_sc_mcu7t5v0__fillcap_4
XFILLER_23_208 VDD VDD VSS VSS gf180mcu_fd_sc_mcu7t5v0__fill_2
XFILLER_23_24 VDD VDD VSS VSS gf180mcu_fd_sc_mcu7t5v0__fillcap_8
XFILLER_23_256 VDD VDD VSS VSS gf180mcu_fd_sc_mcu7t5v0__fillcap_16
XFILLER_23_272 VDD VDD VSS VSS gf180mcu_fd_sc_mcu7t5v0__fillcap_4
XFILLER_23_276 VDD VDD VSS VSS gf180mcu_fd_sc_mcu7t5v0__fill_1
XFILLER_23_32 VDD VDD VSS VSS gf180mcu_fd_sc_mcu7t5v0__fill_2
XFILLER_23_6 VDD VDD VSS VSS gf180mcu_fd_sc_mcu7t5v0__fill_2
XFILLER_23_68 VDD VDD VSS VSS gf180mcu_fd_sc_mcu7t5v0__fill_2
XFILLER_23_72 VDD VDD VSS VSS gf180mcu_fd_sc_mcu7t5v0__fill_2
XFILLER_23_74 VDD VDD VSS VSS gf180mcu_fd_sc_mcu7t5v0__fill_1
XFILLER_23_8 VDD VDD VSS VSS gf180mcu_fd_sc_mcu7t5v0__fill_1
XFILLER_24_10 VDD VDD VSS VSS gf180mcu_fd_sc_mcu7t5v0__fillcap_4
XFILLER_24_107 VDD VDD VSS VSS gf180mcu_fd_sc_mcu7t5v0__fillcap_16
XFILLER_24_2 VDD VDD VSS VSS gf180mcu_fd_sc_mcu7t5v0__fillcap_8
XFILLER_24_255 VDD VDD VSS VSS gf180mcu_fd_sc_mcu7t5v0__fillcap_16
XFILLER_24_29 VDD VDD VSS VSS gf180mcu_fd_sc_mcu7t5v0__fill_1
XFILLER_24_37 VDD VDD VSS VSS gf180mcu_fd_sc_mcu7t5v0__fill_2
XFILLER_24_39 VDD VDD VSS VSS gf180mcu_fd_sc_mcu7t5v0__fill_1
XFILLER_25_103 VDD VDD VSS VSS gf180mcu_fd_sc_mcu7t5v0__fill_1
XFILLER_25_142 VDD VDD VSS VSS gf180mcu_fd_sc_mcu7t5v0__fill_2
XFILLER_25_167 VDD VDD VSS VSS gf180mcu_fd_sc_mcu7t5v0__fill_2
XFILLER_25_169 VDD VDD VSS VSS gf180mcu_fd_sc_mcu7t5v0__fill_1
XFILLER_25_184 VDD VDD VSS VSS gf180mcu_fd_sc_mcu7t5v0__fillcap_16
XFILLER_25_200 VDD VDD VSS VSS gf180mcu_fd_sc_mcu7t5v0__fillcap_8
XFILLER_25_208 VDD VDD VSS VSS gf180mcu_fd_sc_mcu7t5v0__fill_2
XFILLER_25_246 VDD VDD VSS VSS gf180mcu_fd_sc_mcu7t5v0__fillcap_16
XFILLER_25_262 VDD VDD VSS VSS gf180mcu_fd_sc_mcu7t5v0__fillcap_8
XFILLER_25_270 VDD VDD VSS VSS gf180mcu_fd_sc_mcu7t5v0__fillcap_4
XFILLER_25_274 VDD VDD VSS VSS gf180mcu_fd_sc_mcu7t5v0__fill_2
XFILLER_25_276 VDD VDD VSS VSS gf180mcu_fd_sc_mcu7t5v0__fill_1
XFILLER_25_36 VDD VDD VSS VSS gf180mcu_fd_sc_mcu7t5v0__fill_2
XFILLER_25_54 VDD VDD VSS VSS gf180mcu_fd_sc_mcu7t5v0__fill_1
XFILLER_25_99 VDD VDD VSS VSS gf180mcu_fd_sc_mcu7t5v0__fillcap_4
XFILLER_26_121 VDD VDD VSS VSS gf180mcu_fd_sc_mcu7t5v0__fill_1
XFILLER_26_177 VDD VDD VSS VSS gf180mcu_fd_sc_mcu7t5v0__fill_1
XFILLER_26_2 VDD VDD VSS VSS gf180mcu_fd_sc_mcu7t5v0__fillcap_4
XFILLER_26_24 VDD VDD VSS VSS gf180mcu_fd_sc_mcu7t5v0__fillcap_8
XFILLER_26_247 VDD VDD VSS VSS gf180mcu_fd_sc_mcu7t5v0__fillcap_16
XFILLER_26_263 VDD VDD VSS VSS gf180mcu_fd_sc_mcu7t5v0__fill_2
XFILLER_26_32 VDD VDD VSS VSS gf180mcu_fd_sc_mcu7t5v0__fill_2
XFILLER_26_34 VDD VDD VSS VSS gf180mcu_fd_sc_mcu7t5v0__fill_1
XFILLER_26_37 VDD VDD VSS VSS gf180mcu_fd_sc_mcu7t5v0__fillcap_4
XFILLER_26_53 VDD VDD VSS VSS gf180mcu_fd_sc_mcu7t5v0__fillcap_4
XFILLER_26_57 VDD VDD VSS VSS gf180mcu_fd_sc_mcu7t5v0__fill_2
XFILLER_26_59 VDD VDD VSS VSS gf180mcu_fd_sc_mcu7t5v0__fill_1
XFILLER_26_6 VDD VDD VSS VSS gf180mcu_fd_sc_mcu7t5v0__fill_2
XFILLER_26_64 VDD VDD VSS VSS gf180mcu_fd_sc_mcu7t5v0__fillcap_4
XFILLER_26_8 VDD VDD VSS VSS gf180mcu_fd_sc_mcu7t5v0__fill_1
XFILLER_27_132 VDD VDD VSS VSS gf180mcu_fd_sc_mcu7t5v0__fillcap_4
XFILLER_27_147 VDD VDD VSS VSS gf180mcu_fd_sc_mcu7t5v0__fill_2
XFILLER_27_149 VDD VDD VSS VSS gf180mcu_fd_sc_mcu7t5v0__fill_1
XFILLER_27_156 VDD VDD VSS VSS gf180mcu_fd_sc_mcu7t5v0__fillcap_8
XFILLER_27_164 VDD VDD VSS VSS gf180mcu_fd_sc_mcu7t5v0__fill_2
XFILLER_27_166 VDD VDD VSS VSS gf180mcu_fd_sc_mcu7t5v0__fill_1
XFILLER_27_2 VDD VDD VSS VSS gf180mcu_fd_sc_mcu7t5v0__fill_1
XFILLER_27_203 VDD VDD VSS VSS gf180mcu_fd_sc_mcu7t5v0__fill_2
XFILLER_27_205 VDD VDD VSS VSS gf180mcu_fd_sc_mcu7t5v0__fill_1
XFILLER_27_235 VDD VDD VSS VSS gf180mcu_fd_sc_mcu7t5v0__fill_2
XFILLER_27_37 VDD VDD VSS VSS gf180mcu_fd_sc_mcu7t5v0__fillcap_32
XFILLER_27_69 VDD VDD VSS VSS gf180mcu_fd_sc_mcu7t5v0__fill_1
XFILLER_27_72 VDD VDD VSS VSS gf180mcu_fd_sc_mcu7t5v0__fillcap_4
XFILLER_27_76 VDD VDD VSS VSS gf180mcu_fd_sc_mcu7t5v0__fill_2
XFILLER_27_82 VDD VDD VSS VSS gf180mcu_fd_sc_mcu7t5v0__fill_2
XFILLER_27_84 VDD VDD VSS VSS gf180mcu_fd_sc_mcu7t5v0__fill_1
XFILLER_27_93 VDD VDD VSS VSS gf180mcu_fd_sc_mcu7t5v0__fill_2
XFILLER_28_10 VDD VDD VSS VSS gf180mcu_fd_sc_mcu7t5v0__fill_2
XFILLER_28_12 VDD VDD VSS VSS gf180mcu_fd_sc_mcu7t5v0__fill_1
XFILLER_28_150 VDD VDD VSS VSS gf180mcu_fd_sc_mcu7t5v0__fillcap_16
XFILLER_28_166 VDD VDD VSS VSS gf180mcu_fd_sc_mcu7t5v0__fillcap_8
XFILLER_28_174 VDD VDD VSS VSS gf180mcu_fd_sc_mcu7t5v0__fill_1
XFILLER_28_177 VDD VDD VSS VSS gf180mcu_fd_sc_mcu7t5v0__fillcap_8
XFILLER_28_2 VDD VDD VSS VSS gf180mcu_fd_sc_mcu7t5v0__fillcap_8
XFILLER_28_242 VDD VDD VSS VSS gf180mcu_fd_sc_mcu7t5v0__fill_2
XFILLER_28_244 VDD VDD VSS VSS gf180mcu_fd_sc_mcu7t5v0__fill_1
XFILLER_28_255 VDD VDD VSS VSS gf180mcu_fd_sc_mcu7t5v0__fillcap_16
XFILLER_28_28 VDD VDD VSS VSS gf180mcu_fd_sc_mcu7t5v0__fillcap_4
XFILLER_28_32 VDD VDD VSS VSS gf180mcu_fd_sc_mcu7t5v0__fill_2
XFILLER_28_34 VDD VDD VSS VSS gf180mcu_fd_sc_mcu7t5v0__fill_1
XFILLER_28_43 VDD VDD VSS VSS gf180mcu_fd_sc_mcu7t5v0__fillcap_4
XFILLER_28_47 VDD VDD VSS VSS gf180mcu_fd_sc_mcu7t5v0__fill_2
XFILLER_28_83 VDD VDD VSS VSS gf180mcu_fd_sc_mcu7t5v0__fill_2
XFILLER_28_85 VDD VDD VSS VSS gf180mcu_fd_sc_mcu7t5v0__fill_1
XFILLER_29_137 VDD VDD VSS VSS gf180mcu_fd_sc_mcu7t5v0__fill_2
XFILLER_29_139 VDD VDD VSS VSS gf180mcu_fd_sc_mcu7t5v0__fill_1
XFILLER_29_147 VDD VDD VSS VSS gf180mcu_fd_sc_mcu7t5v0__fillcap_16
XFILLER_29_163 VDD VDD VSS VSS gf180mcu_fd_sc_mcu7t5v0__fillcap_4
XFILLER_29_189 VDD VDD VSS VSS gf180mcu_fd_sc_mcu7t5v0__fillcap_8
XFILLER_29_197 VDD VDD VSS VSS gf180mcu_fd_sc_mcu7t5v0__fill_1
XFILLER_29_240 VDD VDD VSS VSS gf180mcu_fd_sc_mcu7t5v0__fill_2
XFILLER_29_242 VDD VDD VSS VSS gf180mcu_fd_sc_mcu7t5v0__fill_1
XFILLER_29_36 VDD VDD VSS VSS gf180mcu_fd_sc_mcu7t5v0__fillcap_4
XFILLER_29_40 VDD VDD VSS VSS gf180mcu_fd_sc_mcu7t5v0__fill_1
XFILLER_29_57 VDD VDD VSS VSS gf180mcu_fd_sc_mcu7t5v0__fillcap_8
XFILLER_29_65 VDD VDD VSS VSS gf180mcu_fd_sc_mcu7t5v0__fillcap_4
XFILLER_29_69 VDD VDD VSS VSS gf180mcu_fd_sc_mcu7t5v0__fill_1
XFILLER_29_72 VDD VDD VSS VSS gf180mcu_fd_sc_mcu7t5v0__fillcap_4
XFILLER_29_76 VDD VDD VSS VSS gf180mcu_fd_sc_mcu7t5v0__fill_2
XFILLER_29_78 VDD VDD VSS VSS gf180mcu_fd_sc_mcu7t5v0__fill_1
XFILLER_29_88 VDD VDD VSS VSS gf180mcu_fd_sc_mcu7t5v0__fill_1
XFILLER_2_10 VDD VDD VSS VSS gf180mcu_fd_sc_mcu7t5v0__fill_2
XFILLER_2_107 VDD VDD VSS VSS gf180mcu_fd_sc_mcu7t5v0__fill_2
XFILLER_2_132 VDD VDD VSS VSS gf180mcu_fd_sc_mcu7t5v0__fillcap_4
XFILLER_2_170 VDD VDD VSS VSS gf180mcu_fd_sc_mcu7t5v0__fillcap_4
XFILLER_2_174 VDD VDD VSS VSS gf180mcu_fd_sc_mcu7t5v0__fill_1
XFILLER_2_182 VDD VDD VSS VSS gf180mcu_fd_sc_mcu7t5v0__fill_1
XFILLER_2_2 VDD VDD VSS VSS gf180mcu_fd_sc_mcu7t5v0__fillcap_8
XFILLER_2_200 VDD VDD VSS VSS gf180mcu_fd_sc_mcu7t5v0__fill_1
XFILLER_2_247 VDD VDD VSS VSS gf180mcu_fd_sc_mcu7t5v0__fillcap_16
XFILLER_2_263 VDD VDD VSS VSS gf180mcu_fd_sc_mcu7t5v0__fill_2
XFILLER_2_27 VDD VDD VSS VSS gf180mcu_fd_sc_mcu7t5v0__fill_2
XFILLER_2_37 VDD VDD VSS VSS gf180mcu_fd_sc_mcu7t5v0__fill_1
XFILLER_2_78 VDD VDD VSS VSS gf180mcu_fd_sc_mcu7t5v0__fillcap_4
XFILLER_30_103 VDD VDD VSS VSS gf180mcu_fd_sc_mcu7t5v0__fill_2
XFILLER_30_107 VDD VDD VSS VSS gf180mcu_fd_sc_mcu7t5v0__fill_2
XFILLER_30_109 VDD VDD VSS VSS gf180mcu_fd_sc_mcu7t5v0__fill_1
XFILLER_30_177 VDD VDD VSS VSS gf180mcu_fd_sc_mcu7t5v0__fillcap_4
XFILLER_30_181 VDD VDD VSS VSS gf180mcu_fd_sc_mcu7t5v0__fill_2
XFILLER_30_183 VDD VDD VSS VSS gf180mcu_fd_sc_mcu7t5v0__fill_1
XFILLER_30_2 VDD VDD VSS VSS gf180mcu_fd_sc_mcu7t5v0__fillcap_32
XFILLER_30_228 VDD VDD VSS VSS gf180mcu_fd_sc_mcu7t5v0__fill_2
XFILLER_30_236 VDD VDD VSS VSS gf180mcu_fd_sc_mcu7t5v0__fill_1
XFILLER_30_252 VDD VDD VSS VSS gf180mcu_fd_sc_mcu7t5v0__fillcap_16
XFILLER_30_268 VDD VDD VSS VSS gf180mcu_fd_sc_mcu7t5v0__fill_2
XFILLER_30_270 VDD VDD VSS VSS gf180mcu_fd_sc_mcu7t5v0__fill_1
XFILLER_30_34 VDD VDD VSS VSS gf180mcu_fd_sc_mcu7t5v0__fill_1
XFILLER_30_37 VDD VDD VSS VSS gf180mcu_fd_sc_mcu7t5v0__fill_1
XFILLER_30_52 VDD VDD VSS VSS gf180mcu_fd_sc_mcu7t5v0__fill_2
XFILLER_30_54 VDD VDD VSS VSS gf180mcu_fd_sc_mcu7t5v0__fill_1
XFILLER_31_132 VDD VDD VSS VSS gf180mcu_fd_sc_mcu7t5v0__fill_1
XFILLER_31_142 VDD VDD VSS VSS gf180mcu_fd_sc_mcu7t5v0__fill_2
XFILLER_31_2 VDD VDD VSS VSS gf180mcu_fd_sc_mcu7t5v0__fillcap_4
XFILLER_31_205 VDD VDD VSS VSS gf180mcu_fd_sc_mcu7t5v0__fillcap_4
XFILLER_31_209 VDD VDD VSS VSS gf180mcu_fd_sc_mcu7t5v0__fill_1
XFILLER_31_224 VDD VDD VSS VSS gf180mcu_fd_sc_mcu7t5v0__fill_1
XFILLER_31_23 VDD VDD VSS VSS gf180mcu_fd_sc_mcu7t5v0__fillcap_8
XFILLER_31_31 VDD VDD VSS VSS gf180mcu_fd_sc_mcu7t5v0__fill_2
XFILLER_31_6 VDD VDD VSS VSS gf180mcu_fd_sc_mcu7t5v0__fill_2
XFILLER_31_67 VDD VDD VSS VSS gf180mcu_fd_sc_mcu7t5v0__fill_2
XFILLER_31_69 VDD VDD VSS VSS gf180mcu_fd_sc_mcu7t5v0__fill_1
XFILLER_31_72 VDD VDD VSS VSS gf180mcu_fd_sc_mcu7t5v0__fill_1
XFILLER_32_142 VDD VDD VSS VSS gf180mcu_fd_sc_mcu7t5v0__fill_2
XFILLER_32_153 VDD VDD VSS VSS gf180mcu_fd_sc_mcu7t5v0__fill_2
XFILLER_32_155 VDD VDD VSS VSS gf180mcu_fd_sc_mcu7t5v0__fill_1
XFILLER_32_164 VDD VDD VSS VSS gf180mcu_fd_sc_mcu7t5v0__fillcap_8
XFILLER_32_172 VDD VDD VSS VSS gf180mcu_fd_sc_mcu7t5v0__fill_2
XFILLER_32_174 VDD VDD VSS VSS gf180mcu_fd_sc_mcu7t5v0__fill_1
XFILLER_32_177 VDD VDD VSS VSS gf180mcu_fd_sc_mcu7t5v0__fillcap_32
XFILLER_32_2 VDD VDD VSS VSS gf180mcu_fd_sc_mcu7t5v0__fillcap_32
XFILLER_32_209 VDD VDD VSS VSS gf180mcu_fd_sc_mcu7t5v0__fillcap_16
XFILLER_32_225 VDD VDD VSS VSS gf180mcu_fd_sc_mcu7t5v0__fillcap_8
XFILLER_32_238 VDD VDD VSS VSS gf180mcu_fd_sc_mcu7t5v0__fill_1
XFILLER_32_251 VDD VDD VSS VSS gf180mcu_fd_sc_mcu7t5v0__fillcap_16
XFILLER_32_267 VDD VDD VSS VSS gf180mcu_fd_sc_mcu7t5v0__fillcap_4
XFILLER_32_34 VDD VDD VSS VSS gf180mcu_fd_sc_mcu7t5v0__fill_1
XFILLER_32_69 VDD VDD VSS VSS gf180mcu_fd_sc_mcu7t5v0__fill_2
XFILLER_32_71 VDD VDD VSS VSS gf180mcu_fd_sc_mcu7t5v0__fill_1
XFILLER_32_81 VDD VDD VSS VSS gf180mcu_fd_sc_mcu7t5v0__fillcap_4
XFILLER_32_85 VDD VDD VSS VSS gf180mcu_fd_sc_mcu7t5v0__fill_2
XFILLER_33_10 VDD VDD VSS VSS gf180mcu_fd_sc_mcu7t5v0__fillcap_4
XFILLER_33_139 VDD VDD VSS VSS gf180mcu_fd_sc_mcu7t5v0__fill_1
XFILLER_33_14 VDD VDD VSS VSS gf180mcu_fd_sc_mcu7t5v0__fill_1
XFILLER_33_142 VDD VDD VSS VSS gf180mcu_fd_sc_mcu7t5v0__fillcap_16
XFILLER_33_158 VDD VDD VSS VSS gf180mcu_fd_sc_mcu7t5v0__fillcap_4
XFILLER_33_162 VDD VDD VSS VSS gf180mcu_fd_sc_mcu7t5v0__fill_2
XFILLER_33_188 VDD VDD VSS VSS gf180mcu_fd_sc_mcu7t5v0__fillcap_16
XFILLER_33_2 VDD VDD VSS VSS gf180mcu_fd_sc_mcu7t5v0__fillcap_8
XFILLER_33_208 VDD VDD VSS VSS gf180mcu_fd_sc_mcu7t5v0__fill_2
XFILLER_33_212 VDD VDD VSS VSS gf180mcu_fd_sc_mcu7t5v0__fillcap_4
XFILLER_33_216 VDD VDD VSS VSS gf180mcu_fd_sc_mcu7t5v0__fill_2
XFILLER_33_228 VDD VDD VSS VSS gf180mcu_fd_sc_mcu7t5v0__fillcap_8
XFILLER_33_236 VDD VDD VSS VSS gf180mcu_fd_sc_mcu7t5v0__fillcap_4
XFILLER_33_240 VDD VDD VSS VSS gf180mcu_fd_sc_mcu7t5v0__fill_2
XFILLER_33_242 VDD VDD VSS VSS gf180mcu_fd_sc_mcu7t5v0__fill_1
XFILLER_33_27 VDD VDD VSS VSS gf180mcu_fd_sc_mcu7t5v0__fillcap_16
XFILLER_33_43 VDD VDD VSS VSS gf180mcu_fd_sc_mcu7t5v0__fill_1
XFILLER_33_59 VDD VDD VSS VSS gf180mcu_fd_sc_mcu7t5v0__fillcap_8
XFILLER_33_67 VDD VDD VSS VSS gf180mcu_fd_sc_mcu7t5v0__fill_2
XFILLER_33_69 VDD VDD VSS VSS gf180mcu_fd_sc_mcu7t5v0__fill_1
XFILLER_33_72 VDD VDD VSS VSS gf180mcu_fd_sc_mcu7t5v0__fillcap_4
XFILLER_33_76 VDD VDD VSS VSS gf180mcu_fd_sc_mcu7t5v0__fill_1
XFILLER_33_94 VDD VDD VSS VSS gf180mcu_fd_sc_mcu7t5v0__fillcap_4
XFILLER_34_120 VDD VDD VSS VSS gf180mcu_fd_sc_mcu7t5v0__fill_1
XFILLER_34_126 VDD VDD VSS VSS gf180mcu_fd_sc_mcu7t5v0__fillcap_8
XFILLER_34_134 VDD VDD VSS VSS gf180mcu_fd_sc_mcu7t5v0__fill_2
XFILLER_34_136 VDD VDD VSS VSS gf180mcu_fd_sc_mcu7t5v0__fill_1
XFILLER_34_164 VDD VDD VSS VSS gf180mcu_fd_sc_mcu7t5v0__fillcap_8
XFILLER_34_172 VDD VDD VSS VSS gf180mcu_fd_sc_mcu7t5v0__fill_2
XFILLER_34_174 VDD VDD VSS VSS gf180mcu_fd_sc_mcu7t5v0__fill_1
XFILLER_34_177 VDD VDD VSS VSS gf180mcu_fd_sc_mcu7t5v0__fillcap_8
XFILLER_34_185 VDD VDD VSS VSS gf180mcu_fd_sc_mcu7t5v0__fill_1
XFILLER_34_2 VDD VDD VSS VSS gf180mcu_fd_sc_mcu7t5v0__fillcap_4
XFILLER_34_231 VDD VDD VSS VSS gf180mcu_fd_sc_mcu7t5v0__fillcap_8
XFILLER_34_239 VDD VDD VSS VSS gf180mcu_fd_sc_mcu7t5v0__fillcap_4
XFILLER_34_243 VDD VDD VSS VSS gf180mcu_fd_sc_mcu7t5v0__fill_2
XFILLER_34_247 VDD VDD VSS VSS gf180mcu_fd_sc_mcu7t5v0__fillcap_16
XFILLER_34_263 VDD VDD VSS VSS gf180mcu_fd_sc_mcu7t5v0__fillcap_8
XFILLER_34_6 VDD VDD VSS VSS gf180mcu_fd_sc_mcu7t5v0__fill_2
XFILLER_34_73 VDD VDD VSS VSS gf180mcu_fd_sc_mcu7t5v0__fillcap_32
XFILLER_35_104 VDD VDD VSS VSS gf180mcu_fd_sc_mcu7t5v0__fillcap_4
XFILLER_35_108 VDD VDD VSS VSS gf180mcu_fd_sc_mcu7t5v0__fill_2
XFILLER_35_120 VDD VDD VSS VSS gf180mcu_fd_sc_mcu7t5v0__fillcap_4
XFILLER_35_124 VDD VDD VSS VSS gf180mcu_fd_sc_mcu7t5v0__fill_2
XFILLER_35_131 VDD VDD VSS VSS gf180mcu_fd_sc_mcu7t5v0__fill_2
XFILLER_35_133 VDD VDD VSS VSS gf180mcu_fd_sc_mcu7t5v0__fill_1
XFILLER_35_142 VDD VDD VSS VSS gf180mcu_fd_sc_mcu7t5v0__fill_2
XFILLER_35_144 VDD VDD VSS VSS gf180mcu_fd_sc_mcu7t5v0__fill_1
XFILLER_35_150 VDD VDD VSS VSS gf180mcu_fd_sc_mcu7t5v0__fillcap_16
XFILLER_35_166 VDD VDD VSS VSS gf180mcu_fd_sc_mcu7t5v0__fill_1
XFILLER_35_201 VDD VDD VSS VSS gf180mcu_fd_sc_mcu7t5v0__fill_2
XFILLER_35_212 VDD VDD VSS VSS gf180mcu_fd_sc_mcu7t5v0__fillcap_16
XFILLER_35_228 VDD VDD VSS VSS gf180mcu_fd_sc_mcu7t5v0__fillcap_8
XFILLER_35_236 VDD VDD VSS VSS gf180mcu_fd_sc_mcu7t5v0__fillcap_4
XFILLER_35_240 VDD VDD VSS VSS gf180mcu_fd_sc_mcu7t5v0__fill_1
XFILLER_35_40 VDD VDD VSS VSS gf180mcu_fd_sc_mcu7t5v0__fillcap_4
XFILLER_35_44 VDD VDD VSS VSS gf180mcu_fd_sc_mcu7t5v0__fill_1
XFILLER_35_53 VDD VDD VSS VSS gf180mcu_fd_sc_mcu7t5v0__fill_2
XFILLER_35_72 VDD VDD VSS VSS gf180mcu_fd_sc_mcu7t5v0__fillcap_32
XFILLER_36_102 VDD VDD VSS VSS gf180mcu_fd_sc_mcu7t5v0__fill_2
XFILLER_36_104 VDD VDD VSS VSS gf180mcu_fd_sc_mcu7t5v0__fill_1
XFILLER_36_107 VDD VDD VSS VSS gf180mcu_fd_sc_mcu7t5v0__fillcap_4
XFILLER_36_111 VDD VDD VSS VSS gf180mcu_fd_sc_mcu7t5v0__fill_2
XFILLER_36_113 VDD VDD VSS VSS gf180mcu_fd_sc_mcu7t5v0__fill_1
XFILLER_36_154 VDD VDD VSS VSS gf180mcu_fd_sc_mcu7t5v0__fillcap_4
XFILLER_36_158 VDD VDD VSS VSS gf180mcu_fd_sc_mcu7t5v0__fill_2
XFILLER_36_160 VDD VDD VSS VSS gf180mcu_fd_sc_mcu7t5v0__fill_1
XFILLER_36_171 VDD VDD VSS VSS gf180mcu_fd_sc_mcu7t5v0__fillcap_4
XFILLER_36_177 VDD VDD VSS VSS gf180mcu_fd_sc_mcu7t5v0__fillcap_16
XFILLER_36_193 VDD VDD VSS VSS gf180mcu_fd_sc_mcu7t5v0__fill_1
XFILLER_36_2 VDD VDD VSS VSS gf180mcu_fd_sc_mcu7t5v0__fillcap_4
XFILLER_36_21 VDD VDD VSS VSS gf180mcu_fd_sc_mcu7t5v0__fill_1
XFILLER_36_228 VDD VDD VSS VSS gf180mcu_fd_sc_mcu7t5v0__fillcap_4
XFILLER_36_232 VDD VDD VSS VSS gf180mcu_fd_sc_mcu7t5v0__fill_2
XFILLER_36_255 VDD VDD VSS VSS gf180mcu_fd_sc_mcu7t5v0__fillcap_16
XFILLER_36_31 VDD VDD VSS VSS gf180mcu_fd_sc_mcu7t5v0__fillcap_4
XFILLER_36_37 VDD VDD VSS VSS gf180mcu_fd_sc_mcu7t5v0__fill_2
XFILLER_36_6 VDD VDD VSS VSS gf180mcu_fd_sc_mcu7t5v0__fill_2
XFILLER_36_73 VDD VDD VSS VSS gf180mcu_fd_sc_mcu7t5v0__fillcap_8
XFILLER_36_81 VDD VDD VSS VSS gf180mcu_fd_sc_mcu7t5v0__fillcap_4
XFILLER_36_85 VDD VDD VSS VSS gf180mcu_fd_sc_mcu7t5v0__fill_1
XFILLER_36_95 VDD VDD VSS VSS gf180mcu_fd_sc_mcu7t5v0__fill_2
XFILLER_37_107 VDD VDD VSS VSS gf180mcu_fd_sc_mcu7t5v0__fill_1
XFILLER_37_142 VDD VDD VSS VSS gf180mcu_fd_sc_mcu7t5v0__fill_2
XFILLER_37_185 VDD VDD VSS VSS gf180mcu_fd_sc_mcu7t5v0__fillcap_16
XFILLER_37_201 VDD VDD VSS VSS gf180mcu_fd_sc_mcu7t5v0__fillcap_4
XFILLER_37_205 VDD VDD VSS VSS gf180mcu_fd_sc_mcu7t5v0__fill_1
XFILLER_37_216 VDD VDD VSS VSS gf180mcu_fd_sc_mcu7t5v0__fill_2
XFILLER_37_240 VDD VDD VSS VSS gf180mcu_fd_sc_mcu7t5v0__fill_1
XFILLER_37_36 VDD VDD VSS VSS gf180mcu_fd_sc_mcu7t5v0__fillcap_4
XFILLER_37_48 VDD VDD VSS VSS gf180mcu_fd_sc_mcu7t5v0__fillcap_16
XFILLER_37_64 VDD VDD VSS VSS gf180mcu_fd_sc_mcu7t5v0__fillcap_4
XFILLER_37_68 VDD VDD VSS VSS gf180mcu_fd_sc_mcu7t5v0__fill_2
XFILLER_37_72 VDD VDD VSS VSS gf180mcu_fd_sc_mcu7t5v0__fill_2
XFILLER_37_74 VDD VDD VSS VSS gf180mcu_fd_sc_mcu7t5v0__fill_1
XFILLER_37_95 VDD VDD VSS VSS gf180mcu_fd_sc_mcu7t5v0__fillcap_4
XFILLER_38_164 VDD VDD VSS VSS gf180mcu_fd_sc_mcu7t5v0__fill_1
XFILLER_38_2 VDD VDD VSS VSS gf180mcu_fd_sc_mcu7t5v0__fillcap_4
XFILLER_38_247 VDD VDD VSS VSS gf180mcu_fd_sc_mcu7t5v0__fillcap_16
XFILLER_38_263 VDD VDD VSS VSS gf180mcu_fd_sc_mcu7t5v0__fillcap_8
XFILLER_38_29 VDD VDD VSS VSS gf180mcu_fd_sc_mcu7t5v0__fillcap_4
XFILLER_38_33 VDD VDD VSS VSS gf180mcu_fd_sc_mcu7t5v0__fill_2
XFILLER_38_37 VDD VDD VSS VSS gf180mcu_fd_sc_mcu7t5v0__fill_2
XFILLER_38_39 VDD VDD VSS VSS gf180mcu_fd_sc_mcu7t5v0__fill_1
XFILLER_38_54 VDD VDD VSS VSS gf180mcu_fd_sc_mcu7t5v0__fillcap_8
XFILLER_38_6 VDD VDD VSS VSS gf180mcu_fd_sc_mcu7t5v0__fill_2
XFILLER_38_62 VDD VDD VSS VSS gf180mcu_fd_sc_mcu7t5v0__fill_1
XFILLER_38_8 VDD VDD VSS VSS gf180mcu_fd_sc_mcu7t5v0__fill_1
XFILLER_38_95 VDD VDD VSS VSS gf180mcu_fd_sc_mcu7t5v0__fill_2
XFILLER_39_142 VDD VDD VSS VSS gf180mcu_fd_sc_mcu7t5v0__fill_2
XFILLER_39_144 VDD VDD VSS VSS gf180mcu_fd_sc_mcu7t5v0__fill_1
XFILLER_39_169 VDD VDD VSS VSS gf180mcu_fd_sc_mcu7t5v0__fill_2
XFILLER_39_171 VDD VDD VSS VSS gf180mcu_fd_sc_mcu7t5v0__fill_1
XFILLER_39_227 VDD VDD VSS VSS gf180mcu_fd_sc_mcu7t5v0__fill_2
XFILLER_39_229 VDD VDD VSS VSS gf180mcu_fd_sc_mcu7t5v0__fill_1
XFILLER_39_36 VDD VDD VSS VSS gf180mcu_fd_sc_mcu7t5v0__fill_2
XFILLER_39_46 VDD VDD VSS VSS gf180mcu_fd_sc_mcu7t5v0__fill_2
XFILLER_39_48 VDD VDD VSS VSS gf180mcu_fd_sc_mcu7t5v0__fill_1
XFILLER_39_57 VDD VDD VSS VSS gf180mcu_fd_sc_mcu7t5v0__fill_1
XFILLER_39_63 VDD VDD VSS VSS gf180mcu_fd_sc_mcu7t5v0__fill_2
XFILLER_39_65 VDD VDD VSS VSS gf180mcu_fd_sc_mcu7t5v0__fill_1
XFILLER_39_72 VDD VDD VSS VSS gf180mcu_fd_sc_mcu7t5v0__fill_2
XFILLER_39_74 VDD VDD VSS VSS gf180mcu_fd_sc_mcu7t5v0__fill_1
XFILLER_39_91 VDD VDD VSS VSS gf180mcu_fd_sc_mcu7t5v0__fill_2
XFILLER_3_139 VDD VDD VSS VSS gf180mcu_fd_sc_mcu7t5v0__fill_1
XFILLER_3_274 VDD VDD VSS VSS gf180mcu_fd_sc_mcu7t5v0__fill_2
XFILLER_3_276 VDD VDD VSS VSS gf180mcu_fd_sc_mcu7t5v0__fill_1
XFILLER_3_77 VDD VDD VSS VSS gf180mcu_fd_sc_mcu7t5v0__fill_1
XFILLER_40_104 VDD VDD VSS VSS gf180mcu_fd_sc_mcu7t5v0__fill_1
XFILLER_40_149 VDD VDD VSS VSS gf180mcu_fd_sc_mcu7t5v0__fillcap_4
XFILLER_40_161 VDD VDD VSS VSS gf180mcu_fd_sc_mcu7t5v0__fill_2
XFILLER_40_171 VDD VDD VSS VSS gf180mcu_fd_sc_mcu7t5v0__fillcap_4
XFILLER_40_177 VDD VDD VSS VSS gf180mcu_fd_sc_mcu7t5v0__fillcap_16
XFILLER_40_18 VDD VDD VSS VSS gf180mcu_fd_sc_mcu7t5v0__fillcap_8
XFILLER_40_193 VDD VDD VSS VSS gf180mcu_fd_sc_mcu7t5v0__fill_2
XFILLER_40_195 VDD VDD VSS VSS gf180mcu_fd_sc_mcu7t5v0__fill_1
XFILLER_40_2 VDD VDD VSS VSS gf180mcu_fd_sc_mcu7t5v0__fillcap_8
XFILLER_40_230 VDD VDD VSS VSS gf180mcu_fd_sc_mcu7t5v0__fill_1
XFILLER_40_255 VDD VDD VSS VSS gf180mcu_fd_sc_mcu7t5v0__fillcap_16
XFILLER_40_26 VDD VDD VSS VSS gf180mcu_fd_sc_mcu7t5v0__fillcap_4
XFILLER_40_71 VDD VDD VSS VSS gf180mcu_fd_sc_mcu7t5v0__fill_2
XFILLER_41_10 VDD VDD VSS VSS gf180mcu_fd_sc_mcu7t5v0__fillcap_4
XFILLER_41_106 VDD VDD VSS VSS gf180mcu_fd_sc_mcu7t5v0__fill_2
XFILLER_41_126 VDD VDD VSS VSS gf180mcu_fd_sc_mcu7t5v0__fillcap_4
XFILLER_41_130 VDD VDD VSS VSS gf180mcu_fd_sc_mcu7t5v0__fill_2
XFILLER_41_132 VDD VDD VSS VSS gf180mcu_fd_sc_mcu7t5v0__fill_1
XFILLER_41_137 VDD VDD VSS VSS gf180mcu_fd_sc_mcu7t5v0__fill_2
XFILLER_41_139 VDD VDD VSS VSS gf180mcu_fd_sc_mcu7t5v0__fill_1
XFILLER_41_14 VDD VDD VSS VSS gf180mcu_fd_sc_mcu7t5v0__fill_1
XFILLER_41_142 VDD VDD VSS VSS gf180mcu_fd_sc_mcu7t5v0__fillcap_4
XFILLER_41_146 VDD VDD VSS VSS gf180mcu_fd_sc_mcu7t5v0__fill_2
XFILLER_41_153 VDD VDD VSS VSS gf180mcu_fd_sc_mcu7t5v0__fillcap_8
XFILLER_41_169 VDD VDD VSS VSS gf180mcu_fd_sc_mcu7t5v0__fillcap_4
XFILLER_41_173 VDD VDD VSS VSS gf180mcu_fd_sc_mcu7t5v0__fill_2
XFILLER_41_175 VDD VDD VSS VSS gf180mcu_fd_sc_mcu7t5v0__fill_1
XFILLER_41_2 VDD VDD VSS VSS gf180mcu_fd_sc_mcu7t5v0__fillcap_8
XFILLER_41_212 VDD VDD VSS VSS gf180mcu_fd_sc_mcu7t5v0__fill_2
XFILLER_41_238 VDD VDD VSS VSS gf180mcu_fd_sc_mcu7t5v0__fill_2
XFILLER_41_240 VDD VDD VSS VSS gf180mcu_fd_sc_mcu7t5v0__fill_1
XFILLER_41_25 VDD VDD VSS VSS gf180mcu_fd_sc_mcu7t5v0__fill_2
XFILLER_41_69 VDD VDD VSS VSS gf180mcu_fd_sc_mcu7t5v0__fill_1
XFILLER_41_72 VDD VDD VSS VSS gf180mcu_fd_sc_mcu7t5v0__fill_1
XFILLER_41_77 VDD VDD VSS VSS gf180mcu_fd_sc_mcu7t5v0__fillcap_4
XFILLER_41_81 VDD VDD VSS VSS gf180mcu_fd_sc_mcu7t5v0__fill_1
XFILLER_41_90 VDD VDD VSS VSS gf180mcu_fd_sc_mcu7t5v0__fillcap_16
XFILLER_42_10 VDD VDD VSS VSS gf180mcu_fd_sc_mcu7t5v0__fillcap_4
XFILLER_42_100 VDD VDD VSS VSS gf180mcu_fd_sc_mcu7t5v0__fill_1
XFILLER_42_107 VDD VDD VSS VSS gf180mcu_fd_sc_mcu7t5v0__fill_2
XFILLER_42_114 VDD VDD VSS VSS gf180mcu_fd_sc_mcu7t5v0__fill_2
XFILLER_42_130 VDD VDD VSS VSS gf180mcu_fd_sc_mcu7t5v0__fillcap_8
XFILLER_42_138 VDD VDD VSS VSS gf180mcu_fd_sc_mcu7t5v0__fill_1
XFILLER_42_14 VDD VDD VSS VSS gf180mcu_fd_sc_mcu7t5v0__fill_2
XFILLER_42_146 VDD VDD VSS VSS gf180mcu_fd_sc_mcu7t5v0__fillcap_16
XFILLER_42_16 VDD VDD VSS VSS gf180mcu_fd_sc_mcu7t5v0__fill_1
XFILLER_42_162 VDD VDD VSS VSS gf180mcu_fd_sc_mcu7t5v0__fillcap_8
XFILLER_42_170 VDD VDD VSS VSS gf180mcu_fd_sc_mcu7t5v0__fillcap_4
XFILLER_42_174 VDD VDD VSS VSS gf180mcu_fd_sc_mcu7t5v0__fill_1
XFILLER_42_177 VDD VDD VSS VSS gf180mcu_fd_sc_mcu7t5v0__fill_2
XFILLER_42_179 VDD VDD VSS VSS gf180mcu_fd_sc_mcu7t5v0__fill_1
XFILLER_42_196 VDD VDD VSS VSS gf180mcu_fd_sc_mcu7t5v0__fillcap_4
XFILLER_42_2 VDD VDD VSS VSS gf180mcu_fd_sc_mcu7t5v0__fillcap_8
XFILLER_42_234 VDD VDD VSS VSS gf180mcu_fd_sc_mcu7t5v0__fill_2
XFILLER_42_236 VDD VDD VSS VSS gf180mcu_fd_sc_mcu7t5v0__fill_1
XFILLER_42_251 VDD VDD VSS VSS gf180mcu_fd_sc_mcu7t5v0__fillcap_16
XFILLER_42_267 VDD VDD VSS VSS gf180mcu_fd_sc_mcu7t5v0__fillcap_4
XFILLER_42_37 VDD VDD VSS VSS gf180mcu_fd_sc_mcu7t5v0__fillcap_4
XFILLER_42_41 VDD VDD VSS VSS gf180mcu_fd_sc_mcu7t5v0__fill_2
XFILLER_42_43 VDD VDD VSS VSS gf180mcu_fd_sc_mcu7t5v0__fill_1
XFILLER_42_78 VDD VDD VSS VSS gf180mcu_fd_sc_mcu7t5v0__fillcap_16
XFILLER_42_94 VDD VDD VSS VSS gf180mcu_fd_sc_mcu7t5v0__fillcap_4
XFILLER_42_98 VDD VDD VSS VSS gf180mcu_fd_sc_mcu7t5v0__fill_2
XFILLER_43_101 VDD VDD VSS VSS gf180mcu_fd_sc_mcu7t5v0__fill_1
XFILLER_43_122 VDD VDD VSS VSS gf180mcu_fd_sc_mcu7t5v0__fillcap_16
XFILLER_43_138 VDD VDD VSS VSS gf180mcu_fd_sc_mcu7t5v0__fill_2
XFILLER_43_142 VDD VDD VSS VSS gf180mcu_fd_sc_mcu7t5v0__fill_2
XFILLER_43_144 VDD VDD VSS VSS gf180mcu_fd_sc_mcu7t5v0__fill_1
XFILLER_43_150 VDD VDD VSS VSS gf180mcu_fd_sc_mcu7t5v0__fillcap_8
XFILLER_43_158 VDD VDD VSS VSS gf180mcu_fd_sc_mcu7t5v0__fillcap_4
XFILLER_43_2 VDD VDD VSS VSS gf180mcu_fd_sc_mcu7t5v0__fillcap_4
XFILLER_43_204 VDD VDD VSS VSS gf180mcu_fd_sc_mcu7t5v0__fillcap_4
XFILLER_43_208 VDD VDD VSS VSS gf180mcu_fd_sc_mcu7t5v0__fill_2
XFILLER_43_212 VDD VDD VSS VSS gf180mcu_fd_sc_mcu7t5v0__fillcap_4
XFILLER_43_41 VDD VDD VSS VSS gf180mcu_fd_sc_mcu7t5v0__fillcap_4
XFILLER_43_45 VDD VDD VSS VSS gf180mcu_fd_sc_mcu7t5v0__fill_2
XFILLER_43_47 VDD VDD VSS VSS gf180mcu_fd_sc_mcu7t5v0__fill_1
XFILLER_43_6 VDD VDD VSS VSS gf180mcu_fd_sc_mcu7t5v0__fill_1
XFILLER_43_63 VDD VDD VSS VSS gf180mcu_fd_sc_mcu7t5v0__fillcap_4
XFILLER_43_67 VDD VDD VSS VSS gf180mcu_fd_sc_mcu7t5v0__fill_2
XFILLER_43_69 VDD VDD VSS VSS gf180mcu_fd_sc_mcu7t5v0__fill_1
XFILLER_43_72 VDD VDD VSS VSS gf180mcu_fd_sc_mcu7t5v0__fillcap_4
XFILLER_43_76 VDD VDD VSS VSS gf180mcu_fd_sc_mcu7t5v0__fill_1
XFILLER_43_92 VDD VDD VSS VSS gf180mcu_fd_sc_mcu7t5v0__fillcap_4
XFILLER_44_102 VDD VDD VSS VSS gf180mcu_fd_sc_mcu7t5v0__fill_2
XFILLER_44_104 VDD VDD VSS VSS gf180mcu_fd_sc_mcu7t5v0__fill_1
XFILLER_44_131 VDD VDD VSS VSS gf180mcu_fd_sc_mcu7t5v0__fill_2
XFILLER_44_133 VDD VDD VSS VSS gf180mcu_fd_sc_mcu7t5v0__fill_1
XFILLER_44_139 VDD VDD VSS VSS gf180mcu_fd_sc_mcu7t5v0__fill_2
XFILLER_44_177 VDD VDD VSS VSS gf180mcu_fd_sc_mcu7t5v0__fillcap_32
XFILLER_44_2 VDD VDD VSS VSS gf180mcu_fd_sc_mcu7t5v0__fillcap_32
XFILLER_44_247 VDD VDD VSS VSS gf180mcu_fd_sc_mcu7t5v0__fillcap_16
XFILLER_44_263 VDD VDD VSS VSS gf180mcu_fd_sc_mcu7t5v0__fill_2
XFILLER_44_34 VDD VDD VSS VSS gf180mcu_fd_sc_mcu7t5v0__fill_1
XFILLER_44_37 VDD VDD VSS VSS gf180mcu_fd_sc_mcu7t5v0__fillcap_8
XFILLER_44_45 VDD VDD VSS VSS gf180mcu_fd_sc_mcu7t5v0__fillcap_4
XFILLER_44_49 VDD VDD VSS VSS gf180mcu_fd_sc_mcu7t5v0__fill_1
XFILLER_44_64 VDD VDD VSS VSS gf180mcu_fd_sc_mcu7t5v0__fillcap_4
XFILLER_45_136 VDD VDD VSS VSS gf180mcu_fd_sc_mcu7t5v0__fillcap_4
XFILLER_45_162 VDD VDD VSS VSS gf180mcu_fd_sc_mcu7t5v0__fill_1
XFILLER_45_18 VDD VDD VSS VSS gf180mcu_fd_sc_mcu7t5v0__fillcap_4
XFILLER_45_199 VDD VDD VSS VSS gf180mcu_fd_sc_mcu7t5v0__fillcap_8
XFILLER_45_2 VDD VDD VSS VSS gf180mcu_fd_sc_mcu7t5v0__fillcap_16
XFILLER_45_207 VDD VDD VSS VSS gf180mcu_fd_sc_mcu7t5v0__fill_2
XFILLER_45_209 VDD VDD VSS VSS gf180mcu_fd_sc_mcu7t5v0__fill_1
XFILLER_45_212 VDD VDD VSS VSS gf180mcu_fd_sc_mcu7t5v0__fillcap_16
XFILLER_45_22 VDD VDD VSS VSS gf180mcu_fd_sc_mcu7t5v0__fill_1
XFILLER_45_228 VDD VDD VSS VSS gf180mcu_fd_sc_mcu7t5v0__fill_2
XFILLER_45_230 VDD VDD VSS VSS gf180mcu_fd_sc_mcu7t5v0__fill_1
XFILLER_45_235 VDD VDD VSS VSS gf180mcu_fd_sc_mcu7t5v0__fillcap_4
XFILLER_45_239 VDD VDD VSS VSS gf180mcu_fd_sc_mcu7t5v0__fill_2
XFILLER_45_29 VDD VDD VSS VSS gf180mcu_fd_sc_mcu7t5v0__fillcap_4
XFILLER_45_33 VDD VDD VSS VSS gf180mcu_fd_sc_mcu7t5v0__fill_2
XFILLER_45_35 VDD VDD VSS VSS gf180mcu_fd_sc_mcu7t5v0__fill_1
XFILLER_45_72 VDD VDD VSS VSS gf180mcu_fd_sc_mcu7t5v0__fill_1
XFILLER_46_107 VDD VDD VSS VSS gf180mcu_fd_sc_mcu7t5v0__fill_2
XFILLER_46_158 VDD VDD VSS VSS gf180mcu_fd_sc_mcu7t5v0__fillcap_16
XFILLER_46_174 VDD VDD VSS VSS gf180mcu_fd_sc_mcu7t5v0__fill_1
XFILLER_46_177 VDD VDD VSS VSS gf180mcu_fd_sc_mcu7t5v0__fillcap_8
XFILLER_46_18 VDD VDD VSS VSS gf180mcu_fd_sc_mcu7t5v0__fillcap_4
XFILLER_46_185 VDD VDD VSS VSS gf180mcu_fd_sc_mcu7t5v0__fill_2
XFILLER_46_196 VDD VDD VSS VSS gf180mcu_fd_sc_mcu7t5v0__fill_1
XFILLER_46_2 VDD VDD VSS VSS gf180mcu_fd_sc_mcu7t5v0__fillcap_8
XFILLER_46_22 VDD VDD VSS VSS gf180mcu_fd_sc_mcu7t5v0__fill_1
XFILLER_46_256 VDD VDD VSS VSS gf180mcu_fd_sc_mcu7t5v0__fillcap_8
XFILLER_46_264 VDD VDD VSS VSS gf180mcu_fd_sc_mcu7t5v0__fillcap_4
XFILLER_46_268 VDD VDD VSS VSS gf180mcu_fd_sc_mcu7t5v0__fill_2
XFILLER_46_27 VDD VDD VSS VSS gf180mcu_fd_sc_mcu7t5v0__fillcap_8
XFILLER_46_270 VDD VDD VSS VSS gf180mcu_fd_sc_mcu7t5v0__fill_1
XFILLER_46_37 VDD VDD VSS VSS gf180mcu_fd_sc_mcu7t5v0__fillcap_16
XFILLER_46_53 VDD VDD VSS VSS gf180mcu_fd_sc_mcu7t5v0__fillcap_8
XFILLER_46_61 VDD VDD VSS VSS gf180mcu_fd_sc_mcu7t5v0__fillcap_4
XFILLER_46_65 VDD VDD VSS VSS gf180mcu_fd_sc_mcu7t5v0__fill_1
XFILLER_47_110 VDD VDD VSS VSS gf180mcu_fd_sc_mcu7t5v0__fill_1
XFILLER_47_212 VDD VDD VSS VSS gf180mcu_fd_sc_mcu7t5v0__fillcap_8
XFILLER_47_220 VDD VDD VSS VSS gf180mcu_fd_sc_mcu7t5v0__fillcap_4
XFILLER_47_224 VDD VDD VSS VSS gf180mcu_fd_sc_mcu7t5v0__fill_1
XFILLER_47_36 VDD VDD VSS VSS gf180mcu_fd_sc_mcu7t5v0__fillcap_16
XFILLER_47_52 VDD VDD VSS VSS gf180mcu_fd_sc_mcu7t5v0__fillcap_8
XFILLER_48_107 VDD VDD VSS VSS gf180mcu_fd_sc_mcu7t5v0__fillcap_4
XFILLER_48_125 VDD VDD VSS VSS gf180mcu_fd_sc_mcu7t5v0__fill_1
XFILLER_48_140 VDD VDD VSS VSS gf180mcu_fd_sc_mcu7t5v0__fill_1
XFILLER_48_2 VDD VDD VSS VSS gf180mcu_fd_sc_mcu7t5v0__fill_2
XFILLER_48_252 VDD VDD VSS VSS gf180mcu_fd_sc_mcu7t5v0__fillcap_16
XFILLER_48_268 VDD VDD VSS VSS gf180mcu_fd_sc_mcu7t5v0__fill_2
XFILLER_48_270 VDD VDD VSS VSS gf180mcu_fd_sc_mcu7t5v0__fill_1
XFILLER_48_42 VDD VDD VSS VSS gf180mcu_fd_sc_mcu7t5v0__fill_2
XFILLER_48_44 VDD VDD VSS VSS gf180mcu_fd_sc_mcu7t5v0__fill_1
XFILLER_48_95 VDD VDD VSS VSS gf180mcu_fd_sc_mcu7t5v0__fill_2
XFILLER_49_139 VDD VDD VSS VSS gf180mcu_fd_sc_mcu7t5v0__fill_1
XFILLER_49_142 VDD VDD VSS VSS gf180mcu_fd_sc_mcu7t5v0__fill_2
XFILLER_49_187 VDD VDD VSS VSS gf180mcu_fd_sc_mcu7t5v0__fillcap_4
XFILLER_49_191 VDD VDD VSS VSS gf180mcu_fd_sc_mcu7t5v0__fill_2
XFILLER_49_193 VDD VDD VSS VSS gf180mcu_fd_sc_mcu7t5v0__fill_1
XFILLER_49_208 VDD VDD VSS VSS gf180mcu_fd_sc_mcu7t5v0__fill_2
XFILLER_49_212 VDD VDD VSS VSS gf180mcu_fd_sc_mcu7t5v0__fillcap_16
XFILLER_49_228 VDD VDD VSS VSS gf180mcu_fd_sc_mcu7t5v0__fill_2
XFILLER_49_230 VDD VDD VSS VSS gf180mcu_fd_sc_mcu7t5v0__fill_1
XFILLER_49_72 VDD VDD VSS VSS gf180mcu_fd_sc_mcu7t5v0__fillcap_4
XFILLER_49_84 VDD VDD VSS VSS gf180mcu_fd_sc_mcu7t5v0__fill_2
XFILLER_49_86 VDD VDD VSS VSS gf180mcu_fd_sc_mcu7t5v0__fill_1
XFILLER_4_10 VDD VDD VSS VSS gf180mcu_fd_sc_mcu7t5v0__fill_2
XFILLER_4_113 VDD VDD VSS VSS gf180mcu_fd_sc_mcu7t5v0__fillcap_8
XFILLER_4_121 VDD VDD VSS VSS gf180mcu_fd_sc_mcu7t5v0__fill_1
XFILLER_4_166 VDD VDD VSS VSS gf180mcu_fd_sc_mcu7t5v0__fill_1
XFILLER_4_177 VDD VDD VSS VSS gf180mcu_fd_sc_mcu7t5v0__fillcap_4
XFILLER_4_181 VDD VDD VSS VSS gf180mcu_fd_sc_mcu7t5v0__fill_2
XFILLER_4_2 VDD VDD VSS VSS gf180mcu_fd_sc_mcu7t5v0__fillcap_8
XFILLER_4_241 VDD VDD VSS VSS gf180mcu_fd_sc_mcu7t5v0__fillcap_4
XFILLER_4_260 VDD VDD VSS VSS gf180mcu_fd_sc_mcu7t5v0__fillcap_8
XFILLER_4_268 VDD VDD VSS VSS gf180mcu_fd_sc_mcu7t5v0__fill_2
XFILLER_4_27 VDD VDD VSS VSS gf180mcu_fd_sc_mcu7t5v0__fillcap_8
XFILLER_4_270 VDD VDD VSS VSS gf180mcu_fd_sc_mcu7t5v0__fill_1
XFILLER_4_71 VDD VDD VSS VSS gf180mcu_fd_sc_mcu7t5v0__fill_2
XFILLER_4_86 VDD VDD VSS VSS gf180mcu_fd_sc_mcu7t5v0__fill_1
XFILLER_50_177 VDD VDD VSS VSS gf180mcu_fd_sc_mcu7t5v0__fill_2
XFILLER_50_193 VDD VDD VSS VSS gf180mcu_fd_sc_mcu7t5v0__fill_1
XFILLER_50_2 VDD VDD VSS VSS gf180mcu_fd_sc_mcu7t5v0__fillcap_4
XFILLER_50_202 VDD VDD VSS VSS gf180mcu_fd_sc_mcu7t5v0__fillcap_4
XFILLER_50_206 VDD VDD VSS VSS gf180mcu_fd_sc_mcu7t5v0__fill_2
XFILLER_50_208 VDD VDD VSS VSS gf180mcu_fd_sc_mcu7t5v0__fill_1
XFILLER_50_247 VDD VDD VSS VSS gf180mcu_fd_sc_mcu7t5v0__fillcap_16
XFILLER_50_263 VDD VDD VSS VSS gf180mcu_fd_sc_mcu7t5v0__fillcap_8
XFILLER_50_44 VDD VDD VSS VSS gf180mcu_fd_sc_mcu7t5v0__fill_2
XFILLER_50_46 VDD VDD VSS VSS gf180mcu_fd_sc_mcu7t5v0__fill_1
XFILLER_51_105 VDD VDD VSS VSS gf180mcu_fd_sc_mcu7t5v0__fill_1
XFILLER_51_2 VDD VDD VSS VSS gf180mcu_fd_sc_mcu7t5v0__fill_1
XFILLER_51_220 VDD VDD VSS VSS gf180mcu_fd_sc_mcu7t5v0__fillcap_16
XFILLER_51_236 VDD VDD VSS VSS gf180mcu_fd_sc_mcu7t5v0__fill_1
XFILLER_51_96 VDD VDD VSS VSS gf180mcu_fd_sc_mcu7t5v0__fillcap_4
XFILLER_52_107 VDD VDD VSS VSS gf180mcu_fd_sc_mcu7t5v0__fillcap_16
XFILLER_52_123 VDD VDD VSS VSS gf180mcu_fd_sc_mcu7t5v0__fill_2
XFILLER_52_130 VDD VDD VSS VSS gf180mcu_fd_sc_mcu7t5v0__fill_1
XFILLER_52_193 VDD VDD VSS VSS gf180mcu_fd_sc_mcu7t5v0__fill_1
XFILLER_52_196 VDD VDD VSS VSS gf180mcu_fd_sc_mcu7t5v0__fillcap_8
XFILLER_52_2 VDD VDD VSS VSS gf180mcu_fd_sc_mcu7t5v0__fill_1
XFILLER_52_204 VDD VDD VSS VSS gf180mcu_fd_sc_mcu7t5v0__fillcap_4
XFILLER_52_208 VDD VDD VSS VSS gf180mcu_fd_sc_mcu7t5v0__fill_1
XFILLER_52_247 VDD VDD VSS VSS gf180mcu_fd_sc_mcu7t5v0__fillcap_16
XFILLER_52_263 VDD VDD VSS VSS gf180mcu_fd_sc_mcu7t5v0__fillcap_8
XFILLER_53_137 VDD VDD VSS VSS gf180mcu_fd_sc_mcu7t5v0__fill_2
XFILLER_53_139 VDD VDD VSS VSS gf180mcu_fd_sc_mcu7t5v0__fill_1
XFILLER_53_186 VDD VDD VSS VSS gf180mcu_fd_sc_mcu7t5v0__fill_2
XFILLER_53_212 VDD VDD VSS VSS gf180mcu_fd_sc_mcu7t5v0__fillcap_4
XFILLER_53_216 VDD VDD VSS VSS gf180mcu_fd_sc_mcu7t5v0__fill_2
XFILLER_53_222 VDD VDD VSS VSS gf180mcu_fd_sc_mcu7t5v0__fillcap_16
XFILLER_53_238 VDD VDD VSS VSS gf180mcu_fd_sc_mcu7t5v0__fill_2
XFILLER_53_240 VDD VDD VSS VSS gf180mcu_fd_sc_mcu7t5v0__fill_1
XFILLER_54_177 VDD VDD VSS VSS gf180mcu_fd_sc_mcu7t5v0__fill_2
XFILLER_54_183 VDD VDD VSS VSS gf180mcu_fd_sc_mcu7t5v0__fillcap_16
XFILLER_54_199 VDD VDD VSS VSS gf180mcu_fd_sc_mcu7t5v0__fillcap_8
XFILLER_54_2 VDD VDD VSS VSS gf180mcu_fd_sc_mcu7t5v0__fill_1
XFILLER_54_207 VDD VDD VSS VSS gf180mcu_fd_sc_mcu7t5v0__fill_2
XFILLER_54_247 VDD VDD VSS VSS gf180mcu_fd_sc_mcu7t5v0__fillcap_16
XFILLER_54_263 VDD VDD VSS VSS gf180mcu_fd_sc_mcu7t5v0__fillcap_8
XFILLER_54_34 VDD VDD VSS VSS gf180mcu_fd_sc_mcu7t5v0__fill_1
XFILLER_54_37 VDD VDD VSS VSS gf180mcu_fd_sc_mcu7t5v0__fill_2
XFILLER_54_39 VDD VDD VSS VSS gf180mcu_fd_sc_mcu7t5v0__fill_1
XFILLER_54_9 VDD VDD VSS VSS gf180mcu_fd_sc_mcu7t5v0__fill_2
XFILLER_54_90 VDD VDD VSS VSS gf180mcu_fd_sc_mcu7t5v0__fill_1
XFILLER_55_142 VDD VDD VSS VSS gf180mcu_fd_sc_mcu7t5v0__fill_2
XFILLER_55_180 VDD VDD VSS VSS gf180mcu_fd_sc_mcu7t5v0__fillcap_16
XFILLER_55_196 VDD VDD VSS VSS gf180mcu_fd_sc_mcu7t5v0__fill_2
XFILLER_55_202 VDD VDD VSS VSS gf180mcu_fd_sc_mcu7t5v0__fillcap_4
XFILLER_55_212 VDD VDD VSS VSS gf180mcu_fd_sc_mcu7t5v0__fill_2
XFILLER_55_218 VDD VDD VSS VSS gf180mcu_fd_sc_mcu7t5v0__fillcap_16
XFILLER_55_234 VDD VDD VSS VSS gf180mcu_fd_sc_mcu7t5v0__fill_2
XFILLER_55_240 VDD VDD VSS VSS gf180mcu_fd_sc_mcu7t5v0__fill_1
XFILLER_56_11 VDD VDD VSS VSS gf180mcu_fd_sc_mcu7t5v0__fillcap_16
XFILLER_56_112 VDD VDD VSS VSS gf180mcu_fd_sc_mcu7t5v0__fill_2
XFILLER_56_114 VDD VDD VSS VSS gf180mcu_fd_sc_mcu7t5v0__fill_1
XFILLER_56_159 VDD VDD VSS VSS gf180mcu_fd_sc_mcu7t5v0__fill_1
XFILLER_56_174 VDD VDD VSS VSS gf180mcu_fd_sc_mcu7t5v0__fill_1
XFILLER_56_177 VDD VDD VSS VSS gf180mcu_fd_sc_mcu7t5v0__fillcap_4
XFILLER_56_195 VDD VDD VSS VSS gf180mcu_fd_sc_mcu7t5v0__fillcap_8
XFILLER_56_2 VDD VDD VSS VSS gf180mcu_fd_sc_mcu7t5v0__fill_2
XFILLER_56_203 VDD VDD VSS VSS gf180mcu_fd_sc_mcu7t5v0__fillcap_4
XFILLER_56_207 VDD VDD VSS VSS gf180mcu_fd_sc_mcu7t5v0__fill_2
XFILLER_56_247 VDD VDD VSS VSS gf180mcu_fd_sc_mcu7t5v0__fillcap_16
XFILLER_56_263 VDD VDD VSS VSS gf180mcu_fd_sc_mcu7t5v0__fill_2
XFILLER_56_27 VDD VDD VSS VSS gf180mcu_fd_sc_mcu7t5v0__fillcap_4
XFILLER_56_4 VDD VDD VSS VSS gf180mcu_fd_sc_mcu7t5v0__fill_1
XFILLER_57_110 VDD VDD VSS VSS gf180mcu_fd_sc_mcu7t5v0__fill_1
XFILLER_57_119 VDD VDD VSS VSS gf180mcu_fd_sc_mcu7t5v0__fillcap_8
XFILLER_57_127 VDD VDD VSS VSS gf180mcu_fd_sc_mcu7t5v0__fill_2
XFILLER_57_129 VDD VDD VSS VSS gf180mcu_fd_sc_mcu7t5v0__fill_1
XFILLER_57_138 VDD VDD VSS VSS gf180mcu_fd_sc_mcu7t5v0__fill_1
XFILLER_57_149 VDD VDD VSS VSS gf180mcu_fd_sc_mcu7t5v0__fillcap_8
XFILLER_57_157 VDD VDD VSS VSS gf180mcu_fd_sc_mcu7t5v0__fillcap_4
XFILLER_57_161 VDD VDD VSS VSS gf180mcu_fd_sc_mcu7t5v0__fill_1
XFILLER_57_18 VDD VDD VSS VSS gf180mcu_fd_sc_mcu7t5v0__fillcap_8
XFILLER_57_2 VDD VDD VSS VSS gf180mcu_fd_sc_mcu7t5v0__fillcap_16
XFILLER_57_203 VDD VDD VSS VSS gf180mcu_fd_sc_mcu7t5v0__fill_1
XFILLER_57_206 VDD VDD VSS VSS gf180mcu_fd_sc_mcu7t5v0__fillcap_8
XFILLER_57_214 VDD VDD VSS VSS gf180mcu_fd_sc_mcu7t5v0__fill_2
XFILLER_57_216 VDD VDD VSS VSS gf180mcu_fd_sc_mcu7t5v0__fill_1
XFILLER_57_223 VDD VDD VSS VSS gf180mcu_fd_sc_mcu7t5v0__fillcap_8
XFILLER_57_231 VDD VDD VSS VSS gf180mcu_fd_sc_mcu7t5v0__fillcap_4
XFILLER_57_235 VDD VDD VSS VSS gf180mcu_fd_sc_mcu7t5v0__fill_2
XFILLER_57_237 VDD VDD VSS VSS gf180mcu_fd_sc_mcu7t5v0__fill_1
XFILLER_57_240 VDD VDD VSS VSS gf180mcu_fd_sc_mcu7t5v0__fill_2
XFILLER_57_242 VDD VDD VSS VSS gf180mcu_fd_sc_mcu7t5v0__fill_1
XFILLER_57_249 VDD VDD VSS VSS gf180mcu_fd_sc_mcu7t5v0__fillcap_4
XFILLER_57_253 VDD VDD VSS VSS gf180mcu_fd_sc_mcu7t5v0__fill_1
XFILLER_57_274 VDD VDD VSS VSS gf180mcu_fd_sc_mcu7t5v0__fill_2
XFILLER_57_276 VDD VDD VSS VSS gf180mcu_fd_sc_mcu7t5v0__fill_1
XFILLER_57_64 VDD VDD VSS VSS gf180mcu_fd_sc_mcu7t5v0__fill_2
XFILLER_57_70 VDD VDD VSS VSS gf180mcu_fd_sc_mcu7t5v0__fill_1
XFILLER_5_133 VDD VDD VSS VSS gf180mcu_fd_sc_mcu7t5v0__fillcap_4
XFILLER_5_137 VDD VDD VSS VSS gf180mcu_fd_sc_mcu7t5v0__fill_2
XFILLER_5_139 VDD VDD VSS VSS gf180mcu_fd_sc_mcu7t5v0__fill_1
XFILLER_5_142 VDD VDD VSS VSS gf180mcu_fd_sc_mcu7t5v0__fillcap_4
XFILLER_5_146 VDD VDD VSS VSS gf180mcu_fd_sc_mcu7t5v0__fill_1
XFILLER_5_212 VDD VDD VSS VSS gf180mcu_fd_sc_mcu7t5v0__fill_2
XFILLER_5_214 VDD VDD VSS VSS gf180mcu_fd_sc_mcu7t5v0__fill_1
XFILLER_5_76 VDD VDD VSS VSS gf180mcu_fd_sc_mcu7t5v0__fill_1
XFILLER_6_10 VDD VDD VSS VSS gf180mcu_fd_sc_mcu7t5v0__fill_2
XFILLER_6_102 VDD VDD VSS VSS gf180mcu_fd_sc_mcu7t5v0__fill_2
XFILLER_6_104 VDD VDD VSS VSS gf180mcu_fd_sc_mcu7t5v0__fill_1
XFILLER_6_107 VDD VDD VSS VSS gf180mcu_fd_sc_mcu7t5v0__fillcap_16
XFILLER_6_12 VDD VDD VSS VSS gf180mcu_fd_sc_mcu7t5v0__fill_1
XFILLER_6_123 VDD VDD VSS VSS gf180mcu_fd_sc_mcu7t5v0__fillcap_8
XFILLER_6_131 VDD VDD VSS VSS gf180mcu_fd_sc_mcu7t5v0__fill_2
XFILLER_6_133 VDD VDD VSS VSS gf180mcu_fd_sc_mcu7t5v0__fill_1
XFILLER_6_168 VDD VDD VSS VSS gf180mcu_fd_sc_mcu7t5v0__fill_1
XFILLER_6_2 VDD VDD VSS VSS gf180mcu_fd_sc_mcu7t5v0__fillcap_8
XFILLER_6_257 VDD VDD VSS VSS gf180mcu_fd_sc_mcu7t5v0__fillcap_8
XFILLER_6_265 VDD VDD VSS VSS gf180mcu_fd_sc_mcu7t5v0__fillcap_4
XFILLER_6_269 VDD VDD VSS VSS gf180mcu_fd_sc_mcu7t5v0__fill_2
XFILLER_6_28 VDD VDD VSS VSS gf180mcu_fd_sc_mcu7t5v0__fillcap_4
XFILLER_6_32 VDD VDD VSS VSS gf180mcu_fd_sc_mcu7t5v0__fill_2
XFILLER_6_34 VDD VDD VSS VSS gf180mcu_fd_sc_mcu7t5v0__fill_1
XFILLER_6_37 VDD VDD VSS VSS gf180mcu_fd_sc_mcu7t5v0__fillcap_4
XFILLER_6_41 VDD VDD VSS VSS gf180mcu_fd_sc_mcu7t5v0__fill_2
XFILLER_6_51 VDD VDD VSS VSS gf180mcu_fd_sc_mcu7t5v0__fillcap_16
XFILLER_6_67 VDD VDD VSS VSS gf180mcu_fd_sc_mcu7t5v0__fill_2
XFILLER_6_69 VDD VDD VSS VSS gf180mcu_fd_sc_mcu7t5v0__fill_1
XFILLER_6_78 VDD VDD VSS VSS gf180mcu_fd_sc_mcu7t5v0__fillcap_8
XFILLER_6_94 VDD VDD VSS VSS gf180mcu_fd_sc_mcu7t5v0__fillcap_8
XFILLER_7_114 VDD VDD VSS VSS gf180mcu_fd_sc_mcu7t5v0__fillcap_8
XFILLER_7_122 VDD VDD VSS VSS gf180mcu_fd_sc_mcu7t5v0__fill_1
XFILLER_7_240 VDD VDD VSS VSS gf180mcu_fd_sc_mcu7t5v0__fill_1
XFILLER_7_36 VDD VDD VSS VSS gf180mcu_fd_sc_mcu7t5v0__fillcap_8
XFILLER_7_50 VDD VDD VSS VSS gf180mcu_fd_sc_mcu7t5v0__fillcap_8
XFILLER_7_58 VDD VDD VSS VSS gf180mcu_fd_sc_mcu7t5v0__fillcap_4
XFILLER_7_72 VDD VDD VSS VSS gf180mcu_fd_sc_mcu7t5v0__fill_2
XFILLER_7_98 VDD VDD VSS VSS gf180mcu_fd_sc_mcu7t5v0__fillcap_16
XFILLER_8_102 VDD VDD VSS VSS gf180mcu_fd_sc_mcu7t5v0__fill_2
XFILLER_8_104 VDD VDD VSS VSS gf180mcu_fd_sc_mcu7t5v0__fill_1
XFILLER_8_157 VDD VDD VSS VSS gf180mcu_fd_sc_mcu7t5v0__fillcap_8
XFILLER_8_165 VDD VDD VSS VSS gf180mcu_fd_sc_mcu7t5v0__fill_2
XFILLER_8_167 VDD VDD VSS VSS gf180mcu_fd_sc_mcu7t5v0__fill_1
XFILLER_8_195 VDD VDD VSS VSS gf180mcu_fd_sc_mcu7t5v0__fill_2
XFILLER_8_2 VDD VDD VSS VSS gf180mcu_fd_sc_mcu7t5v0__fillcap_32
XFILLER_8_252 VDD VDD VSS VSS gf180mcu_fd_sc_mcu7t5v0__fillcap_16
XFILLER_8_268 VDD VDD VSS VSS gf180mcu_fd_sc_mcu7t5v0__fill_2
XFILLER_8_270 VDD VDD VSS VSS gf180mcu_fd_sc_mcu7t5v0__fill_1
XFILLER_8_34 VDD VDD VSS VSS gf180mcu_fd_sc_mcu7t5v0__fill_1
XFILLER_8_52 VDD VDD VSS VSS gf180mcu_fd_sc_mcu7t5v0__fillcap_8
XFILLER_8_60 VDD VDD VSS VSS gf180mcu_fd_sc_mcu7t5v0__fill_1
XFILLER_8_74 VDD VDD VSS VSS gf180mcu_fd_sc_mcu7t5v0__fillcap_4
XFILLER_8_78 VDD VDD VSS VSS gf180mcu_fd_sc_mcu7t5v0__fill_2
XFILLER_8_80 VDD VDD VSS VSS gf180mcu_fd_sc_mcu7t5v0__fill_1
XFILLER_8_86 VDD VDD VSS VSS gf180mcu_fd_sc_mcu7t5v0__fillcap_16
XFILLER_9_139 VDD VDD VSS VSS gf180mcu_fd_sc_mcu7t5v0__fill_1
XFILLER_9_142 VDD VDD VSS VSS gf180mcu_fd_sc_mcu7t5v0__fillcap_32
XFILLER_9_174 VDD VDD VSS VSS gf180mcu_fd_sc_mcu7t5v0__fill_2
XFILLER_9_18 VDD VDD VSS VSS gf180mcu_fd_sc_mcu7t5v0__fillcap_8
XFILLER_9_2 VDD VDD VSS VSS gf180mcu_fd_sc_mcu7t5v0__fillcap_16
XFILLER_9_240 VDD VDD VSS VSS gf180mcu_fd_sc_mcu7t5v0__fill_1
XFILLER_9_60 VDD VDD VSS VSS gf180mcu_fd_sc_mcu7t5v0__fill_1
XFILLER_9_69 VDD VDD VSS VSS gf180mcu_fd_sc_mcu7t5v0__fill_1
XFILLER_9_95 VDD VDD VSS VSS gf180mcu_fd_sc_mcu7t5v0__fillcap_4
XFILLER_9_99 VDD VDD VSS VSS gf180mcu_fd_sc_mcu7t5v0__fill_2
XPHY_EDGE_ROW_0_Left_58 VDD VDD VSS VSS gf180mcu_fd_sc_mcu7t5v0__endcap
XPHY_EDGE_ROW_0_Right_0 VDD VDD VSS VSS gf180mcu_fd_sc_mcu7t5v0__endcap
XPHY_EDGE_ROW_10_Left_68 VDD VDD VSS VSS gf180mcu_fd_sc_mcu7t5v0__endcap
XPHY_EDGE_ROW_10_Right_10 VDD VDD VSS VSS gf180mcu_fd_sc_mcu7t5v0__endcap
XPHY_EDGE_ROW_11_Left_69 VDD VDD VSS VSS gf180mcu_fd_sc_mcu7t5v0__endcap
XPHY_EDGE_ROW_11_Right_11 VDD VDD VSS VSS gf180mcu_fd_sc_mcu7t5v0__endcap
XPHY_EDGE_ROW_12_Left_70 VDD VDD VSS VSS gf180mcu_fd_sc_mcu7t5v0__endcap
XPHY_EDGE_ROW_12_Right_12 VDD VDD VSS VSS gf180mcu_fd_sc_mcu7t5v0__endcap
XPHY_EDGE_ROW_13_Left_71 VDD VDD VSS VSS gf180mcu_fd_sc_mcu7t5v0__endcap
XPHY_EDGE_ROW_13_Right_13 VDD VDD VSS VSS gf180mcu_fd_sc_mcu7t5v0__endcap
XPHY_EDGE_ROW_14_Left_72 VDD VDD VSS VSS gf180mcu_fd_sc_mcu7t5v0__endcap
XPHY_EDGE_ROW_14_Right_14 VDD VDD VSS VSS gf180mcu_fd_sc_mcu7t5v0__endcap
XPHY_EDGE_ROW_15_Left_73 VDD VDD VSS VSS gf180mcu_fd_sc_mcu7t5v0__endcap
XPHY_EDGE_ROW_15_Right_15 VDD VDD VSS VSS gf180mcu_fd_sc_mcu7t5v0__endcap
XPHY_EDGE_ROW_16_Left_74 VDD VDD VSS VSS gf180mcu_fd_sc_mcu7t5v0__endcap
XPHY_EDGE_ROW_16_Right_16 VDD VDD VSS VSS gf180mcu_fd_sc_mcu7t5v0__endcap
XPHY_EDGE_ROW_17_Left_75 VDD VDD VSS VSS gf180mcu_fd_sc_mcu7t5v0__endcap
XPHY_EDGE_ROW_17_Right_17 VDD VDD VSS VSS gf180mcu_fd_sc_mcu7t5v0__endcap
XPHY_EDGE_ROW_18_Left_76 VDD VDD VSS VSS gf180mcu_fd_sc_mcu7t5v0__endcap
XPHY_EDGE_ROW_18_Right_18 VDD VDD VSS VSS gf180mcu_fd_sc_mcu7t5v0__endcap
XPHY_EDGE_ROW_19_Left_77 VDD VDD VSS VSS gf180mcu_fd_sc_mcu7t5v0__endcap
XPHY_EDGE_ROW_19_Right_19 VDD VDD VSS VSS gf180mcu_fd_sc_mcu7t5v0__endcap
XPHY_EDGE_ROW_1_Left_59 VDD VDD VSS VSS gf180mcu_fd_sc_mcu7t5v0__endcap
XPHY_EDGE_ROW_1_Right_1 VDD VDD VSS VSS gf180mcu_fd_sc_mcu7t5v0__endcap
XPHY_EDGE_ROW_20_Left_78 VDD VDD VSS VSS gf180mcu_fd_sc_mcu7t5v0__endcap
XPHY_EDGE_ROW_20_Right_20 VDD VDD VSS VSS gf180mcu_fd_sc_mcu7t5v0__endcap
XPHY_EDGE_ROW_21_Left_79 VDD VDD VSS VSS gf180mcu_fd_sc_mcu7t5v0__endcap
XPHY_EDGE_ROW_21_Right_21 VDD VDD VSS VSS gf180mcu_fd_sc_mcu7t5v0__endcap
XPHY_EDGE_ROW_22_Left_80 VDD VDD VSS VSS gf180mcu_fd_sc_mcu7t5v0__endcap
XPHY_EDGE_ROW_22_Right_22 VDD VDD VSS VSS gf180mcu_fd_sc_mcu7t5v0__endcap
XPHY_EDGE_ROW_23_Left_81 VDD VDD VSS VSS gf180mcu_fd_sc_mcu7t5v0__endcap
XPHY_EDGE_ROW_23_Right_23 VDD VDD VSS VSS gf180mcu_fd_sc_mcu7t5v0__endcap
XPHY_EDGE_ROW_24_Left_82 VDD VDD VSS VSS gf180mcu_fd_sc_mcu7t5v0__endcap
XPHY_EDGE_ROW_24_Right_24 VDD VDD VSS VSS gf180mcu_fd_sc_mcu7t5v0__endcap
XPHY_EDGE_ROW_25_Left_83 VDD VDD VSS VSS gf180mcu_fd_sc_mcu7t5v0__endcap
XPHY_EDGE_ROW_25_Right_25 VDD VDD VSS VSS gf180mcu_fd_sc_mcu7t5v0__endcap
XPHY_EDGE_ROW_26_Left_84 VDD VDD VSS VSS gf180mcu_fd_sc_mcu7t5v0__endcap
XPHY_EDGE_ROW_26_Right_26 VDD VDD VSS VSS gf180mcu_fd_sc_mcu7t5v0__endcap
XPHY_EDGE_ROW_27_Left_85 VDD VDD VSS VSS gf180mcu_fd_sc_mcu7t5v0__endcap
XPHY_EDGE_ROW_27_Right_27 VDD VDD VSS VSS gf180mcu_fd_sc_mcu7t5v0__endcap
XPHY_EDGE_ROW_28_Left_86 VDD VDD VSS VSS gf180mcu_fd_sc_mcu7t5v0__endcap
XPHY_EDGE_ROW_28_Right_28 VDD VDD VSS VSS gf180mcu_fd_sc_mcu7t5v0__endcap
XPHY_EDGE_ROW_29_Left_87 VDD VDD VSS VSS gf180mcu_fd_sc_mcu7t5v0__endcap
XPHY_EDGE_ROW_29_Right_29 VDD VDD VSS VSS gf180mcu_fd_sc_mcu7t5v0__endcap
XPHY_EDGE_ROW_2_Left_60 VDD VDD VSS VSS gf180mcu_fd_sc_mcu7t5v0__endcap
XPHY_EDGE_ROW_2_Right_2 VDD VDD VSS VSS gf180mcu_fd_sc_mcu7t5v0__endcap
XPHY_EDGE_ROW_30_Left_88 VDD VDD VSS VSS gf180mcu_fd_sc_mcu7t5v0__endcap
XPHY_EDGE_ROW_30_Right_30 VDD VDD VSS VSS gf180mcu_fd_sc_mcu7t5v0__endcap
XPHY_EDGE_ROW_31_Left_89 VDD VDD VSS VSS gf180mcu_fd_sc_mcu7t5v0__endcap
XPHY_EDGE_ROW_31_Right_31 VDD VDD VSS VSS gf180mcu_fd_sc_mcu7t5v0__endcap
XPHY_EDGE_ROW_32_Left_90 VDD VDD VSS VSS gf180mcu_fd_sc_mcu7t5v0__endcap
XPHY_EDGE_ROW_32_Right_32 VDD VDD VSS VSS gf180mcu_fd_sc_mcu7t5v0__endcap
XPHY_EDGE_ROW_33_Left_91 VDD VDD VSS VSS gf180mcu_fd_sc_mcu7t5v0__endcap
XPHY_EDGE_ROW_33_Right_33 VDD VDD VSS VSS gf180mcu_fd_sc_mcu7t5v0__endcap
XPHY_EDGE_ROW_34_Left_92 VDD VDD VSS VSS gf180mcu_fd_sc_mcu7t5v0__endcap
XPHY_EDGE_ROW_34_Right_34 VDD VDD VSS VSS gf180mcu_fd_sc_mcu7t5v0__endcap
XPHY_EDGE_ROW_35_Left_93 VDD VDD VSS VSS gf180mcu_fd_sc_mcu7t5v0__endcap
XPHY_EDGE_ROW_35_Right_35 VDD VDD VSS VSS gf180mcu_fd_sc_mcu7t5v0__endcap
XPHY_EDGE_ROW_36_Left_94 VDD VDD VSS VSS gf180mcu_fd_sc_mcu7t5v0__endcap
XPHY_EDGE_ROW_36_Right_36 VDD VDD VSS VSS gf180mcu_fd_sc_mcu7t5v0__endcap
XPHY_EDGE_ROW_37_Left_95 VDD VDD VSS VSS gf180mcu_fd_sc_mcu7t5v0__endcap
XPHY_EDGE_ROW_37_Right_37 VDD VDD VSS VSS gf180mcu_fd_sc_mcu7t5v0__endcap
XPHY_EDGE_ROW_38_Left_96 VDD VDD VSS VSS gf180mcu_fd_sc_mcu7t5v0__endcap
XPHY_EDGE_ROW_38_Right_38 VDD VDD VSS VSS gf180mcu_fd_sc_mcu7t5v0__endcap
XPHY_EDGE_ROW_39_Left_97 VDD VDD VSS VSS gf180mcu_fd_sc_mcu7t5v0__endcap
XPHY_EDGE_ROW_39_Right_39 VDD VDD VSS VSS gf180mcu_fd_sc_mcu7t5v0__endcap
XPHY_EDGE_ROW_3_Left_61 VDD VDD VSS VSS gf180mcu_fd_sc_mcu7t5v0__endcap
XPHY_EDGE_ROW_3_Right_3 VDD VDD VSS VSS gf180mcu_fd_sc_mcu7t5v0__endcap
XPHY_EDGE_ROW_40_Left_98 VDD VDD VSS VSS gf180mcu_fd_sc_mcu7t5v0__endcap
XPHY_EDGE_ROW_40_Right_40 VDD VDD VSS VSS gf180mcu_fd_sc_mcu7t5v0__endcap
XPHY_EDGE_ROW_41_Left_99 VDD VDD VSS VSS gf180mcu_fd_sc_mcu7t5v0__endcap
XPHY_EDGE_ROW_41_Right_41 VDD VDD VSS VSS gf180mcu_fd_sc_mcu7t5v0__endcap
XPHY_EDGE_ROW_42_Left_100 VDD VDD VSS VSS gf180mcu_fd_sc_mcu7t5v0__endcap
XPHY_EDGE_ROW_42_Right_42 VDD VDD VSS VSS gf180mcu_fd_sc_mcu7t5v0__endcap
XPHY_EDGE_ROW_43_Left_101 VDD VDD VSS VSS gf180mcu_fd_sc_mcu7t5v0__endcap
XPHY_EDGE_ROW_43_Right_43 VDD VDD VSS VSS gf180mcu_fd_sc_mcu7t5v0__endcap
XPHY_EDGE_ROW_44_Left_102 VDD VDD VSS VSS gf180mcu_fd_sc_mcu7t5v0__endcap
XPHY_EDGE_ROW_44_Right_44 VDD VDD VSS VSS gf180mcu_fd_sc_mcu7t5v0__endcap
XPHY_EDGE_ROW_45_Left_103 VDD VDD VSS VSS gf180mcu_fd_sc_mcu7t5v0__endcap
XPHY_EDGE_ROW_45_Right_45 VDD VDD VSS VSS gf180mcu_fd_sc_mcu7t5v0__endcap
XPHY_EDGE_ROW_46_Left_104 VDD VDD VSS VSS gf180mcu_fd_sc_mcu7t5v0__endcap
XPHY_EDGE_ROW_46_Right_46 VDD VDD VSS VSS gf180mcu_fd_sc_mcu7t5v0__endcap
XPHY_EDGE_ROW_47_Left_105 VDD VDD VSS VSS gf180mcu_fd_sc_mcu7t5v0__endcap
XPHY_EDGE_ROW_47_Right_47 VDD VDD VSS VSS gf180mcu_fd_sc_mcu7t5v0__endcap
XPHY_EDGE_ROW_48_Left_106 VDD VDD VSS VSS gf180mcu_fd_sc_mcu7t5v0__endcap
XPHY_EDGE_ROW_48_Right_48 VDD VDD VSS VSS gf180mcu_fd_sc_mcu7t5v0__endcap
XPHY_EDGE_ROW_49_Left_107 VDD VDD VSS VSS gf180mcu_fd_sc_mcu7t5v0__endcap
XPHY_EDGE_ROW_49_Right_49 VDD VDD VSS VSS gf180mcu_fd_sc_mcu7t5v0__endcap
XPHY_EDGE_ROW_4_Left_62 VDD VDD VSS VSS gf180mcu_fd_sc_mcu7t5v0__endcap
XPHY_EDGE_ROW_4_Right_4 VDD VDD VSS VSS gf180mcu_fd_sc_mcu7t5v0__endcap
XPHY_EDGE_ROW_50_Left_108 VDD VDD VSS VSS gf180mcu_fd_sc_mcu7t5v0__endcap
XPHY_EDGE_ROW_50_Right_50 VDD VDD VSS VSS gf180mcu_fd_sc_mcu7t5v0__endcap
XPHY_EDGE_ROW_51_Left_109 VDD VDD VSS VSS gf180mcu_fd_sc_mcu7t5v0__endcap
XPHY_EDGE_ROW_51_Right_51 VDD VDD VSS VSS gf180mcu_fd_sc_mcu7t5v0__endcap
XPHY_EDGE_ROW_52_Left_110 VDD VDD VSS VSS gf180mcu_fd_sc_mcu7t5v0__endcap
XPHY_EDGE_ROW_52_Right_52 VDD VDD VSS VSS gf180mcu_fd_sc_mcu7t5v0__endcap
XPHY_EDGE_ROW_53_Left_111 VDD VDD VSS VSS gf180mcu_fd_sc_mcu7t5v0__endcap
XPHY_EDGE_ROW_53_Right_53 VDD VDD VSS VSS gf180mcu_fd_sc_mcu7t5v0__endcap
XPHY_EDGE_ROW_54_Left_112 VDD VDD VSS VSS gf180mcu_fd_sc_mcu7t5v0__endcap
XPHY_EDGE_ROW_54_Right_54 VDD VDD VSS VSS gf180mcu_fd_sc_mcu7t5v0__endcap
XPHY_EDGE_ROW_55_Left_113 VDD VDD VSS VSS gf180mcu_fd_sc_mcu7t5v0__endcap
XPHY_EDGE_ROW_55_Right_55 VDD VDD VSS VSS gf180mcu_fd_sc_mcu7t5v0__endcap
XPHY_EDGE_ROW_56_Left_114 VDD VDD VSS VSS gf180mcu_fd_sc_mcu7t5v0__endcap
XPHY_EDGE_ROW_56_Right_56 VDD VDD VSS VSS gf180mcu_fd_sc_mcu7t5v0__endcap
XPHY_EDGE_ROW_57_Left_115 VDD VDD VSS VSS gf180mcu_fd_sc_mcu7t5v0__endcap
XPHY_EDGE_ROW_57_Right_57 VDD VDD VSS VSS gf180mcu_fd_sc_mcu7t5v0__endcap
XPHY_EDGE_ROW_5_Left_63 VDD VDD VSS VSS gf180mcu_fd_sc_mcu7t5v0__endcap
XPHY_EDGE_ROW_5_Right_5 VDD VDD VSS VSS gf180mcu_fd_sc_mcu7t5v0__endcap
XPHY_EDGE_ROW_6_Left_64 VDD VDD VSS VSS gf180mcu_fd_sc_mcu7t5v0__endcap
XPHY_EDGE_ROW_6_Right_6 VDD VDD VSS VSS gf180mcu_fd_sc_mcu7t5v0__endcap
XPHY_EDGE_ROW_7_Left_65 VDD VDD VSS VSS gf180mcu_fd_sc_mcu7t5v0__endcap
XPHY_EDGE_ROW_7_Right_7 VDD VDD VSS VSS gf180mcu_fd_sc_mcu7t5v0__endcap
XPHY_EDGE_ROW_8_Left_66 VDD VDD VSS VSS gf180mcu_fd_sc_mcu7t5v0__endcap
XPHY_EDGE_ROW_8_Right_8 VDD VDD VSS VSS gf180mcu_fd_sc_mcu7t5v0__endcap
XPHY_EDGE_ROW_9_Left_67 VDD VDD VSS VSS gf180mcu_fd_sc_mcu7t5v0__endcap
XPHY_EDGE_ROW_9_Right_9 VDD VDD VSS VSS gf180mcu_fd_sc_mcu7t5v0__endcap
XTAP_TAPCELL_ROW_0_116 VDD VSS gf180mcu_fd_sc_mcu7t5v0__filltie
XTAP_TAPCELL_ROW_0_117 VDD VSS gf180mcu_fd_sc_mcu7t5v0__filltie
XTAP_TAPCELL_ROW_0_118 VDD VSS gf180mcu_fd_sc_mcu7t5v0__filltie
XTAP_TAPCELL_ROW_0_119 VDD VSS gf180mcu_fd_sc_mcu7t5v0__filltie
XTAP_TAPCELL_ROW_0_120 VDD VSS gf180mcu_fd_sc_mcu7t5v0__filltie
XTAP_TAPCELL_ROW_0_121 VDD VSS gf180mcu_fd_sc_mcu7t5v0__filltie
XTAP_TAPCELL_ROW_0_122 VDD VSS gf180mcu_fd_sc_mcu7t5v0__filltie
XTAP_TAPCELL_ROW_0_123 VDD VSS gf180mcu_fd_sc_mcu7t5v0__filltie
XTAP_TAPCELL_ROW_10_155 VDD VSS gf180mcu_fd_sc_mcu7t5v0__filltie
XTAP_TAPCELL_ROW_10_156 VDD VSS gf180mcu_fd_sc_mcu7t5v0__filltie
XTAP_TAPCELL_ROW_10_157 VDD VSS gf180mcu_fd_sc_mcu7t5v0__filltie
XTAP_TAPCELL_ROW_10_158 VDD VSS gf180mcu_fd_sc_mcu7t5v0__filltie
XTAP_TAPCELL_ROW_11_159 VDD VSS gf180mcu_fd_sc_mcu7t5v0__filltie
XTAP_TAPCELL_ROW_11_160 VDD VSS gf180mcu_fd_sc_mcu7t5v0__filltie
XTAP_TAPCELL_ROW_11_161 VDD VSS gf180mcu_fd_sc_mcu7t5v0__filltie
XTAP_TAPCELL_ROW_12_162 VDD VSS gf180mcu_fd_sc_mcu7t5v0__filltie
XTAP_TAPCELL_ROW_12_163 VDD VSS gf180mcu_fd_sc_mcu7t5v0__filltie
XTAP_TAPCELL_ROW_12_164 VDD VSS gf180mcu_fd_sc_mcu7t5v0__filltie
XTAP_TAPCELL_ROW_12_165 VDD VSS gf180mcu_fd_sc_mcu7t5v0__filltie
XTAP_TAPCELL_ROW_13_166 VDD VSS gf180mcu_fd_sc_mcu7t5v0__filltie
XTAP_TAPCELL_ROW_13_167 VDD VSS gf180mcu_fd_sc_mcu7t5v0__filltie
XTAP_TAPCELL_ROW_13_168 VDD VSS gf180mcu_fd_sc_mcu7t5v0__filltie
XTAP_TAPCELL_ROW_14_169 VDD VSS gf180mcu_fd_sc_mcu7t5v0__filltie
XTAP_TAPCELL_ROW_14_170 VDD VSS gf180mcu_fd_sc_mcu7t5v0__filltie
XTAP_TAPCELL_ROW_14_171 VDD VSS gf180mcu_fd_sc_mcu7t5v0__filltie
XTAP_TAPCELL_ROW_14_172 VDD VSS gf180mcu_fd_sc_mcu7t5v0__filltie
XTAP_TAPCELL_ROW_15_173 VDD VSS gf180mcu_fd_sc_mcu7t5v0__filltie
XTAP_TAPCELL_ROW_15_174 VDD VSS gf180mcu_fd_sc_mcu7t5v0__filltie
XTAP_TAPCELL_ROW_15_175 VDD VSS gf180mcu_fd_sc_mcu7t5v0__filltie
XTAP_TAPCELL_ROW_16_176 VDD VSS gf180mcu_fd_sc_mcu7t5v0__filltie
XTAP_TAPCELL_ROW_16_177 VDD VSS gf180mcu_fd_sc_mcu7t5v0__filltie
XTAP_TAPCELL_ROW_16_178 VDD VSS gf180mcu_fd_sc_mcu7t5v0__filltie
XTAP_TAPCELL_ROW_16_179 VDD VSS gf180mcu_fd_sc_mcu7t5v0__filltie
XTAP_TAPCELL_ROW_17_180 VDD VSS gf180mcu_fd_sc_mcu7t5v0__filltie
XTAP_TAPCELL_ROW_17_181 VDD VSS gf180mcu_fd_sc_mcu7t5v0__filltie
XTAP_TAPCELL_ROW_17_182 VDD VSS gf180mcu_fd_sc_mcu7t5v0__filltie
XTAP_TAPCELL_ROW_18_183 VDD VSS gf180mcu_fd_sc_mcu7t5v0__filltie
XTAP_TAPCELL_ROW_18_184 VDD VSS gf180mcu_fd_sc_mcu7t5v0__filltie
XTAP_TAPCELL_ROW_18_185 VDD VSS gf180mcu_fd_sc_mcu7t5v0__filltie
XTAP_TAPCELL_ROW_18_186 VDD VSS gf180mcu_fd_sc_mcu7t5v0__filltie
XTAP_TAPCELL_ROW_19_187 VDD VSS gf180mcu_fd_sc_mcu7t5v0__filltie
XTAP_TAPCELL_ROW_19_188 VDD VSS gf180mcu_fd_sc_mcu7t5v0__filltie
XTAP_TAPCELL_ROW_19_189 VDD VSS gf180mcu_fd_sc_mcu7t5v0__filltie
XTAP_TAPCELL_ROW_1_124 VDD VSS gf180mcu_fd_sc_mcu7t5v0__filltie
XTAP_TAPCELL_ROW_1_125 VDD VSS gf180mcu_fd_sc_mcu7t5v0__filltie
XTAP_TAPCELL_ROW_1_126 VDD VSS gf180mcu_fd_sc_mcu7t5v0__filltie
XTAP_TAPCELL_ROW_20_190 VDD VSS gf180mcu_fd_sc_mcu7t5v0__filltie
XTAP_TAPCELL_ROW_20_191 VDD VSS gf180mcu_fd_sc_mcu7t5v0__filltie
XTAP_TAPCELL_ROW_20_192 VDD VSS gf180mcu_fd_sc_mcu7t5v0__filltie
XTAP_TAPCELL_ROW_20_193 VDD VSS gf180mcu_fd_sc_mcu7t5v0__filltie
XTAP_TAPCELL_ROW_21_194 VDD VSS gf180mcu_fd_sc_mcu7t5v0__filltie
XTAP_TAPCELL_ROW_21_195 VDD VSS gf180mcu_fd_sc_mcu7t5v0__filltie
XTAP_TAPCELL_ROW_21_196 VDD VSS gf180mcu_fd_sc_mcu7t5v0__filltie
XTAP_TAPCELL_ROW_22_197 VDD VSS gf180mcu_fd_sc_mcu7t5v0__filltie
XTAP_TAPCELL_ROW_22_198 VDD VSS gf180mcu_fd_sc_mcu7t5v0__filltie
XTAP_TAPCELL_ROW_22_199 VDD VSS gf180mcu_fd_sc_mcu7t5v0__filltie
XTAP_TAPCELL_ROW_22_200 VDD VSS gf180mcu_fd_sc_mcu7t5v0__filltie
XTAP_TAPCELL_ROW_23_201 VDD VSS gf180mcu_fd_sc_mcu7t5v0__filltie
XTAP_TAPCELL_ROW_23_202 VDD VSS gf180mcu_fd_sc_mcu7t5v0__filltie
XTAP_TAPCELL_ROW_23_203 VDD VSS gf180mcu_fd_sc_mcu7t5v0__filltie
XTAP_TAPCELL_ROW_24_204 VDD VSS gf180mcu_fd_sc_mcu7t5v0__filltie
XTAP_TAPCELL_ROW_24_205 VDD VSS gf180mcu_fd_sc_mcu7t5v0__filltie
XTAP_TAPCELL_ROW_24_206 VDD VSS gf180mcu_fd_sc_mcu7t5v0__filltie
XTAP_TAPCELL_ROW_24_207 VDD VSS gf180mcu_fd_sc_mcu7t5v0__filltie
XTAP_TAPCELL_ROW_25_208 VDD VSS gf180mcu_fd_sc_mcu7t5v0__filltie
XTAP_TAPCELL_ROW_25_209 VDD VSS gf180mcu_fd_sc_mcu7t5v0__filltie
XTAP_TAPCELL_ROW_25_210 VDD VSS gf180mcu_fd_sc_mcu7t5v0__filltie
XTAP_TAPCELL_ROW_26_211 VDD VSS gf180mcu_fd_sc_mcu7t5v0__filltie
XTAP_TAPCELL_ROW_26_212 VDD VSS gf180mcu_fd_sc_mcu7t5v0__filltie
XTAP_TAPCELL_ROW_26_213 VDD VSS gf180mcu_fd_sc_mcu7t5v0__filltie
XTAP_TAPCELL_ROW_26_214 VDD VSS gf180mcu_fd_sc_mcu7t5v0__filltie
XTAP_TAPCELL_ROW_27_215 VDD VSS gf180mcu_fd_sc_mcu7t5v0__filltie
XTAP_TAPCELL_ROW_27_216 VDD VSS gf180mcu_fd_sc_mcu7t5v0__filltie
XTAP_TAPCELL_ROW_27_217 VDD VSS gf180mcu_fd_sc_mcu7t5v0__filltie
XTAP_TAPCELL_ROW_28_218 VDD VSS gf180mcu_fd_sc_mcu7t5v0__filltie
XTAP_TAPCELL_ROW_28_219 VDD VSS gf180mcu_fd_sc_mcu7t5v0__filltie
XTAP_TAPCELL_ROW_28_220 VDD VSS gf180mcu_fd_sc_mcu7t5v0__filltie
XTAP_TAPCELL_ROW_28_221 VDD VSS gf180mcu_fd_sc_mcu7t5v0__filltie
XTAP_TAPCELL_ROW_29_222 VDD VSS gf180mcu_fd_sc_mcu7t5v0__filltie
XTAP_TAPCELL_ROW_29_223 VDD VSS gf180mcu_fd_sc_mcu7t5v0__filltie
XTAP_TAPCELL_ROW_29_224 VDD VSS gf180mcu_fd_sc_mcu7t5v0__filltie
XTAP_TAPCELL_ROW_2_127 VDD VSS gf180mcu_fd_sc_mcu7t5v0__filltie
XTAP_TAPCELL_ROW_2_128 VDD VSS gf180mcu_fd_sc_mcu7t5v0__filltie
XTAP_TAPCELL_ROW_2_129 VDD VSS gf180mcu_fd_sc_mcu7t5v0__filltie
XTAP_TAPCELL_ROW_2_130 VDD VSS gf180mcu_fd_sc_mcu7t5v0__filltie
XTAP_TAPCELL_ROW_30_225 VDD VSS gf180mcu_fd_sc_mcu7t5v0__filltie
XTAP_TAPCELL_ROW_30_226 VDD VSS gf180mcu_fd_sc_mcu7t5v0__filltie
XTAP_TAPCELL_ROW_30_227 VDD VSS gf180mcu_fd_sc_mcu7t5v0__filltie
XTAP_TAPCELL_ROW_30_228 VDD VSS gf180mcu_fd_sc_mcu7t5v0__filltie
XTAP_TAPCELL_ROW_31_229 VDD VSS gf180mcu_fd_sc_mcu7t5v0__filltie
XTAP_TAPCELL_ROW_31_230 VDD VSS gf180mcu_fd_sc_mcu7t5v0__filltie
XTAP_TAPCELL_ROW_31_231 VDD VSS gf180mcu_fd_sc_mcu7t5v0__filltie
XTAP_TAPCELL_ROW_32_232 VDD VSS gf180mcu_fd_sc_mcu7t5v0__filltie
XTAP_TAPCELL_ROW_32_233 VDD VSS gf180mcu_fd_sc_mcu7t5v0__filltie
XTAP_TAPCELL_ROW_32_234 VDD VSS gf180mcu_fd_sc_mcu7t5v0__filltie
XTAP_TAPCELL_ROW_32_235 VDD VSS gf180mcu_fd_sc_mcu7t5v0__filltie
XTAP_TAPCELL_ROW_33_236 VDD VSS gf180mcu_fd_sc_mcu7t5v0__filltie
XTAP_TAPCELL_ROW_33_237 VDD VSS gf180mcu_fd_sc_mcu7t5v0__filltie
XTAP_TAPCELL_ROW_33_238 VDD VSS gf180mcu_fd_sc_mcu7t5v0__filltie
XTAP_TAPCELL_ROW_34_239 VDD VSS gf180mcu_fd_sc_mcu7t5v0__filltie
XTAP_TAPCELL_ROW_34_240 VDD VSS gf180mcu_fd_sc_mcu7t5v0__filltie
XTAP_TAPCELL_ROW_34_241 VDD VSS gf180mcu_fd_sc_mcu7t5v0__filltie
XTAP_TAPCELL_ROW_34_242 VDD VSS gf180mcu_fd_sc_mcu7t5v0__filltie
XTAP_TAPCELL_ROW_35_243 VDD VSS gf180mcu_fd_sc_mcu7t5v0__filltie
XTAP_TAPCELL_ROW_35_244 VDD VSS gf180mcu_fd_sc_mcu7t5v0__filltie
XTAP_TAPCELL_ROW_35_245 VDD VSS gf180mcu_fd_sc_mcu7t5v0__filltie
XTAP_TAPCELL_ROW_36_246 VDD VSS gf180mcu_fd_sc_mcu7t5v0__filltie
XTAP_TAPCELL_ROW_36_247 VDD VSS gf180mcu_fd_sc_mcu7t5v0__filltie
XTAP_TAPCELL_ROW_36_248 VDD VSS gf180mcu_fd_sc_mcu7t5v0__filltie
XTAP_TAPCELL_ROW_36_249 VDD VSS gf180mcu_fd_sc_mcu7t5v0__filltie
XTAP_TAPCELL_ROW_37_250 VDD VSS gf180mcu_fd_sc_mcu7t5v0__filltie
XTAP_TAPCELL_ROW_37_251 VDD VSS gf180mcu_fd_sc_mcu7t5v0__filltie
XTAP_TAPCELL_ROW_37_252 VDD VSS gf180mcu_fd_sc_mcu7t5v0__filltie
XTAP_TAPCELL_ROW_38_253 VDD VSS gf180mcu_fd_sc_mcu7t5v0__filltie
XTAP_TAPCELL_ROW_38_254 VDD VSS gf180mcu_fd_sc_mcu7t5v0__filltie
XTAP_TAPCELL_ROW_38_255 VDD VSS gf180mcu_fd_sc_mcu7t5v0__filltie
XTAP_TAPCELL_ROW_38_256 VDD VSS gf180mcu_fd_sc_mcu7t5v0__filltie
XTAP_TAPCELL_ROW_39_257 VDD VSS gf180mcu_fd_sc_mcu7t5v0__filltie
XTAP_TAPCELL_ROW_39_258 VDD VSS gf180mcu_fd_sc_mcu7t5v0__filltie
XTAP_TAPCELL_ROW_39_259 VDD VSS gf180mcu_fd_sc_mcu7t5v0__filltie
XTAP_TAPCELL_ROW_3_131 VDD VSS gf180mcu_fd_sc_mcu7t5v0__filltie
XTAP_TAPCELL_ROW_3_132 VDD VSS gf180mcu_fd_sc_mcu7t5v0__filltie
XTAP_TAPCELL_ROW_3_133 VDD VSS gf180mcu_fd_sc_mcu7t5v0__filltie
XTAP_TAPCELL_ROW_40_260 VDD VSS gf180mcu_fd_sc_mcu7t5v0__filltie
XTAP_TAPCELL_ROW_40_261 VDD VSS gf180mcu_fd_sc_mcu7t5v0__filltie
XTAP_TAPCELL_ROW_40_262 VDD VSS gf180mcu_fd_sc_mcu7t5v0__filltie
XTAP_TAPCELL_ROW_40_263 VDD VSS gf180mcu_fd_sc_mcu7t5v0__filltie
XTAP_TAPCELL_ROW_41_264 VDD VSS gf180mcu_fd_sc_mcu7t5v0__filltie
XTAP_TAPCELL_ROW_41_265 VDD VSS gf180mcu_fd_sc_mcu7t5v0__filltie
XTAP_TAPCELL_ROW_41_266 VDD VSS gf180mcu_fd_sc_mcu7t5v0__filltie
XTAP_TAPCELL_ROW_42_267 VDD VSS gf180mcu_fd_sc_mcu7t5v0__filltie
XTAP_TAPCELL_ROW_42_268 VDD VSS gf180mcu_fd_sc_mcu7t5v0__filltie
XTAP_TAPCELL_ROW_42_269 VDD VSS gf180mcu_fd_sc_mcu7t5v0__filltie
XTAP_TAPCELL_ROW_42_270 VDD VSS gf180mcu_fd_sc_mcu7t5v0__filltie
XTAP_TAPCELL_ROW_43_271 VDD VSS gf180mcu_fd_sc_mcu7t5v0__filltie
XTAP_TAPCELL_ROW_43_272 VDD VSS gf180mcu_fd_sc_mcu7t5v0__filltie
XTAP_TAPCELL_ROW_43_273 VDD VSS gf180mcu_fd_sc_mcu7t5v0__filltie
XTAP_TAPCELL_ROW_44_274 VDD VSS gf180mcu_fd_sc_mcu7t5v0__filltie
XTAP_TAPCELL_ROW_44_275 VDD VSS gf180mcu_fd_sc_mcu7t5v0__filltie
XTAP_TAPCELL_ROW_44_276 VDD VSS gf180mcu_fd_sc_mcu7t5v0__filltie
XTAP_TAPCELL_ROW_44_277 VDD VSS gf180mcu_fd_sc_mcu7t5v0__filltie
XTAP_TAPCELL_ROW_45_278 VDD VSS gf180mcu_fd_sc_mcu7t5v0__filltie
XTAP_TAPCELL_ROW_45_279 VDD VSS gf180mcu_fd_sc_mcu7t5v0__filltie
XTAP_TAPCELL_ROW_45_280 VDD VSS gf180mcu_fd_sc_mcu7t5v0__filltie
XTAP_TAPCELL_ROW_46_281 VDD VSS gf180mcu_fd_sc_mcu7t5v0__filltie
XTAP_TAPCELL_ROW_46_282 VDD VSS gf180mcu_fd_sc_mcu7t5v0__filltie
XTAP_TAPCELL_ROW_46_283 VDD VSS gf180mcu_fd_sc_mcu7t5v0__filltie
XTAP_TAPCELL_ROW_46_284 VDD VSS gf180mcu_fd_sc_mcu7t5v0__filltie
XTAP_TAPCELL_ROW_47_285 VDD VSS gf180mcu_fd_sc_mcu7t5v0__filltie
XTAP_TAPCELL_ROW_47_286 VDD VSS gf180mcu_fd_sc_mcu7t5v0__filltie
XTAP_TAPCELL_ROW_47_287 VDD VSS gf180mcu_fd_sc_mcu7t5v0__filltie
XTAP_TAPCELL_ROW_48_288 VDD VSS gf180mcu_fd_sc_mcu7t5v0__filltie
XTAP_TAPCELL_ROW_48_289 VDD VSS gf180mcu_fd_sc_mcu7t5v0__filltie
XTAP_TAPCELL_ROW_48_290 VDD VSS gf180mcu_fd_sc_mcu7t5v0__filltie
XTAP_TAPCELL_ROW_48_291 VDD VSS gf180mcu_fd_sc_mcu7t5v0__filltie
XTAP_TAPCELL_ROW_49_292 VDD VSS gf180mcu_fd_sc_mcu7t5v0__filltie
XTAP_TAPCELL_ROW_49_293 VDD VSS gf180mcu_fd_sc_mcu7t5v0__filltie
XTAP_TAPCELL_ROW_49_294 VDD VSS gf180mcu_fd_sc_mcu7t5v0__filltie
XTAP_TAPCELL_ROW_4_134 VDD VSS gf180mcu_fd_sc_mcu7t5v0__filltie
XTAP_TAPCELL_ROW_4_135 VDD VSS gf180mcu_fd_sc_mcu7t5v0__filltie
XTAP_TAPCELL_ROW_4_136 VDD VSS gf180mcu_fd_sc_mcu7t5v0__filltie
XTAP_TAPCELL_ROW_4_137 VDD VSS gf180mcu_fd_sc_mcu7t5v0__filltie
XTAP_TAPCELL_ROW_50_295 VDD VSS gf180mcu_fd_sc_mcu7t5v0__filltie
XTAP_TAPCELL_ROW_50_296 VDD VSS gf180mcu_fd_sc_mcu7t5v0__filltie
XTAP_TAPCELL_ROW_50_297 VDD VSS gf180mcu_fd_sc_mcu7t5v0__filltie
XTAP_TAPCELL_ROW_50_298 VDD VSS gf180mcu_fd_sc_mcu7t5v0__filltie
XTAP_TAPCELL_ROW_51_299 VDD VSS gf180mcu_fd_sc_mcu7t5v0__filltie
XTAP_TAPCELL_ROW_51_300 VDD VSS gf180mcu_fd_sc_mcu7t5v0__filltie
XTAP_TAPCELL_ROW_51_301 VDD VSS gf180mcu_fd_sc_mcu7t5v0__filltie
XTAP_TAPCELL_ROW_52_302 VDD VSS gf180mcu_fd_sc_mcu7t5v0__filltie
XTAP_TAPCELL_ROW_52_303 VDD VSS gf180mcu_fd_sc_mcu7t5v0__filltie
XTAP_TAPCELL_ROW_52_304 VDD VSS gf180mcu_fd_sc_mcu7t5v0__filltie
XTAP_TAPCELL_ROW_52_305 VDD VSS gf180mcu_fd_sc_mcu7t5v0__filltie
XTAP_TAPCELL_ROW_53_306 VDD VSS gf180mcu_fd_sc_mcu7t5v0__filltie
XTAP_TAPCELL_ROW_53_307 VDD VSS gf180mcu_fd_sc_mcu7t5v0__filltie
XTAP_TAPCELL_ROW_53_308 VDD VSS gf180mcu_fd_sc_mcu7t5v0__filltie
XTAP_TAPCELL_ROW_54_309 VDD VSS gf180mcu_fd_sc_mcu7t5v0__filltie
XTAP_TAPCELL_ROW_54_310 VDD VSS gf180mcu_fd_sc_mcu7t5v0__filltie
XTAP_TAPCELL_ROW_54_311 VDD VSS gf180mcu_fd_sc_mcu7t5v0__filltie
XTAP_TAPCELL_ROW_54_312 VDD VSS gf180mcu_fd_sc_mcu7t5v0__filltie
XTAP_TAPCELL_ROW_55_313 VDD VSS gf180mcu_fd_sc_mcu7t5v0__filltie
XTAP_TAPCELL_ROW_55_314 VDD VSS gf180mcu_fd_sc_mcu7t5v0__filltie
XTAP_TAPCELL_ROW_55_315 VDD VSS gf180mcu_fd_sc_mcu7t5v0__filltie
XTAP_TAPCELL_ROW_56_316 VDD VSS gf180mcu_fd_sc_mcu7t5v0__filltie
XTAP_TAPCELL_ROW_56_317 VDD VSS gf180mcu_fd_sc_mcu7t5v0__filltie
XTAP_TAPCELL_ROW_56_318 VDD VSS gf180mcu_fd_sc_mcu7t5v0__filltie
XTAP_TAPCELL_ROW_56_319 VDD VSS gf180mcu_fd_sc_mcu7t5v0__filltie
XTAP_TAPCELL_ROW_57_320 VDD VSS gf180mcu_fd_sc_mcu7t5v0__filltie
XTAP_TAPCELL_ROW_57_321 VDD VSS gf180mcu_fd_sc_mcu7t5v0__filltie
XTAP_TAPCELL_ROW_57_322 VDD VSS gf180mcu_fd_sc_mcu7t5v0__filltie
XTAP_TAPCELL_ROW_57_323 VDD VSS gf180mcu_fd_sc_mcu7t5v0__filltie
XTAP_TAPCELL_ROW_57_324 VDD VSS gf180mcu_fd_sc_mcu7t5v0__filltie
XTAP_TAPCELL_ROW_57_325 VDD VSS gf180mcu_fd_sc_mcu7t5v0__filltie
XTAP_TAPCELL_ROW_57_326 VDD VSS gf180mcu_fd_sc_mcu7t5v0__filltie
XTAP_TAPCELL_ROW_57_327 VDD VSS gf180mcu_fd_sc_mcu7t5v0__filltie
XTAP_TAPCELL_ROW_5_138 VDD VSS gf180mcu_fd_sc_mcu7t5v0__filltie
XTAP_TAPCELL_ROW_5_139 VDD VSS gf180mcu_fd_sc_mcu7t5v0__filltie
XTAP_TAPCELL_ROW_5_140 VDD VSS gf180mcu_fd_sc_mcu7t5v0__filltie
XTAP_TAPCELL_ROW_6_141 VDD VSS gf180mcu_fd_sc_mcu7t5v0__filltie
XTAP_TAPCELL_ROW_6_142 VDD VSS gf180mcu_fd_sc_mcu7t5v0__filltie
XTAP_TAPCELL_ROW_6_143 VDD VSS gf180mcu_fd_sc_mcu7t5v0__filltie
XTAP_TAPCELL_ROW_6_144 VDD VSS gf180mcu_fd_sc_mcu7t5v0__filltie
XTAP_TAPCELL_ROW_7_145 VDD VSS gf180mcu_fd_sc_mcu7t5v0__filltie
XTAP_TAPCELL_ROW_7_146 VDD VSS gf180mcu_fd_sc_mcu7t5v0__filltie
XTAP_TAPCELL_ROW_7_147 VDD VSS gf180mcu_fd_sc_mcu7t5v0__filltie
XTAP_TAPCELL_ROW_8_148 VDD VSS gf180mcu_fd_sc_mcu7t5v0__filltie
XTAP_TAPCELL_ROW_8_149 VDD VSS gf180mcu_fd_sc_mcu7t5v0__filltie
XTAP_TAPCELL_ROW_8_150 VDD VSS gf180mcu_fd_sc_mcu7t5v0__filltie
XTAP_TAPCELL_ROW_8_151 VDD VSS gf180mcu_fd_sc_mcu7t5v0__filltie
XTAP_TAPCELL_ROW_9_152 VDD VSS gf180mcu_fd_sc_mcu7t5v0__filltie
XTAP_TAPCELL_ROW_9_153 VDD VSS gf180mcu_fd_sc_mcu7t5v0__filltie
XTAP_TAPCELL_ROW_9_154 VDD VSS gf180mcu_fd_sc_mcu7t5v0__filltie
X_0487_ eff_q[12] _0012_ VDD VDD VSS VSS gf180mcu_fd_sc_mcu7t5v0__clkinv_1
X_0488_ rip[0].q _0045_ VDD VDD VSS VSS gf180mcu_fd_sc_mcu7t5v0__clkinv_1
X_0489_ net45 _0046_ VDD VDD VSS VSS gf180mcu_fd_sc_mcu7t5v0__clkinv_1
X_0490_ rip[2].q _0047_ VDD VDD VSS VSS gf180mcu_fd_sc_mcu7t5v0__clkinv_1
X_0491_ net46 _0048_ VDD VDD VSS VSS gf180mcu_fd_sc_mcu7t5v0__clkinv_1
X_0492_ rip[4].q _0049_ VDD VDD VSS VSS gf180mcu_fd_sc_mcu7t5v0__clkinv_1
X_0493_ rip[5].q _0050_ VDD VDD VSS VSS gf180mcu_fd_sc_mcu7t5v0__clkinv_1
X_0494_ rip[6].q _0051_ VDD VDD VSS VSS gf180mcu_fd_sc_mcu7t5v0__clkinv_1
X_0495_ net44 _0052_ VDD VDD VSS VSS gf180mcu_fd_sc_mcu7t5v0__clkinv_1
X_0496_ eff_q[15] _0121_ VDD VDD VSS VSS gf180mcu_fd_sc_mcu7t5v0__clkinv_1
X_0497_ eff_q[16] _0122_ VDD VDD VSS VSS gf180mcu_fd_sc_mcu7t5v0__clkinv_1
X_0498_ eff_q[17] _0020_ VDD VDD VSS VSS gf180mcu_fd_sc_mcu7t5v0__clkinv_1
X_0499_ eff_q[13] _0123_ VDD VDD VSS VSS gf180mcu_fd_sc_mcu7t5v0__clkinv_1
X_0500_ eff_q[14] _0124_ VDD VDD VSS VSS gf180mcu_fd_sc_mcu7t5v0__clkinv_1
X_0501_ s_cs[1] _0125_ VDD VDD VSS VSS gf180mcu_fd_sc_mcu7t5v0__clkinv_1
X_0502_ s_fsk[1] _0126_ VDD VDD VSS VSS gf180mcu_fd_sc_mcu7t5v0__clkinv_1
X_0503_ eff_q[0] _0127_ VDD VDD VSS VSS gf180mcu_fd_sc_mcu7t5v0__clkinv_1
X_0504_ s_sclk[2] _0128_ VDD VDD VSS VSS gf180mcu_fd_sc_mcu7t5v0__clkinv_1
X_0505_ sr[12] _0129_ VDD VDD VSS VSS gf180mcu_fd_sc_mcu7t5v0__clkinv_1
X_0506_ bitcnt[0] _0130_ VDD VDD VSS VSS gf180mcu_fd_sc_mcu7t5v0__clkinv_1
X_0507_ sr[14] _0131_ VDD VDD VSS VSS gf180mcu_fd_sc_mcu7t5v0__clkinv_1
X_0508_ eff_q[10] _0010_ VDD VDD VSS VSS gf180mcu_fd_sc_mcu7t5v0__clkinv_1
X_0509_ eff_q[9] _0009_ VDD VDD VSS VSS gf180mcu_fd_sc_mcu7t5v0__clkinv_1
X_0510_ eff_q[11] _0011_ VDD VDD VSS VSS gf180mcu_fd_sc_mcu7t5v0__clkinv_1
X_0511_ eff_q[8] _0008_ VDD VDD VSS VSS gf180mcu_fd_sc_mcu7t5v0__clkinv_1
X_0512_ base[0] _0132_ VDD VDD VSS VSS gf180mcu_fd_sc_mcu7t5v0__clkinv_1
X_0513_ devx[0] _0133_ VDD VDD VSS VSS gf180mcu_fd_sc_mcu7t5v0__clkinv_1
X_0514_ devx[1] _0134_ VDD VDD VSS VSS gf180mcu_fd_sc_mcu7t5v0__clkinv_1
X_0515_ devx[2] _0135_ VDD VDD VSS VSS gf180mcu_fd_sc_mcu7t5v0__clkinv_1
X_0516_ devx[7] _0136_ VDD VDD VSS VSS gf180mcu_fd_sc_mcu7t5v0__clkinv_1
X_0517_ devx[11] _0137_ VDD VDD VSS VSS gf180mcu_fd_sc_mcu7t5v0__clkinv_1
X_0518_ base[15] _0138_ VDD VDD VSS VSS gf180mcu_fd_sc_mcu7t5v0__clkinv_1
X_0519_ base[14] _0139_ VDD VDD VSS VSS gf180mcu_fd_sc_mcu7t5v0__clkinv_1
X_0520_ base[13] _0140_ VDD VDD VSS VSS gf180mcu_fd_sc_mcu7t5v0__clkinv_1
X_0521_ base[12] _0141_ VDD VDD VSS VSS gf180mcu_fd_sc_mcu7t5v0__clkinv_1
X_0522_ base[11] _0142_ VDD VDD VSS VSS gf180mcu_fd_sc_mcu7t5v0__clkinv_1
X_0523_ base[10] _0143_ VDD VDD VSS VSS gf180mcu_fd_sc_mcu7t5v0__clkinv_1
X_0524_ base[9] _0144_ VDD VDD VSS VSS gf180mcu_fd_sc_mcu7t5v0__clkinv_1
X_0525_ base[8] _0145_ VDD VDD VSS VSS gf180mcu_fd_sc_mcu7t5v0__clkinv_1
X_0526_ base[7] _0146_ VDD VDD VSS VSS gf180mcu_fd_sc_mcu7t5v0__clkinv_1
X_0527_ base[6] _0147_ VDD VDD VSS VSS gf180mcu_fd_sc_mcu7t5v0__clkinv_1
X_0528_ base[5] _0148_ VDD VDD VSS VSS gf180mcu_fd_sc_mcu7t5v0__clkinv_1
X_0529_ base[4] _0149_ VDD VDD VSS VSS gf180mcu_fd_sc_mcu7t5v0__clkinv_1
X_0530_ base[3] _0150_ VDD VDD VSS VSS gf180mcu_fd_sc_mcu7t5v0__clkinv_1
X_0531_ base[2] _0151_ VDD VDD VSS VSS gf180mcu_fd_sc_mcu7t5v0__clkinv_1
X_0532_ base[1] _0152_ VDD VDD VSS VSS gf180mcu_fd_sc_mcu7t5v0__clkinv_1
X_0533_ base[16] _0153_ VDD VDD VSS VSS gf180mcu_fd_sc_mcu7t5v0__clkinv_1
X_0534_ base[17] _0154_ VDD VDD VSS VSS gf180mcu_fd_sc_mcu7t5v0__clkinv_1
X_0535_ s_mosi[1] _0155_ VDD VDD VSS VSS gf180mcu_fd_sc_mcu7t5v0__clkinv_1
X_0536_ sr[1] _0156_ VDD VDD VSS VSS gf180mcu_fd_sc_mcu7t5v0__clkinv_1
X_0537_ net47 _0157_ VDD VDD VSS VSS gf180mcu_fd_sc_mcu7t5v0__clkinv_1
X_0538_ eff_q[15] eff_q[16] eff_q[17] _0024_ VDD VDD VSS VSS gf180mcu_fd_sc_mcu7t5v0__oai21_1
X_0539_ _0123_ _0124_ _0158_ VDD VDD VSS VSS gf180mcu_fd_sc_mcu7t5v0__nand2_1
X_0540_ _0122_ _0020_ _0159_ VDD VDD VSS VSS gf180mcu_fd_sc_mcu7t5v0__nor2_1
X_0541_ _0159_ _0029_ VDD VDD VSS VSS gf180mcu_fd_sc_mcu7t5v0__clkinv_1
X_0542_ eff_q[15] _0158_ _0160_ VDD VDD VSS VSS gf180mcu_fd_sc_mcu7t5v0__and2_1
X_0543_ eff_q[16] _0160_ eff_q[17] _0026_ VDD VDD VSS VSS gf180mcu_fd_sc_mcu7t5v0__oai21_1
X_0544_ _0121_ eff_q[16] _0123_ eff_q[14] _0161_ VDD VDD VSS VSS gf180mcu_fd_sc_mcu7t5v0__nor4_1
X_0545_ _0026_ _0161_ _0027_ VDD VDD VSS VSS gf180mcu_fd_sc_mcu7t5v0__or2_1
X_0546_ _0027_ _0162_ VDD VDD VSS VSS gf180mcu_fd_sc_mcu7t5v0__clkinv_1
X_0547_ eff_q[15] eff_q[17] _0123_ eff_q[14] _0163_ VDD VDD VSS VSS gf180mcu_fd_sc_mcu7t5v0__nand4_1
X_0548_ eff_q[16] _0163_ _0162_ _0028_ VDD VDD VSS VSS gf180mcu_fd_sc_mcu7t5v0__oai21_1
X_0549_ _0121_ _0124_ _0164_ VDD VDD VSS VSS gf180mcu_fd_sc_mcu7t5v0__nand2_1
X_0550_ eff_q[16] eff_q[13] _0165_ VDD VDD VSS VSS gf180mcu_fd_sc_mcu7t5v0__nand2_1
X_0551_ eff_q[15] _0158_ _0159_ _0030_ VDD VDD VSS VSS gf180mcu_fd_sc_mcu7t5v0__oai21_1
X_0552_ _0159_ _0164_ _0031_ VDD VDD VSS VSS gf180mcu_fd_sc_mcu7t5v0__nand2_1
X_0553_ _0123_ _0124_ _0166_ VDD VDD VSS VSS gf180mcu_fd_sc_mcu7t5v0__nor2_1
X_0554_ _0121_ _0122_ _0167_ VDD VDD VSS VSS gf180mcu_fd_sc_mcu7t5v0__nor2_1
X_0555_ _0121_ _0029_ _0168_ VDD VDD VSS VSS gf180mcu_fd_sc_mcu7t5v0__nor2_1
X_0556_ _0168_ _0033_ VDD VDD VSS VSS gf180mcu_fd_sc_mcu7t5v0__clkinv_1
X_0557_ eff_q[15] _0166_ _0159_ _0032_ VDD VDD VSS VSS gf180mcu_fd_sc_mcu7t5v0__oai21_1
X_0558_ _0158_ _0168_ _0034_ VDD VDD VSS VSS gf180mcu_fd_sc_mcu7t5v0__nand2_1
X_0559_ eff_q[14] _0168_ _0035_ VDD VDD VSS VSS gf180mcu_fd_sc_mcu7t5v0__nand2_1
X_0560_ _0166_ _0168_ _0037_ VDD VDD VSS VSS gf180mcu_fd_sc_mcu7t5v0__nand2_1
X_0561_ _0122_ _0020_ _0169_ VDD VDD VSS VSS gf180mcu_fd_sc_mcu7t5v0__nand2_1
X_0562_ _0169_ _0042_ VDD VDD VSS VSS gf180mcu_fd_sc_mcu7t5v0__clkinv_1
X_0563_ _0164_ _0169_ _0025_ VDD VDD VSS VSS gf180mcu_fd_sc_mcu7t5v0__nor2_1
X_0564_ eff_q[15] _0169_ _0038_ VDD VDD VSS VSS gf180mcu_fd_sc_mcu7t5v0__nor2_1
X_0565_ eff_q[15] _0166_ _0169_ _0036_ VDD VDD VSS VSS gf180mcu_fd_sc_mcu7t5v0__nor3_1
X_0566_ _0160_ _0169_ _0039_ VDD VDD VSS VSS gf180mcu_fd_sc_mcu7t5v0__nor2_1
X_0567_ eff_q[15] eff_q[14] _0169_ _0040_ VDD VDD VSS VSS gf180mcu_fd_sc_mcu7t5v0__aoi21_1
X_0568_ eff_q[15] _0166_ eff_q[17] eff_q[16] _0041_ VDD VDD VSS VSS gf180mcu_fd_sc_mcu7t5v0__aoi211_1
X_0569_ eff_q[16] _0164_ eff_q[17] _0044_ VDD VDD VSS VSS gf180mcu_fd_sc_mcu7t5v0__aoi21_1
X_0570_ _0165_ _0044_ _0043_ VDD VDD VSS VSS gf180mcu_fd_sc_mcu7t5v0__and2_1
X_0571_ eff_q[17] _0167_ _0016_ VDD VDD VSS VSS gf180mcu_fd_sc_mcu7t5v0__nor2_1
X_0572_ eff_q[16] _0166_ _0167_ eff_q[17] _0015_ VDD VDD VSS VSS gf180mcu_fd_sc_mcu7t5v0__aoi211_1
X_0573_ _0158_ _0167_ eff_q[17] _0017_ VDD VDD VSS VSS gf180mcu_fd_sc_mcu7t5v0__aoi21_1
X_0574_ eff_q[14] _0167_ eff_q[17] _0018_ VDD VDD VSS VSS gf180mcu_fd_sc_mcu7t5v0__aoi21_1
X_0575_ _0166_ _0167_ eff_q[17] _0019_ VDD VDD VSS VSS gf180mcu_fd_sc_mcu7t5v0__aoi21_1
X_0576_ eff_q[15] eff_q[16] _0158_ eff_q[17] _0021_ VDD VDD VSS VSS gf180mcu_fd_sc_mcu7t5v0__oai31_1
X_0577_ eff_q[16] _0164_ eff_q[17] _0022_ VDD VDD VSS VSS gf180mcu_fd_sc_mcu7t5v0__oai21_1
X_0578_ eff_q[15] eff_q[16] _0166_ eff_q[17] _0023_ VDD VDD VSS VSS gf180mcu_fd_sc_mcu7t5v0__oai31_1
X_0579_ s_cs[1] s_cs[2] en_spi VDD VDD VSS VSS gf180mcu_fd_sc_mcu7t5v0__nand2_1
X_0580_ _0126_ s_fsk[2] en_spi _0170_ VDD VDD VSS VSS gf180mcu_fd_sc_mcu7t5v0__aoi21_1
X_0581_ _0126_ s_fsk[2] _0170_ g_eff.en VDD VDD VSS VSS gf180mcu_fd_sc_mcu7t5v0__oai21_1
X_0582_ acc[6] acc[7] _0171_ VDD VDD VSS VSS gf180mcu_fd_sc_mcu7t5v0__nor2_1
X_0583_ sd_en acc[0] acc[1] acc[4] _0172_ VDD VDD VSS VSS gf180mcu_fd_sc_mcu7t5v0__nor4_1
X_0584_ _0171_ _0172_ _0173_ VDD VDD VSS VSS gf180mcu_fd_sc_mcu7t5v0__nand2_1
X_0585_ acc[5] acc[2] acc[3] _0173_ _0174_ VDD VDD VSS VSS gf180mcu_fd_sc_mcu7t5v0__nor4_1
X_0586_ eff_q[1] eff_q[2] eff_q[3] eff_q[6] _0175_ VDD VDD VSS VSS gf180mcu_fd_sc_mcu7t5v0__nor4_1
X_0587_ sd_en _0127_ _0175_ _0176_ VDD VDD VSS VSS gf180mcu_fd_sc_mcu7t5v0__nand3_1
X_0588_ eff_q[5] eff_q[4] eff_q[7] _0176_ _0177_ VDD VDD VSS VSS gf180mcu_fd_sc_mcu7t5v0__nor4_1
X_0589_ _0174_ _0177_ net12 g_sd.en VDD VDD VSS VSS gf180mcu_fd_sc_mcu7t5v0__oai21_1
X_0590_ clknet_1_0__leaf_ck g_en net6 VDD VDD VSS VSS gf180mcu_fd_sc_mcu7t5v0__and2_1
X_0591_ eff_q[15] _0158_ _0169_ _0014_ VDD VDD VSS VSS gf180mcu_fd_sc_mcu7t5v0__nor3_1
X_0592_ eff_q[17] eff_int[9] _0178_ VDD VDD VSS VSS gf180mcu_fd_sc_mcu7t5v0__xor2_1
X_0593_ _0012_ eff_int[4] _0179_ VDD VDD VSS VSS gf180mcu_fd_sc_mcu7t5v0__nand2_1
X_0594_ _0012_ eff_int[4] _0008_ eff_int[0] _0180_ VDD VDD VSS VSS gf180mcu_fd_sc_mcu7t5v0__oai22_1
X_0595_ eff_q[11] eff_int[3] _0181_ VDD VDD VSS VSS gf180mcu_fd_sc_mcu7t5v0__xor2_1
X_0596_ eff_int[2] _0010_ eff_int[1] _0009_ _0182_ VDD VDD VSS VSS gf180mcu_fd_sc_mcu7t5v0__aoi22_1
X_0597_ eff_int[1] _0009_ eff_int[7] _0121_ _0182_ _0183_ VDD VDD VSS VSS gf180mcu_fd_sc_mcu7t5v0__oai221_1
X_0598_ _0122_ eff_int[8] eff_int[6] _0124_ _0184_ VDD VDD VSS VSS gf180mcu_fd_sc_mcu7t5v0__aoi22_1
X_0599_ _0124_ eff_int[6] _0184_ _0185_ VDD VDD VSS VSS gf180mcu_fd_sc_mcu7t5v0__oai21_1
X_0600_ _0123_ eff_int[5] _0183_ _0185_ _0186_ VDD VDD VSS VSS gf180mcu_fd_sc_mcu7t5v0__aoi211_1
X_0601_ _0122_ eff_int[8] _0179_ _0187_ VDD VDD VSS VSS gf180mcu_fd_sc_mcu7t5v0__oai21_1
X_0602_ eff_int[2] _0010_ eff_int[5] _0123_ _0188_ VDD VDD VSS VSS gf180mcu_fd_sc_mcu7t5v0__oai22_1
X_0603_ _0121_ eff_int[7] _0008_ eff_int[0] _0188_ _0189_ VDD VDD VSS VSS gf180mcu_fd_sc_mcu7t5v0__aoi221_1
X_0604_ _0178_ _0180_ _0181_ _0187_ _0190_ VDD VDD VSS VSS gf180mcu_fd_sc_mcu7t5v0__nor4_1
X_0605_ _0186_ _0189_ _0190_ g_dec.en VDD VDD VSS VSS gf180mcu_fd_sc_mcu7t5v0__nand3_1
X_0606_ fsk_inv s_fsk[1] _0191_ VDD VDD VSS VSS gf180mcu_fd_sc_mcu7t5v0__xor2_2
X_0607_ s_fsk[1] fsk_inv _0192_ VDD VDD VSS VSS gf180mcu_fd_sc_mcu7t5v0__xnor2_2
X_0608_ devx[0] devx[1] _0193_ VDD VDD VSS VSS gf180mcu_fd_sc_mcu7t5v0__nor2_1
X_0609_ _0191_ _0193_ _0194_ VDD VDD VSS VSS gf180mcu_fd_sc_mcu7t5v0__nor2_4
X_0610_ _0191_ _0193_ _0135_ _0195_ VDD VDD VSS VSS gf180mcu_fd_sc_mcu7t5v0__oai21_2
X_0611_ devx[3] devx[4] _0195_ _0196_ VDD VDD VSS VSS gf180mcu_fd_sc_mcu7t5v0__or3_2
X_0612_ devx[5] devx[6] _0196_ _0197_ VDD VDD VSS VSS gf180mcu_fd_sc_mcu7t5v0__nor3_2
X_0613_ _0136_ _0197_ _0198_ VDD VDD VSS VSS gf180mcu_fd_sc_mcu7t5v0__nand2_2
X_0614_ _0198_ devx[9] devx[10] devx[8] _0199_ VDD VDD VSS VSS gf180mcu_fd_sc_mcu7t5v0__nor4_4
X_0615_ _0192_ _0195_ _0200_ VDD VDD VSS VSS gf180mcu_fd_sc_mcu7t5v0__nand2_1
X_0616_ devx[3] _0195_ _0192_ _0201_ VDD VDD VSS VSS gf180mcu_fd_sc_mcu7t5v0__oai21_1
X_0617_ _0192_ _0196_ _0202_ VDD VDD VSS VSS gf180mcu_fd_sc_mcu7t5v0__nand2_1
X_0618_ devx[5] _0196_ _0192_ _0203_ VDD VDD VSS VSS gf180mcu_fd_sc_mcu7t5v0__oai21_1
X_0619_ _0191_ _0197_ _0204_ VDD VDD VSS VSS gf180mcu_fd_sc_mcu7t5v0__nor2_1
X_0620_ _0192_ _0198_ _0205_ VDD VDD VSS VSS gf180mcu_fd_sc_mcu7t5v0__nand2_1
X_0621_ devx[8] _0198_ _0192_ _0206_ VDD VDD VSS VSS gf180mcu_fd_sc_mcu7t5v0__oai21_1
X_0622_ devx[8] devx[9] _0198_ _0192_ _0207_ VDD VDD VSS VSS gf180mcu_fd_sc_mcu7t5v0__oai31_2
X_0623_ net62 _0199_ _0208_ VDD VDD VSS VSS gf180mcu_fd_sc_mcu7t5v0__nor2_1
X_0624_ devx[11] _0208_ _0209_ VDD VDD VSS VSS gf180mcu_fd_sc_mcu7t5v0__xor2_1
X_0625_ base[11] _0209_ _0210_ VDD VDD VSS VSS gf180mcu_fd_sc_mcu7t5v0__and2_1
X_0626_ devx[10] _0207_ _0211_ VDD VDD VSS VSS gf180mcu_fd_sc_mcu7t5v0__xnor2_1
X_0627_ base[10] _0211_ _0212_ VDD VDD VSS VSS gf180mcu_fd_sc_mcu7t5v0__nand2_1
X_0628_ devx[9] _0206_ _0213_ VDD VDD VSS VSS gf180mcu_fd_sc_mcu7t5v0__xnor2_1
X_0629_ base[9] _0213_ _0214_ VDD VDD VSS VSS gf180mcu_fd_sc_mcu7t5v0__and2_1
X_0630_ devx[8] _0205_ _0215_ VDD VDD VSS VSS gf180mcu_fd_sc_mcu7t5v0__xnor2_1
X_0631_ base[8] _0215_ _0216_ VDD VDD VSS VSS gf180mcu_fd_sc_mcu7t5v0__nand2_1
X_0632_ devx[7] _0204_ _0217_ VDD VDD VSS VSS gf180mcu_fd_sc_mcu7t5v0__xor2_1
X_0633_ base[7] _0217_ _0218_ VDD VDD VSS VSS gf180mcu_fd_sc_mcu7t5v0__and2_1
X_0634_ devx[6] _0203_ _0219_ VDD VDD VSS VSS gf180mcu_fd_sc_mcu7t5v0__xnor2_1
X_0635_ base[6] _0219_ _0220_ VDD VDD VSS VSS gf180mcu_fd_sc_mcu7t5v0__nand2_1
X_0636_ devx[5] _0202_ _0221_ VDD VDD VSS VSS gf180mcu_fd_sc_mcu7t5v0__xnor2_1
X_0637_ base[5] _0221_ _0222_ VDD VDD VSS VSS gf180mcu_fd_sc_mcu7t5v0__and2_1
X_0638_ _0201_ devx[4] _0223_ VDD VDD VSS VSS gf180mcu_fd_sc_mcu7t5v0__xnor2_1
X_0639_ base[4] _0223_ _0224_ VDD VDD VSS VSS gf180mcu_fd_sc_mcu7t5v0__nand2_1
X_0640_ devx[3] _0200_ _0225_ VDD VDD VSS VSS gf180mcu_fd_sc_mcu7t5v0__xnor2_1
X_0641_ base[3] _0225_ _0226_ VDD VDD VSS VSS gf180mcu_fd_sc_mcu7t5v0__and2_1
X_0642_ _0194_ devx[2] _0227_ VDD VDD VSS VSS gf180mcu_fd_sc_mcu7t5v0__xor2_1
X_0643_ base[2] _0227_ _0228_ VDD VDD VSS VSS gf180mcu_fd_sc_mcu7t5v0__nand2_1
X_0644_ devx[0] _0134_ _0192_ _0229_ VDD VDD VSS VSS gf180mcu_fd_sc_mcu7t5v0__nand3_1
X_0645_ _0133_ net62 devx[1] _0230_ VDD VDD VSS VSS gf180mcu_fd_sc_mcu7t5v0__oai21_2
X_0646_ _0229_ _0230_ _0231_ VDD VDD VSS VSS gf180mcu_fd_sc_mcu7t5v0__and2_1
X_0647_ _0229_ _0230_ _0152_ _0232_ VDD VDD VSS VSS gf180mcu_fd_sc_mcu7t5v0__aoi21_1
X_0648_ base[0] devx[0] _0233_ VDD VDD VSS VSS gf180mcu_fd_sc_mcu7t5v0__nand2_1
X_0649_ _0233_ _0234_ VDD VDD VSS VSS gf180mcu_fd_sc_mcu7t5v0__clkinv_1
X_0650_ _0152_ _0229_ _0230_ _0235_ VDD VDD VSS VSS gf180mcu_fd_sc_mcu7t5v0__nand3_2
X_0651_ _0234_ _0235_ _0232_ _0236_ VDD VDD VSS VSS gf180mcu_fd_sc_mcu7t5v0__aoi21_4
X_0652_ _0227_ _0151_ _0237_ VDD VDD VSS VSS gf180mcu_fd_sc_mcu7t5v0__xor2_2
X_0653_ _0237_ _0236_ _0228_ _0238_ VDD VDD VSS VSS gf180mcu_fd_sc_mcu7t5v0__oai21_4
X_0654_ base[3] _0225_ _0239_ VDD VDD VSS VSS gf180mcu_fd_sc_mcu7t5v0__or2_1
X_0655_ _0238_ _0239_ _0226_ _0240_ VDD VDD VSS VSS gf180mcu_fd_sc_mcu7t5v0__aoi21_4
X_0656_ _0149_ _0223_ _0241_ VDD VDD VSS VSS gf180mcu_fd_sc_mcu7t5v0__xor2_2
X_0657_ _0241_ _0240_ _0224_ _0242_ VDD VDD VSS VSS gf180mcu_fd_sc_mcu7t5v0__oai21_4
X_0658_ base[5] _0221_ _0243_ VDD VDD VSS VSS gf180mcu_fd_sc_mcu7t5v0__or2_1
X_0659_ _0242_ _0243_ _0222_ _0244_ VDD VDD VSS VSS gf180mcu_fd_sc_mcu7t5v0__aoi21_4
X_0660_ base[6] _0219_ _0245_ VDD VDD VSS VSS gf180mcu_fd_sc_mcu7t5v0__nor2_1
X_0661_ _0245_ _0244_ _0220_ _0246_ VDD VDD VSS VSS gf180mcu_fd_sc_mcu7t5v0__oai21_4
X_0662_ base[7] _0217_ _0247_ VDD VDD VSS VSS gf180mcu_fd_sc_mcu7t5v0__or2_1
X_0663_ _0246_ _0247_ _0218_ _0248_ VDD VDD VSS VSS gf180mcu_fd_sc_mcu7t5v0__aoi21_4
X_0664_ base[8] _0215_ _0249_ VDD VDD VSS VSS gf180mcu_fd_sc_mcu7t5v0__nor2_1
X_0665_ _0249_ _0248_ _0216_ _0250_ VDD VDD VSS VSS gf180mcu_fd_sc_mcu7t5v0__oai21_4
X_0666_ base[9] _0213_ _0251_ VDD VDD VSS VSS gf180mcu_fd_sc_mcu7t5v0__or2_1
X_0667_ _0250_ _0251_ _0214_ _0252_ VDD VDD VSS VSS gf180mcu_fd_sc_mcu7t5v0__aoi21_4
X_0668_ _0143_ _0211_ _0253_ VDD VDD VSS VSS gf180mcu_fd_sc_mcu7t5v0__xor2_2
X_0669_ _0253_ _0252_ _0212_ _0254_ VDD VDD VSS VSS gf180mcu_fd_sc_mcu7t5v0__oai21_4
X_0670_ base[11] _0209_ _0255_ VDD VDD VSS VSS gf180mcu_fd_sc_mcu7t5v0__or2_1
X_0671_ _0255_ _0254_ _0210_ _0256_ VDD VDD VSS VSS gf180mcu_fd_sc_mcu7t5v0__aoi21_4
X_0672_ devx[11] _0192_ _0208_ _0257_ VDD VDD VSS VSS gf180mcu_fd_sc_mcu7t5v0__aoi21_1
X_0673_ _0137_ _0199_ net62 _0258_ VDD VDD VSS VSS gf180mcu_fd_sc_mcu7t5v0__aoi21_4
X_0674_ base[12] _0258_ _0259_ VDD VDD VSS VSS gf180mcu_fd_sc_mcu7t5v0__nand2_1
X_0675_ _0141_ _0257_ _0260_ VDD VDD VSS VSS gf180mcu_fd_sc_mcu7t5v0__nand2_1
X_0676_ _0259_ _0260_ _0261_ VDD VDD VSS VSS gf180mcu_fd_sc_mcu7t5v0__nand2_1
X_0677_ base[13] _0258_ _0262_ VDD VDD VSS VSS gf180mcu_fd_sc_mcu7t5v0__xor2_1
X_0678_ _0262_ _0263_ VDD VDD VSS VSS gf180mcu_fd_sc_mcu7t5v0__clkinv_1
X_0679_ _0256_ _0261_ _0263_ _0264_ VDD VDD VSS VSS gf180mcu_fd_sc_mcu7t5v0__or3_1
X_0680_ _0138_ _0258_ _0265_ VDD VDD VSS VSS gf180mcu_fd_sc_mcu7t5v0__xor2_1
X_0681_ _0139_ _0257_ _0266_ VDD VDD VSS VSS gf180mcu_fd_sc_mcu7t5v0__nor2_1
X_0682_ _0139_ _0258_ _0267_ VDD VDD VSS VSS gf180mcu_fd_sc_mcu7t5v0__xor2_1
X_0683_ _0265_ _0267_ _0268_ VDD VDD VSS VSS gf180mcu_fd_sc_mcu7t5v0__or2_1
X_0684_ _0256_ _0261_ _0263_ _0268_ _0269_ VDD VDD VSS VSS gf180mcu_fd_sc_mcu7t5v0__nor4_4
X_0685_ _0256_ _0261_ _0263_ _0268_ _0270_ VDD VDD VSS VSS gf180mcu_fd_sc_mcu7t5v0__or4_4
X_0686_ base[13] base[12] _0258_ _0271_ VDD VDD VSS VSS gf180mcu_fd_sc_mcu7t5v0__oai21_1
X_0687_ base[15] base[14] _0258_ _0272_ VDD VDD VSS VSS gf180mcu_fd_sc_mcu7t5v0__oai21_1
X_0688_ _0271_ _0272_ _0273_ VDD VDD VSS VSS gf180mcu_fd_sc_mcu7t5v0__nand2_1
X_0689_ _0269_ _0273_ _0274_ VDD VDD VSS VSS gf180mcu_fd_sc_mcu7t5v0__nor2_1
X_0690_ _0153_ _0258_ _0275_ VDD VDD VSS VSS gf180mcu_fd_sc_mcu7t5v0__nand2_1
X_0691_ _0269_ _0273_ _0275_ _0276_ VDD VDD VSS VSS gf180mcu_fd_sc_mcu7t5v0__nor3_1
X_0692_ _0269_ _0273_ _0275_ _0154_ _0277_ VDD VDD VSS VSS gf180mcu_fd_sc_mcu7t5v0__oai31_4
X_0693_ _0271_ _0270_ _0153_ _0258_ _0278_ VDD VDD VSS VSS gf180mcu_fd_sc_mcu7t5v0__aoi211_4
X_0694_ _0154_ _0278_ _0279_ VDD VDD VSS VSS gf180mcu_fd_sc_mcu7t5v0__or2_1
X_0695_ _0278_ _0154_ _0277_ _0280_ VDD VDD VSS VSS gf180mcu_fd_sc_mcu7t5v0__oai21_4
X_0696_ _0132_ _0133_ _0281_ VDD VDD VSS VSS gf180mcu_fd_sc_mcu7t5v0__nand2_1
X_0697_ _0277_ _0279_ _0281_ _0233_ _0282_ VDD VDD VSS VSS gf180mcu_fd_sc_mcu7t5v0__aoi22_1
X_0698_ _0280_ net62 fsk_en _0283_ VDD VDD VSS VSS gf180mcu_fd_sc_mcu7t5v0__oai21_4
X_0699_ fsk_en _0132_ _0282_ net58 eff[0] VDD VDD VSS VSS gf180mcu_fd_sc_mcu7t5v0__oai22_1
X_0700_ base[1] _0231_ _0234_ _0284_ VDD VDD VSS VSS gf180mcu_fd_sc_mcu7t5v0__xor3_1
X_0701_ _0280_ _0284_ _0285_ VDD VDD VSS VSS gf180mcu_fd_sc_mcu7t5v0__and2_1
X_0702_ fsk_en _0152_ net58 _0285_ eff[1] VDD VDD VSS VSS gf180mcu_fd_sc_mcu7t5v0__oai22_1
X_0703_ _0236_ _0237_ _0286_ VDD VDD VSS VSS gf180mcu_fd_sc_mcu7t5v0__xnor2_1
X_0704_ net60 _0286_ _0287_ VDD VDD VSS VSS gf180mcu_fd_sc_mcu7t5v0__and2_1
X_0705_ fsk_en _0151_ net58 _0287_ eff[2] VDD VDD VSS VSS gf180mcu_fd_sc_mcu7t5v0__oai22_2
X_0706_ base[3] _0225_ _0238_ _0288_ VDD VDD VSS VSS gf180mcu_fd_sc_mcu7t5v0__xor3_1
X_0707_ _0277_ _0279_ _0288_ _0289_ VDD VDD VSS VSS gf180mcu_fd_sc_mcu7t5v0__aoi21_1
X_0708_ fsk_en _0150_ net58 _0289_ eff[3] VDD VDD VSS VSS gf180mcu_fd_sc_mcu7t5v0__oai22_1
X_0709_ _0240_ _0241_ _0290_ VDD VDD VSS VSS gf180mcu_fd_sc_mcu7t5v0__xnor2_1
X_0710_ net60 _0290_ _0291_ VDD VDD VSS VSS gf180mcu_fd_sc_mcu7t5v0__and2_1
X_0711_ fsk_en _0149_ net58 _0291_ eff[4] VDD VDD VSS VSS gf180mcu_fd_sc_mcu7t5v0__oai22_1
X_0712_ _0148_ _0221_ _0242_ _0292_ VDD VDD VSS VSS gf180mcu_fd_sc_mcu7t5v0__xor3_1
X_0713_ net60 _0292_ _0293_ VDD VDD VSS VSS gf180mcu_fd_sc_mcu7t5v0__and2_1
X_0714_ fsk_en _0148_ net58 _0293_ eff[5] VDD VDD VSS VSS gf180mcu_fd_sc_mcu7t5v0__oai22_2
X_0715_ base[6] _0219_ _0244_ _0294_ VDD VDD VSS VSS gf180mcu_fd_sc_mcu7t5v0__xor3_1
X_0716_ net60 _0294_ _0295_ VDD VDD VSS VSS gf180mcu_fd_sc_mcu7t5v0__and2_1
X_0717_ fsk_en _0147_ net58 _0295_ eff[6] VDD VDD VSS VSS gf180mcu_fd_sc_mcu7t5v0__oai22_1
X_0718_ _0146_ _0217_ _0246_ _0296_ VDD VDD VSS VSS gf180mcu_fd_sc_mcu7t5v0__xor3_1
X_0719_ net60 _0296_ _0297_ VDD VDD VSS VSS gf180mcu_fd_sc_mcu7t5v0__and2_4
X_0720_ fsk_en _0146_ _0297_ net58 eff[7] VDD VDD VSS VSS gf180mcu_fd_sc_mcu7t5v0__oai22_2
X_0721_ base[8] _0215_ _0248_ _0298_ VDD VDD VSS VSS gf180mcu_fd_sc_mcu7t5v0__xor3_1
X_0722_ net61 _0298_ _0299_ VDD VDD VSS VSS gf180mcu_fd_sc_mcu7t5v0__and2_1
X_0723_ fsk_en _0145_ net59 _0299_ eff[8] VDD VDD VSS VSS gf180mcu_fd_sc_mcu7t5v0__oai22_1
X_0724_ _0144_ _0213_ _0250_ _0300_ VDD VDD VSS VSS gf180mcu_fd_sc_mcu7t5v0__xor3_1
X_0725_ net61 _0300_ _0301_ VDD VDD VSS VSS gf180mcu_fd_sc_mcu7t5v0__and2_1
X_0726_ fsk_en _0144_ net59 _0301_ eff[9] VDD VDD VSS VSS gf180mcu_fd_sc_mcu7t5v0__oai22_1
X_0727_ _0252_ _0253_ _0302_ VDD VDD VSS VSS gf180mcu_fd_sc_mcu7t5v0__xnor2_1
X_0728_ net61 _0302_ _0303_ VDD VDD VSS VSS gf180mcu_fd_sc_mcu7t5v0__and2_1
X_0729_ fsk_en _0143_ net59 _0303_ eff[10] VDD VDD VSS VSS gf180mcu_fd_sc_mcu7t5v0__oai22_1
X_0730_ _0142_ _0209_ _0254_ _0304_ VDD VDD VSS VSS gf180mcu_fd_sc_mcu7t5v0__xor3_1
X_0731_ net61 _0304_ _0305_ VDD VDD VSS VSS gf180mcu_fd_sc_mcu7t5v0__and2_1
X_0732_ fsk_en _0142_ net59 _0305_ eff[11] VDD VDD VSS VSS gf180mcu_fd_sc_mcu7t5v0__oai22_1
X_0733_ _0256_ _0261_ _0306_ VDD VDD VSS VSS gf180mcu_fd_sc_mcu7t5v0__xnor2_1
X_0734_ net61 _0306_ _0307_ VDD VDD VSS VSS gf180mcu_fd_sc_mcu7t5v0__and2_1
X_0735_ fsk_en _0141_ net59 _0307_ eff[12] VDD VDD VSS VSS gf180mcu_fd_sc_mcu7t5v0__oai22_1
X_0736_ _0256_ _0261_ _0259_ _0308_ VDD VDD VSS VSS gf180mcu_fd_sc_mcu7t5v0__oai21_1
X_0737_ _0263_ _0308_ _0309_ VDD VDD VSS VSS gf180mcu_fd_sc_mcu7t5v0__xor2_1
X_0738_ net61 _0309_ _0310_ VDD VDD VSS VSS gf180mcu_fd_sc_mcu7t5v0__and2_2
X_0739_ fsk_en _0140_ net59 _0310_ eff[13] VDD VDD VSS VSS gf180mcu_fd_sc_mcu7t5v0__oai22_1
X_0740_ _0264_ _0271_ _0311_ VDD VDD VSS VSS gf180mcu_fd_sc_mcu7t5v0__nand2_1
X_0741_ _0264_ _0271_ _0267_ _0312_ VDD VDD VSS VSS gf180mcu_fd_sc_mcu7t5v0__aoi21_1
X_0742_ _0267_ _0311_ _0313_ VDD VDD VSS VSS gf180mcu_fd_sc_mcu7t5v0__xor2_1
X_0743_ net61 _0313_ _0314_ VDD VDD VSS VSS gf180mcu_fd_sc_mcu7t5v0__and2_1
X_0744_ fsk_en _0139_ net59 _0314_ eff[14] VDD VDD VSS VSS gf180mcu_fd_sc_mcu7t5v0__oai22_1
X_0745_ _0265_ _0266_ _0312_ _0315_ VDD VDD VSS VSS gf180mcu_fd_sc_mcu7t5v0__or3_1
X_0746_ _0266_ _0312_ _0265_ _0316_ VDD VDD VSS VSS gf180mcu_fd_sc_mcu7t5v0__oai21_1
X_0747_ net61 _0315_ _0316_ _0317_ VDD VDD VSS VSS gf180mcu_fd_sc_mcu7t5v0__and3_1
X_0748_ fsk_en _0138_ net59 _0317_ eff[15] VDD VDD VSS VSS gf180mcu_fd_sc_mcu7t5v0__oai22_1
X_0749_ _0153_ _0257_ _0274_ _0318_ VDD VDD VSS VSS gf180mcu_fd_sc_mcu7t5v0__xor3_1
X_0750_ net61 _0318_ _0319_ VDD VDD VSS VSS gf180mcu_fd_sc_mcu7t5v0__and2_1
X_0751_ fsk_en _0153_ net59 _0319_ eff[16] VDD VDD VSS VSS gf180mcu_fd_sc_mcu7t5v0__oai22_1
X_0752_ base[17] _0276_ _0320_ VDD VDD VSS VSS gf180mcu_fd_sc_mcu7t5v0__xor2_1
X_0753_ _0278_ _0320_ _0321_ VDD VDD VSS VSS gf180mcu_fd_sc_mcu7t5v0__nor2_1
X_0754_ fsk_en _0154_ net59 _0321_ eff[17] VDD VDD VSS VSS gf180mcu_fd_sc_mcu7t5v0__oai22_1
X_0755_ acc[7] eff_q[7] _0322_ VDD VDD VSS VSS gf180mcu_fd_sc_mcu7t5v0__nand2_1
X_0756_ acc[5] eff_q[5] _0323_ VDD VDD VSS VSS gf180mcu_fd_sc_mcu7t5v0__nand2_1
X_0757_ acc[4] eff_q[4] _0324_ VDD VDD VSS VSS gf180mcu_fd_sc_mcu7t5v0__nand2_1
X_0758_ acc[4] eff_q[4] _0325_ VDD VDD VSS VSS gf180mcu_fd_sc_mcu7t5v0__xor2_1
X_0759_ acc[3] eff_q[3] _0326_ VDD VDD VSS VSS gf180mcu_fd_sc_mcu7t5v0__nor2_1
X_0760_ acc[3] eff_q[3] _0327_ VDD VDD VSS VSS gf180mcu_fd_sc_mcu7t5v0__nand2_1
X_0761_ acc[2] eff_q[2] _0328_ VDD VDD VSS VSS gf180mcu_fd_sc_mcu7t5v0__and2_1
X_0762_ acc[1] eff_q[1] _0329_ VDD VDD VSS VSS gf180mcu_fd_sc_mcu7t5v0__nand2_1
X_0763_ acc[1] eff_q[1] _0330_ VDD VDD VSS VSS gf180mcu_fd_sc_mcu7t5v0__xor2_1
X_0764_ acc[0] eff_q[0] _0331_ VDD VDD VSS VSS gf180mcu_fd_sc_mcu7t5v0__and2_1
X_0765_ _0330_ _0331_ _0332_ VDD VDD VSS VSS gf180mcu_fd_sc_mcu7t5v0__nand2_1
X_0766_ _0329_ _0332_ _0333_ VDD VDD VSS VSS gf180mcu_fd_sc_mcu7t5v0__nand2_1
X_0767_ acc[2] eff_q[2] _0334_ VDD VDD VSS VSS gf180mcu_fd_sc_mcu7t5v0__xor2_1
X_0768_ _0333_ _0334_ _0328_ _0335_ VDD VDD VSS VSS gf180mcu_fd_sc_mcu7t5v0__aoi21_1
X_0769_ _0326_ _0335_ _0327_ _0336_ VDD VDD VSS VSS gf180mcu_fd_sc_mcu7t5v0__oai21_1
X_0770_ _0325_ _0336_ _0337_ VDD VDD VSS VSS gf180mcu_fd_sc_mcu7t5v0__nand2_1
X_0771_ _0324_ _0337_ _0338_ VDD VDD VSS VSS gf180mcu_fd_sc_mcu7t5v0__nand2_1
X_0772_ acc[5] eff_q[5] _0339_ VDD VDD VSS VSS gf180mcu_fd_sc_mcu7t5v0__xor2_1
X_0773_ _0338_ _0339_ _0340_ VDD VDD VSS VSS gf180mcu_fd_sc_mcu7t5v0__nand2_1
X_0774_ acc[6] eff_q[6] _0341_ VDD VDD VSS VSS gf180mcu_fd_sc_mcu7t5v0__xnor2_1
X_0775_ _0323_ _0340_ _0341_ _0342_ VDD VDD VSS VSS gf180mcu_fd_sc_mcu7t5v0__aoi21_1
X_0776_ acc[6] eff_q[6] _0342_ _0343_ VDD VDD VSS VSS gf180mcu_fd_sc_mcu7t5v0__aoi21_1
X_0777_ _0322_ _0343_ _0344_ VDD VDD VSS VSS gf180mcu_fd_sc_mcu7t5v0__nand2_1
X_0778_ acc[7] eff_q[7] _0344_ sd_en _0013_ VDD VDD VSS VSS gf180mcu_fd_sc_mcu7t5v0__oai211_1
X_0779_ acc[0] eff_q[0] sd_en _0345_ VDD VDD VSS VSS gf180mcu_fd_sc_mcu7t5v0__oai21_1
X_0780_ _0331_ _0345_ _0000_ VDD VDD VSS VSS gf180mcu_fd_sc_mcu7t5v0__nor2_1
X_0781_ _0330_ _0331_ sd_en _0346_ VDD VDD VSS VSS gf180mcu_fd_sc_mcu7t5v0__oai21_1
X_0782_ _0330_ _0331_ _0346_ _0001_ VDD VDD VSS VSS gf180mcu_fd_sc_mcu7t5v0__aoi21_1
X_0783_ _0333_ _0334_ sd_en _0347_ VDD VDD VSS VSS gf180mcu_fd_sc_mcu7t5v0__oai21_1
X_0784_ _0333_ _0334_ _0347_ _0002_ VDD VDD VSS VSS gf180mcu_fd_sc_mcu7t5v0__aoi21_1
X_0785_ acc[3] eff_q[3] _0348_ VDD VDD VSS VSS gf180mcu_fd_sc_mcu7t5v0__xnor2_1
X_0786_ _0335_ _0348_ sd_en _0349_ VDD VDD VSS VSS gf180mcu_fd_sc_mcu7t5v0__oai21_1
X_0787_ _0335_ _0348_ _0349_ _0003_ VDD VDD VSS VSS gf180mcu_fd_sc_mcu7t5v0__aoi21_1
X_0788_ _0325_ _0336_ sd_en _0350_ VDD VDD VSS VSS gf180mcu_fd_sc_mcu7t5v0__oai21_1
X_0789_ _0325_ _0336_ _0350_ _0004_ VDD VDD VSS VSS gf180mcu_fd_sc_mcu7t5v0__aoi21_1
X_0790_ _0338_ _0339_ sd_en _0351_ VDD VDD VSS VSS gf180mcu_fd_sc_mcu7t5v0__oai21_1
X_0791_ _0338_ _0339_ _0351_ _0005_ VDD VDD VSS VSS gf180mcu_fd_sc_mcu7t5v0__aoi21_1
X_0792_ _0323_ _0340_ _0341_ _0352_ VDD VDD VSS VSS gf180mcu_fd_sc_mcu7t5v0__nand3_1
X_0793_ sd_en _0352_ _0353_ VDD VDD VSS VSS gf180mcu_fd_sc_mcu7t5v0__nand2_1
X_0794_ _0342_ _0353_ _0006_ VDD VDD VSS VSS gf180mcu_fd_sc_mcu7t5v0__nor2_1
X_0795_ acc[7] eff_q[7] _0354_ VDD VDD VSS VSS gf180mcu_fd_sc_mcu7t5v0__xnor2_1
X_0796_ _0343_ _0354_ sd_en _0355_ VDD VDD VSS VSS gf180mcu_fd_sc_mcu7t5v0__oai21_1
X_0797_ _0343_ _0354_ _0355_ _0007_ VDD VDD VSS VSS gf180mcu_fd_sc_mcu7t5v0__aoi21_1
X_0798_ bitcnt[2] bitcnt[3] _0356_ VDD VDD VSS VSS gf180mcu_fd_sc_mcu7t5v0__or2_1
X_0799_ bitcnt[4] s_sclk[1] _0357_ VDD VDD VSS VSS gf180mcu_fd_sc_mcu7t5v0__nor2_1
X_0800_ s_sclk[2] rnw _0356_ _0357_ _0358_ VDD VDD VSS VSS gf180mcu_fd_sc_mcu7t5v0__nand4_2
X_0801_ rd[11] _0358_ _0359_ VDD VDD VSS VSS gf180mcu_fd_sc_mcu7t5v0__nor2_1
X_0802_ _0157_ _0358_ _0359_ s_cs[1] _0053_ VDD VDD VSS VSS gf180mcu_fd_sc_mcu7t5v0__aoi211_1
X_0803_ s_sclk[1] _0128_ _0360_ VDD VDD VSS VSS gf180mcu_fd_sc_mcu7t5v0__nand2_1
X_0804_ s_cs[1] _0360_ _0361_ VDD VDD VSS VSS gf180mcu_fd_sc_mcu7t5v0__nor2_1
X_0805_ _0125_ s_sclk[1] _0128_ _0362_ VDD VDD VSS VSS gf180mcu_fd_sc_mcu7t5v0__nand3_2
X_0806_ sr[13] _0362_ _0363_ VDD VDD VSS VSS gf180mcu_fd_sc_mcu7t5v0__nor2_1
X_0807_ _0363_ _0364_ VDD VDD VSS VSS gf180mcu_fd_sc_mcu7t5v0__clkinv_1
X_0808_ bitcnt[0] bitcnt[1] _0365_ VDD VDD VSS VSS gf180mcu_fd_sc_mcu7t5v0__nand2_1
X_0809_ bitcnt[4] _0365_ _0366_ VDD VDD VSS VSS gf180mcu_fd_sc_mcu7t5v0__nor2_1
X_0810_ bitcnt[2] bitcnt[3] _0366_ _0367_ VDD VDD VSS VSS gf180mcu_fd_sc_mcu7t5v0__nand3_1
X_0811_ sr[14] _0367_ _0368_ VDD VDD VSS VSS gf180mcu_fd_sc_mcu7t5v0__nor2_1
X_0812_ _0368_ _0369_ VDD VDD VSS VSS gf180mcu_fd_sc_mcu7t5v0__clkinv_1
X_0813_ sr[12] sr[11] _0364_ _0369_ _0370_ VDD VDD VSS VSS gf180mcu_fd_sc_mcu7t5v0__nor4_1
X_0814_ s_mosi[1] net48 _0371_ VDD VDD VSS VSS gf180mcu_fd_sc_mcu7t5v0__nand2_1
X_0815_ _0145_ net48 _0371_ _0054_ VDD VDD VSS VSS gf180mcu_fd_sc_mcu7t5v0__oai21_1
X_0816_ sr[0] net48 _0372_ VDD VDD VSS VSS gf180mcu_fd_sc_mcu7t5v0__nand2_1
X_0817_ _0144_ net48 _0372_ _0055_ VDD VDD VSS VSS gf180mcu_fd_sc_mcu7t5v0__oai21_1
X_0818_ sr[1] net48 _0373_ VDD VDD VSS VSS gf180mcu_fd_sc_mcu7t5v0__nand2_1
X_0819_ _0143_ net48 _0373_ _0056_ VDD VDD VSS VSS gf180mcu_fd_sc_mcu7t5v0__oai21_1
X_0820_ sr[2] net48 _0374_ VDD VDD VSS VSS gf180mcu_fd_sc_mcu7t5v0__nand2_1
X_0821_ _0142_ net48 _0374_ _0057_ VDD VDD VSS VSS gf180mcu_fd_sc_mcu7t5v0__oai21_1
X_0822_ sr[3] net49 _0375_ VDD VDD VSS VSS gf180mcu_fd_sc_mcu7t5v0__nand2_1
X_0823_ _0141_ net49 _0375_ _0058_ VDD VDD VSS VSS gf180mcu_fd_sc_mcu7t5v0__oai21_1
X_0824_ sr[4] net49 _0376_ VDD VDD VSS VSS gf180mcu_fd_sc_mcu7t5v0__nand2_1
X_0825_ _0140_ net49 _0376_ _0059_ VDD VDD VSS VSS gf180mcu_fd_sc_mcu7t5v0__oai21_1
X_0826_ sr[5] net49 _0377_ VDD VDD VSS VSS gf180mcu_fd_sc_mcu7t5v0__nand2_1
X_0827_ _0139_ net49 _0377_ _0060_ VDD VDD VSS VSS gf180mcu_fd_sc_mcu7t5v0__oai21_1
X_0828_ sr[6] net49 _0378_ VDD VDD VSS VSS gf180mcu_fd_sc_mcu7t5v0__nand2_1
X_0829_ _0138_ net49 _0378_ _0061_ VDD VDD VSS VSS gf180mcu_fd_sc_mcu7t5v0__oai21_1
X_0830_ sr[7] net49 _0379_ VDD VDD VSS VSS gf180mcu_fd_sc_mcu7t5v0__nand2_1
X_0831_ _0153_ net48 _0379_ _0062_ VDD VDD VSS VSS gf180mcu_fd_sc_mcu7t5v0__oai21_1
X_0832_ sr[8] net49 _0380_ VDD VDD VSS VSS gf180mcu_fd_sc_mcu7t5v0__nand2_1
X_0833_ _0154_ net48 _0380_ _0063_ VDD VDD VSS VSS gf180mcu_fd_sc_mcu7t5v0__oai21_1
X_0834_ _0129_ sr[11] _0363_ _0368_ _0381_ VDD VDD VSS VSS gf180mcu_fd_sc_mcu7t5v0__nand4_1
X_0835_ base[0] _0381_ _0382_ VDD VDD VSS VSS gf180mcu_fd_sc_mcu7t5v0__nand2_1
X_0836_ _0155_ _0381_ _0382_ _0064_ VDD VDD VSS VSS gf180mcu_fd_sc_mcu7t5v0__oai21_1
X_0837_ sr[0] _0381_ _0383_ VDD VDD VSS VSS gf180mcu_fd_sc_mcu7t5v0__nor2_1
X_0838_ _0152_ _0381_ _0383_ _0065_ VDD VDD VSS VSS gf180mcu_fd_sc_mcu7t5v0__aoi21_1
X_0839_ base[2] _0381_ _0384_ VDD VDD VSS VSS gf180mcu_fd_sc_mcu7t5v0__nand2_1
X_0840_ _0156_ _0381_ _0384_ _0066_ VDD VDD VSS VSS gf180mcu_fd_sc_mcu7t5v0__oai21_1
X_0841_ sr[2] _0381_ _0385_ VDD VDD VSS VSS gf180mcu_fd_sc_mcu7t5v0__nor2_1
X_0842_ _0150_ _0381_ _0385_ _0067_ VDD VDD VSS VSS gf180mcu_fd_sc_mcu7t5v0__aoi21_1
X_0843_ sr[3] _0381_ _0386_ VDD VDD VSS VSS gf180mcu_fd_sc_mcu7t5v0__nor2_1
X_0844_ _0149_ _0381_ _0386_ _0068_ VDD VDD VSS VSS gf180mcu_fd_sc_mcu7t5v0__aoi21_1
X_0845_ sr[4] _0381_ _0387_ VDD VDD VSS VSS gf180mcu_fd_sc_mcu7t5v0__nor2_1
X_0846_ _0148_ _0381_ _0387_ _0069_ VDD VDD VSS VSS gf180mcu_fd_sc_mcu7t5v0__aoi21_1
X_0847_ sr[5] _0381_ _0388_ VDD VDD VSS VSS gf180mcu_fd_sc_mcu7t5v0__nor2_1
X_0848_ _0147_ _0381_ _0388_ _0070_ VDD VDD VSS VSS gf180mcu_fd_sc_mcu7t5v0__aoi21_1
X_0849_ sr[6] _0381_ _0389_ VDD VDD VSS VSS gf180mcu_fd_sc_mcu7t5v0__nor2_1
X_0850_ _0146_ _0381_ _0389_ _0071_ VDD VDD VSS VSS gf180mcu_fd_sc_mcu7t5v0__aoi21_1
X_0851_ _0129_ sr[11] _0364_ _0369_ _0390_ VDD VDD VSS VSS gf180mcu_fd_sc_mcu7t5v0__or4_1
X_0852_ devx[0] _0390_ _0391_ VDD VDD VSS VSS gf180mcu_fd_sc_mcu7t5v0__nand2_1
X_0853_ _0155_ _0390_ _0391_ _0072_ VDD VDD VSS VSS gf180mcu_fd_sc_mcu7t5v0__oai21_1
X_0854_ sr[0] _0390_ _0392_ VDD VDD VSS VSS gf180mcu_fd_sc_mcu7t5v0__nor2_1
X_0855_ _0134_ _0390_ _0392_ _0073_ VDD VDD VSS VSS gf180mcu_fd_sc_mcu7t5v0__aoi21_1
X_0856_ devx[2] _0390_ _0393_ VDD VDD VSS VSS gf180mcu_fd_sc_mcu7t5v0__nand2_1
X_0857_ _0156_ _0390_ _0393_ _0074_ VDD VDD VSS VSS gf180mcu_fd_sc_mcu7t5v0__oai21_1
X_0858_ sr[2] devx[3] _0390_ _0075_ VDD VDD VSS VSS gf180mcu_fd_sc_mcu7t5v0__mux2_2
X_0859_ sr[3] devx[4] _0390_ _0076_ VDD VDD VSS VSS gf180mcu_fd_sc_mcu7t5v0__mux2_2
X_0860_ sr[4] devx[5] _0390_ _0077_ VDD VDD VSS VSS gf180mcu_fd_sc_mcu7t5v0__mux2_2
X_0861_ sr[5] devx[6] _0390_ _0078_ VDD VDD VSS VSS gf180mcu_fd_sc_mcu7t5v0__mux2_2
X_0862_ sr[6] _0390_ _0394_ VDD VDD VSS VSS gf180mcu_fd_sc_mcu7t5v0__nor2_1
X_0863_ _0136_ _0390_ _0394_ _0079_ VDD VDD VSS VSS gf180mcu_fd_sc_mcu7t5v0__aoi21_1
X_0864_ sr[7] devx[8] _0390_ _0080_ VDD VDD VSS VSS gf180mcu_fd_sc_mcu7t5v0__mux2_2
X_0865_ sr[8] devx[9] _0390_ _0081_ VDD VDD VSS VSS gf180mcu_fd_sc_mcu7t5v0__mux2_2
X_0866_ sr[9] devx[10] _0390_ _0082_ VDD VDD VSS VSS gf180mcu_fd_sc_mcu7t5v0__mux2_2
X_0867_ sr[10] _0390_ _0395_ VDD VDD VSS VSS gf180mcu_fd_sc_mcu7t5v0__nor2_1
X_0868_ _0137_ _0390_ _0395_ _0083_ VDD VDD VSS VSS gf180mcu_fd_sc_mcu7t5v0__aoi21_1
X_0869_ sr[12] sr[11] _0363_ _0368_ _0396_ VDD VDD VSS VSS gf180mcu_fd_sc_mcu7t5v0__nand4_1
X_0870_ sd_en _0396_ _0397_ VDD VDD VSS VSS gf180mcu_fd_sc_mcu7t5v0__nand2_1
X_0871_ _0155_ _0396_ _0397_ _0084_ VDD VDD VSS VSS gf180mcu_fd_sc_mcu7t5v0__oai21_1
X_0872_ sr[0] ck_en _0396_ _0085_ VDD VDD VSS VSS gf180mcu_fd_sc_mcu7t5v0__mux2_2
X_0873_ fsk_en _0396_ _0398_ VDD VDD VSS VSS gf180mcu_fd_sc_mcu7t5v0__nand2_1
X_0874_ _0156_ _0396_ _0398_ _0086_ VDD VDD VSS VSS gf180mcu_fd_sc_mcu7t5v0__oai21_1
X_0875_ sr[2] fsk_inv _0396_ _0087_ VDD VDD VSS VSS gf180mcu_fd_sc_mcu7t5v0__mux2_2
X_0876_ _0125_ _0360_ _0130_ _0399_ VDD VDD VSS VSS gf180mcu_fd_sc_mcu7t5v0__aoi21_1
X_0877_ _0130_ _0362_ _0399_ _0088_ VDD VDD VSS VSS gf180mcu_fd_sc_mcu7t5v0__aoi21_1
X_0878_ _0360_ _0365_ _0400_ VDD VDD VSS VSS gf180mcu_fd_sc_mcu7t5v0__nor2_1
X_0879_ bitcnt[1] _0399_ _0125_ _0401_ VDD VDD VSS VSS gf180mcu_fd_sc_mcu7t5v0__oai21_1
X_0880_ _0400_ _0401_ _0089_ VDD VDD VSS VSS gf180mcu_fd_sc_mcu7t5v0__nor2_1
X_0881_ bitcnt[2] _0400_ _0402_ VDD VDD VSS VSS gf180mcu_fd_sc_mcu7t5v0__nor2_1
X_0882_ bitcnt[2] bitcnt[1] _0399_ _0403_ VDD VDD VSS VSS gf180mcu_fd_sc_mcu7t5v0__and3_1
X_0883_ s_cs[1] _0402_ _0403_ _0090_ VDD VDD VSS VSS gf180mcu_fd_sc_mcu7t5v0__nor3_1
X_0884_ bitcnt[2] bitcnt[3] _0400_ _0404_ VDD VDD VSS VSS gf180mcu_fd_sc_mcu7t5v0__nand3_1
X_0885_ bitcnt[3] _0403_ _0404_ _0405_ VDD VDD VSS VSS gf180mcu_fd_sc_mcu7t5v0__oai21_1
X_0886_ s_cs[1] _0405_ _0091_ VDD VDD VSS VSS gf180mcu_fd_sc_mcu7t5v0__nor2_1
X_0887_ _0125_ bitcnt[4] _0404_ _0406_ VDD VDD VSS VSS gf180mcu_fd_sc_mcu7t5v0__nand3_1
X_0888_ _0362_ _0367_ _0406_ _0092_ VDD VDD VSS VSS gf180mcu_fd_sc_mcu7t5v0__oai21_1
X_0889_ sr[0] _0362_ _0407_ VDD VDD VSS VSS gf180mcu_fd_sc_mcu7t5v0__nand2_1
X_0890_ _0155_ _0362_ _0407_ _0093_ VDD VDD VSS VSS gf180mcu_fd_sc_mcu7t5v0__oai21_1
X_0891_ sr[0] _0361_ _0408_ VDD VDD VSS VSS gf180mcu_fd_sc_mcu7t5v0__nand2_1
X_0892_ _0156_ _0361_ _0408_ _0094_ VDD VDD VSS VSS gf180mcu_fd_sc_mcu7t5v0__oai21_1
X_0893_ sr[2] _0362_ _0409_ VDD VDD VSS VSS gf180mcu_fd_sc_mcu7t5v0__nand2_1
X_0894_ _0156_ _0362_ _0409_ _0095_ VDD VDD VSS VSS gf180mcu_fd_sc_mcu7t5v0__oai21_1
X_0895_ sr[2] sr[3] _0362_ _0096_ VDD VDD VSS VSS gf180mcu_fd_sc_mcu7t5v0__mux2_2
X_0896_ sr[3] sr[4] _0362_ _0097_ VDD VDD VSS VSS gf180mcu_fd_sc_mcu7t5v0__mux2_2
X_0897_ sr[4] sr[5] _0362_ _0098_ VDD VDD VSS VSS gf180mcu_fd_sc_mcu7t5v0__mux2_2
X_0898_ sr[5] sr[6] _0362_ _0099_ VDD VDD VSS VSS gf180mcu_fd_sc_mcu7t5v0__mux2_2
X_0899_ sr[6] sr[7] _0362_ _0100_ VDD VDD VSS VSS gf180mcu_fd_sc_mcu7t5v0__mux2_2
X_0900_ sr[7] sr[8] _0362_ _0101_ VDD VDD VSS VSS gf180mcu_fd_sc_mcu7t5v0__mux2_2
X_0901_ sr[8] sr[9] _0362_ _0102_ VDD VDD VSS VSS gf180mcu_fd_sc_mcu7t5v0__mux2_2
X_0902_ sr[9] sr[10] _0362_ _0103_ VDD VDD VSS VSS gf180mcu_fd_sc_mcu7t5v0__mux2_2
X_0903_ sr[10] sr[11] _0362_ _0104_ VDD VDD VSS VSS gf180mcu_fd_sc_mcu7t5v0__mux2_2
X_0904_ sr[11] _0361_ _0410_ VDD VDD VSS VSS gf180mcu_fd_sc_mcu7t5v0__nand2_1
X_0905_ _0129_ _0361_ _0410_ _0105_ VDD VDD VSS VSS gf180mcu_fd_sc_mcu7t5v0__oai21_1
X_0906_ sr[13] _0361_ _0411_ VDD VDD VSS VSS gf180mcu_fd_sc_mcu7t5v0__nor2_1
X_0907_ _0129_ _0361_ _0411_ _0106_ VDD VDD VSS VSS gf180mcu_fd_sc_mcu7t5v0__aoi21_1
X_0908_ _0131_ _0362_ _0363_ _0107_ VDD VDD VSS VSS gf180mcu_fd_sc_mcu7t5v0__aoi21_1
X_0909_ s_cs[1] _0358_ _0412_ VDD VDD VSS VSS gf180mcu_fd_sc_mcu7t5v0__or2_1
X_0910_ bitcnt[4] _0356_ _0362_ _0365_ _0413_ VDD VDD VSS VSS gf180mcu_fd_sc_mcu7t5v0__or4_1
X_0911_ _0412_ _0413_ _0414_ VDD VDD VSS VSS gf180mcu_fd_sc_mcu7t5v0__and2_1
X_0912_ _0412_ _0413_ _0415_ VDD VDD VSS VSS gf180mcu_fd_sc_mcu7t5v0__nand2_1
X_0913_ rd[0] _0414_ _0416_ VDD VDD VSS VSS gf180mcu_fd_sc_mcu7t5v0__nand2_1
X_0914_ sr[0] s_mosi[1] sr[1] _0417_ VDD VDD VSS VSS gf180mcu_fd_sc_mcu7t5v0__nor3_1
X_0915_ base[8] _0417_ _0418_ VDD VDD VSS VSS gf180mcu_fd_sc_mcu7t5v0__nand2_1
X_0916_ sr[0] s_mosi[1] _0419_ VDD VDD VSS VSS gf180mcu_fd_sc_mcu7t5v0__nand2_1
X_0917_ sd_en sr[1] s_mosi[1] sr[0] _0420_ VDD VDD VSS VSS gf180mcu_fd_sc_mcu7t5v0__oai211_1
X_0918_ sr[0] s_mosi[1] _0156_ _0421_ VDD VDD VSS VSS gf180mcu_fd_sc_mcu7t5v0__nor3_1
X_0919_ sr[0] _0155_ sr[1] _0422_ VDD VDD VSS VSS gf180mcu_fd_sc_mcu7t5v0__nor3_1
X_0920_ sr[0] _0155_ _0156_ _0423_ VDD VDD VSS VSS gf180mcu_fd_sc_mcu7t5v0__and3_1
X_0921_ eff_int[0] _0421_ _0422_ base[0] _0423_ devx[0] _0424_ VDD VDD VSS VSS gf180mcu_fd_sc_mcu7t5v0__aoi222_1
X_0922_ sr[1] _0419_ _0425_ VDD VDD VSS VSS gf180mcu_fd_sc_mcu7t5v0__nor2_1
X_0923_ _0418_ _0420_ _0424_ _0426_ VDD VDD VSS VSS gf180mcu_fd_sc_mcu7t5v0__and3_1
X_0924_ _0413_ _0426_ _0416_ _0108_ VDD VDD VSS VSS gf180mcu_fd_sc_mcu7t5v0__oai21_1
X_0925_ rd[1] _0414_ _0427_ VDD VDD VSS VSS gf180mcu_fd_sc_mcu7t5v0__nand2_1
X_0926_ _0156_ _0419_ _0358_ _0428_ VDD VDD VSS VSS gf180mcu_fd_sc_mcu7t5v0__oai21_1
X_0927_ base[9] _0417_ _0422_ base[1] _0425_ ck_en _0429_ VDD VDD VSS VSS gf180mcu_fd_sc_mcu7t5v0__aoi222_1
X_0928_ eff_int[1] _0421_ _0423_ devx[1] _0428_ _0430_ VDD VDD VSS VSS gf180mcu_fd_sc_mcu7t5v0__aoi221_1
X_0929_ _0429_ _0430_ _0431_ VDD VDD VSS VSS gf180mcu_fd_sc_mcu7t5v0__nand2_1
X_0930_ rd[0] _0358_ _0415_ _0431_ _0432_ VDD VDD VSS VSS gf180mcu_fd_sc_mcu7t5v0__oai211_1
X_0931_ _0427_ _0432_ _0109_ VDD VDD VSS VSS gf180mcu_fd_sc_mcu7t5v0__nand2_1
X_0932_ rd[2] _0414_ _0433_ VDD VDD VSS VSS gf180mcu_fd_sc_mcu7t5v0__nand2_1
X_0933_ eff_int[2] _0421_ _0434_ VDD VDD VSS VSS gf180mcu_fd_sc_mcu7t5v0__nand2_1
X_0934_ base[10] _0417_ _0425_ fsk_en _0435_ VDD VDD VSS VSS gf180mcu_fd_sc_mcu7t5v0__aoi22_1
X_0935_ base[2] _0422_ _0423_ devx[2] _0436_ VDD VDD VSS VSS gf180mcu_fd_sc_mcu7t5v0__aoi22_1
X_0936_ _0358_ _0434_ _0435_ _0436_ _0437_ VDD VDD VSS VSS gf180mcu_fd_sc_mcu7t5v0__nand4_1
X_0937_ rd[1] _0358_ _0415_ _0437_ _0438_ VDD VDD VSS VSS gf180mcu_fd_sc_mcu7t5v0__oai211_1
X_0938_ _0433_ _0438_ _0110_ VDD VDD VSS VSS gf180mcu_fd_sc_mcu7t5v0__nand2_1
X_0939_ rd[3] _0414_ _0439_ VDD VDD VSS VSS gf180mcu_fd_sc_mcu7t5v0__nand2_1
X_0940_ devx[3] _0423_ _0440_ VDD VDD VSS VSS gf180mcu_fd_sc_mcu7t5v0__nand2_1
X_0941_ base[11] _0417_ _0421_ eff_int[3] _0441_ VDD VDD VSS VSS gf180mcu_fd_sc_mcu7t5v0__aoi22_1
X_0942_ base[3] _0422_ _0425_ fsk_inv _0442_ VDD VDD VSS VSS gf180mcu_fd_sc_mcu7t5v0__aoi22_1
X_0943_ _0358_ _0440_ _0441_ _0442_ _0443_ VDD VDD VSS VSS gf180mcu_fd_sc_mcu7t5v0__nand4_1
X_0944_ rd[2] _0358_ _0415_ _0443_ _0444_ VDD VDD VSS VSS gf180mcu_fd_sc_mcu7t5v0__oai211_1
X_0945_ _0439_ _0444_ _0111_ VDD VDD VSS VSS gf180mcu_fd_sc_mcu7t5v0__nand2_1
X_0946_ rd[4] _0414_ _0445_ VDD VDD VSS VSS gf180mcu_fd_sc_mcu7t5v0__nand2_1
X_0947_ base[12] _0417_ _0421_ eff_int[4] _0446_ VDD VDD VSS VSS gf180mcu_fd_sc_mcu7t5v0__aoi22_1
X_0948_ base[4] _0422_ _0423_ devx[4] _0447_ VDD VDD VSS VSS gf180mcu_fd_sc_mcu7t5v0__aoi22_1
X_0949_ _0446_ _0447_ _0448_ VDD VDD VSS VSS gf180mcu_fd_sc_mcu7t5v0__nand2_1
X_0950_ rd[3] _0358_ _0428_ _0448_ _0415_ _0449_ VDD VDD VSS VSS gf180mcu_fd_sc_mcu7t5v0__oai221_1
X_0951_ _0445_ _0449_ _0112_ VDD VDD VSS VSS gf180mcu_fd_sc_mcu7t5v0__nand2_1
X_0952_ rd[5] _0414_ _0450_ VDD VDD VSS VSS gf180mcu_fd_sc_mcu7t5v0__nand2_1
X_0953_ eff_int[5] _0421_ _0422_ base[5] _0451_ VDD VDD VSS VSS gf180mcu_fd_sc_mcu7t5v0__aoi22_1
X_0954_ base[13] _0417_ _0423_ devx[5] _0452_ VDD VDD VSS VSS gf180mcu_fd_sc_mcu7t5v0__aoi22_1
X_0955_ _0451_ _0452_ _0453_ VDD VDD VSS VSS gf180mcu_fd_sc_mcu7t5v0__nand2_1
X_0956_ rd[4] _0358_ _0428_ _0453_ _0415_ _0454_ VDD VDD VSS VSS gf180mcu_fd_sc_mcu7t5v0__oai221_1
X_0957_ _0450_ _0454_ _0113_ VDD VDD VSS VSS gf180mcu_fd_sc_mcu7t5v0__nand2_1
X_0958_ rd[6] _0414_ _0455_ VDD VDD VSS VSS gf180mcu_fd_sc_mcu7t5v0__nand2_1
X_0959_ devx[6] _0423_ _0456_ VDD VDD VSS VSS gf180mcu_fd_sc_mcu7t5v0__nand2_1
X_0960_ base[14] _0417_ _0422_ base[6] _0421_ eff_int[6] _0457_ VDD VDD VSS VSS gf180mcu_fd_sc_mcu7t5v0__aoi222_1
X_0961_ _0358_ _0456_ _0457_ _0458_ VDD VDD VSS VSS gf180mcu_fd_sc_mcu7t5v0__nand3_1
X_0962_ rd[5] _0358_ _0415_ _0458_ _0459_ VDD VDD VSS VSS gf180mcu_fd_sc_mcu7t5v0__oai211_1
X_0963_ _0455_ _0459_ _0114_ VDD VDD VSS VSS gf180mcu_fd_sc_mcu7t5v0__nand2_1
X_0964_ rd[7] _0414_ _0460_ VDD VDD VSS VSS gf180mcu_fd_sc_mcu7t5v0__nand2_1
X_0965_ eff_int[7] _0421_ _0461_ VDD VDD VSS VSS gf180mcu_fd_sc_mcu7t5v0__nand2_1
X_0966_ base[15] _0417_ _0422_ base[7] _0423_ devx[7] _0462_ VDD VDD VSS VSS gf180mcu_fd_sc_mcu7t5v0__aoi222_1
X_0967_ _0358_ _0461_ _0462_ _0463_ VDD VDD VSS VSS gf180mcu_fd_sc_mcu7t5v0__nand3_1
X_0968_ rd[6] _0358_ _0415_ _0463_ _0464_ VDD VDD VSS VSS gf180mcu_fd_sc_mcu7t5v0__oai211_1
X_0969_ _0460_ _0464_ _0115_ VDD VDD VSS VSS gf180mcu_fd_sc_mcu7t5v0__nand2_1
X_0970_ rd[8] _0414_ _0465_ VDD VDD VSS VSS gf180mcu_fd_sc_mcu7t5v0__nand2_1
X_0971_ base[16] _0417_ _0421_ eff_int[8] _0466_ VDD VDD VSS VSS gf180mcu_fd_sc_mcu7t5v0__aoi22_1
X_0972_ devx[8] _0423_ _0467_ VDD VDD VSS VSS gf180mcu_fd_sc_mcu7t5v0__nand2_1
X_0973_ _0358_ _0466_ _0467_ _0468_ VDD VDD VSS VSS gf180mcu_fd_sc_mcu7t5v0__nand3_1
X_0974_ rd[7] _0358_ _0415_ _0468_ _0469_ VDD VDD VSS VSS gf180mcu_fd_sc_mcu7t5v0__oai211_1
X_0975_ _0465_ _0469_ _0116_ VDD VDD VSS VSS gf180mcu_fd_sc_mcu7t5v0__nand2_1
X_0976_ rd[9] _0414_ _0470_ VDD VDD VSS VSS gf180mcu_fd_sc_mcu7t5v0__nand2_1
X_0977_ base[17] _0417_ _0421_ eff_int[9] _0471_ VDD VDD VSS VSS gf180mcu_fd_sc_mcu7t5v0__aoi22_1
X_0978_ devx[9] _0423_ _0472_ VDD VDD VSS VSS gf180mcu_fd_sc_mcu7t5v0__nand2_1
X_0979_ _0358_ _0471_ _0472_ _0473_ VDD VDD VSS VSS gf180mcu_fd_sc_mcu7t5v0__nand3_1
X_0980_ rd[8] _0358_ _0415_ _0473_ _0474_ VDD VDD VSS VSS gf180mcu_fd_sc_mcu7t5v0__oai211_1
X_0981_ _0470_ _0474_ _0117_ VDD VDD VSS VSS gf180mcu_fd_sc_mcu7t5v0__nand2_1
X_0982_ rd[10] _0414_ _0475_ VDD VDD VSS VSS gf180mcu_fd_sc_mcu7t5v0__nand2_1
X_0983_ devx[10] _0423_ _0428_ _0476_ VDD VDD VSS VSS gf180mcu_fd_sc_mcu7t5v0__aoi21_1
X_0984_ rd[9] _0358_ _0415_ _0477_ VDD VDD VSS VSS gf180mcu_fd_sc_mcu7t5v0__oai21_1
X_0985_ _0476_ _0477_ _0475_ _0118_ VDD VDD VSS VSS gf180mcu_fd_sc_mcu7t5v0__oai21_1
X_0986_ devx[11] _0423_ _0478_ VDD VDD VSS VSS gf180mcu_fd_sc_mcu7t5v0__nand2_1
X_0987_ _0358_ _0478_ _0479_ VDD VDD VSS VSS gf180mcu_fd_sc_mcu7t5v0__nand2_1
X_0988_ rd[11] _0414_ _0480_ VDD VDD VSS VSS gf180mcu_fd_sc_mcu7t5v0__nand2_1
X_0989_ rd[10] _0358_ _0415_ _0479_ _0481_ VDD VDD VSS VSS gf180mcu_fd_sc_mcu7t5v0__oai211_1
X_0990_ _0480_ _0481_ _0119_ VDD VDD VSS VSS gf180mcu_fd_sc_mcu7t5v0__nand2_1
X_0991_ sr[2] rnw _0413_ _0120_ VDD VDD VSS VSS gf180mcu_fd_sc_mcu7t5v0__mux2_2
X_0992_ _0053_ net4 clknet_3_6__leaf_clk_spi net47 VDD VDD VSS VSS gf180mcu_fd_sc_mcu7t5v0__dffrnq_1
X_0993_ _0054_ net52 clknet_3_7__leaf_clk_spi base[8] VDD VDD VSS VSS gf180mcu_fd_sc_mcu7t5v0__dffrnq_1
X_0994_ _0055_ net52 clknet_3_6__leaf_clk_spi base[9] VDD VDD VSS VSS gf180mcu_fd_sc_mcu7t5v0__dffrnq_1
X_0995_ _0056_ net52 clknet_3_6__leaf_clk_spi base[10] VDD VDD VSS VSS gf180mcu_fd_sc_mcu7t5v0__dffrnq_1
X_0996_ _0057_ net52 clknet_3_6__leaf_clk_spi base[11] VDD VDD VSS VSS gf180mcu_fd_sc_mcu7t5v0__dffrnq_1
X_0997_ _0058_ net52 clknet_3_2__leaf_clk_spi base[12] VDD VDD VSS VSS gf180mcu_fd_sc_mcu7t5v0__dffrnq_1
X_0998_ _0059_ net53 clknet_3_3__leaf_clk_spi base[13] VDD VDD VSS VSS gf180mcu_fd_sc_mcu7t5v0__dffrnq_1
X_0999_ _0060_ net52 clknet_3_2__leaf_clk_spi base[14] VDD VDD VSS VSS gf180mcu_fd_sc_mcu7t5v0__dffrnq_1
X_1000_ _0061_ net52 clknet_3_2__leaf_clk_spi base[15] VDD VDD VSS VSS gf180mcu_fd_sc_mcu7t5v0__dffrnq_1
X_1001_ _0062_ net52 clknet_3_3__leaf_clk_spi base[16] VDD VDD VSS VSS gf180mcu_fd_sc_mcu7t5v0__dffrnq_1
X_1002_ _0063_ net52 clknet_3_3__leaf_clk_spi base[17] VDD VDD VSS VSS gf180mcu_fd_sc_mcu7t5v0__dffsnq_1
X_1003_ _0064_ net4 clknet_3_4__leaf_clk_spi base[0] VDD VDD VSS VSS gf180mcu_fd_sc_mcu7t5v0__dffrnq_1
X_1004_ _0065_ net53 clknet_3_1__leaf_clk_spi base[1] VDD VDD VSS VSS gf180mcu_fd_sc_mcu7t5v0__dffrnq_1
X_1005_ _0066_ net53 clknet_3_2__leaf_clk_spi base[2] VDD VDD VSS VSS gf180mcu_fd_sc_mcu7t5v0__dffrnq_1
X_1006_ _0067_ net53 clknet_3_0__leaf_clk_spi base[3] VDD VDD VSS VSS gf180mcu_fd_sc_mcu7t5v0__dffrnq_1
X_1007_ _0068_ net53 clknet_3_0__leaf_clk_spi base[4] VDD VDD VSS VSS gf180mcu_fd_sc_mcu7t5v0__dffrnq_1
X_1008_ _0069_ net53 clknet_3_0__leaf_clk_spi base[5] VDD VDD VSS VSS gf180mcu_fd_sc_mcu7t5v0__dffrnq_1
X_1009_ _0070_ net52 clknet_3_2__leaf_clk_spi base[6] VDD VDD VSS VSS gf180mcu_fd_sc_mcu7t5v0__dffrnq_1
X_1010_ _0071_ net52 clknet_3_2__leaf_clk_spi base[7] VDD VDD VSS VSS gf180mcu_fd_sc_mcu7t5v0__dffrnq_1
X_1011_ _0072_ net4 clknet_3_4__leaf_clk_spi devx[0] VDD VDD VSS VSS gf180mcu_fd_sc_mcu7t5v0__dffrnq_1
X_1012_ _0073_ net53 clknet_3_1__leaf_clk_spi devx[1] VDD VDD VSS VSS gf180mcu_fd_sc_mcu7t5v0__dffrnq_1
X_1013_ _0074_ net53 clknet_3_2__leaf_clk_spi devx[2] VDD VDD VSS VSS gf180mcu_fd_sc_mcu7t5v0__dffrnq_1
X_1014_ _0075_ net53 clknet_3_0__leaf_clk_spi devx[3] VDD VDD VSS VSS gf180mcu_fd_sc_mcu7t5v0__dffrnq_1
X_1015_ _0076_ net53 clknet_3_0__leaf_clk_spi devx[4] VDD VDD VSS VSS gf180mcu_fd_sc_mcu7t5v0__dffrnq_1
X_1016_ _0077_ net53 clknet_3_2__leaf_clk_spi devx[5] VDD VDD VSS VSS gf180mcu_fd_sc_mcu7t5v0__dffrnq_1
X_1017_ _0078_ net53 clknet_3_0__leaf_clk_spi devx[6] VDD VDD VSS VSS gf180mcu_fd_sc_mcu7t5v0__dffrnq_1
X_1018_ _0079_ net53 clknet_3_0__leaf_clk_spi devx[7] VDD VDD VSS VSS gf180mcu_fd_sc_mcu7t5v0__dffrnq_1
X_1019_ _0080_ net53 clknet_3_3__leaf_clk_spi devx[8] VDD VDD VSS VSS gf180mcu_fd_sc_mcu7t5v0__dffrnq_1
X_1020_ _0081_ net53 clknet_3_1__leaf_clk_spi devx[9] VDD VDD VSS VSS gf180mcu_fd_sc_mcu7t5v0__dffrnq_1
X_1021_ _0082_ net53 clknet_3_1__leaf_clk_spi devx[10] VDD VDD VSS VSS gf180mcu_fd_sc_mcu7t5v0__dffrnq_1
X_1022_ _0083_ net4 clknet_3_1__leaf_clk_spi devx[11] VDD VDD VSS VSS gf180mcu_fd_sc_mcu7t5v0__dffrnq_1
X_1023_ _0084_ net4 clknet_3_4__leaf_clk_spi sd_en VDD VDD VSS VSS gf180mcu_fd_sc_mcu7t5v0__dffrnq_1
X_1024_ _0085_ net4 clknet_3_5__leaf_clk_spi ck_en VDD VDD VSS VSS gf180mcu_fd_sc_mcu7t5v0__dffrnq_1
X_1025_ _0086_ net4 clknet_3_5__leaf_clk_spi fsk_en VDD VDD VSS VSS gf180mcu_fd_sc_mcu7t5v0__dffrnq_1
X_1026_ _0087_ net4 clknet_3_4__leaf_clk_spi fsk_inv VDD VDD VSS VSS gf180mcu_fd_sc_mcu7t5v0__dffrnq_2
X_1027_ _0088_ net53 clknet_3_5__leaf_clk_spi bitcnt[0] VDD VDD VSS VSS gf180mcu_fd_sc_mcu7t5v0__dffrnq_1
X_1028_ _0089_ net53 clknet_3_5__leaf_clk_spi bitcnt[1] VDD VDD VSS VSS gf180mcu_fd_sc_mcu7t5v0__dffrnq_1
X_1029_ _0090_ net53 clknet_3_5__leaf_clk_spi bitcnt[2] VDD VDD VSS VSS gf180mcu_fd_sc_mcu7t5v0__dffrnq_1
X_1030_ _0091_ net53 clknet_3_5__leaf_clk_spi bitcnt[3] VDD VDD VSS VSS gf180mcu_fd_sc_mcu7t5v0__dffrnq_1
X_1031_ _0092_ net4 clknet_3_5__leaf_clk_spi bitcnt[4] VDD VDD VSS VSS gf180mcu_fd_sc_mcu7t5v0__dffrnq_1
X_1032_ _0093_ net4 clknet_3_4__leaf_clk_spi sr[0] VDD VDD VSS VSS gf180mcu_fd_sc_mcu7t5v0__dffrnq_1
X_1033_ _0094_ net4 clknet_3_4__leaf_clk_spi sr[1] VDD VDD VSS VSS gf180mcu_fd_sc_mcu7t5v0__dffrnq_1
X_1034_ _0095_ net53 clknet_3_5__leaf_clk_spi sr[2] VDD VDD VSS VSS gf180mcu_fd_sc_mcu7t5v0__dffrnq_1
X_1035_ _0096_ net53 clknet_3_0__leaf_clk_spi sr[3] VDD VDD VSS VSS gf180mcu_fd_sc_mcu7t5v0__dffrnq_1
X_1036_ _0097_ net53 clknet_3_0__leaf_clk_spi sr[4] VDD VDD VSS VSS gf180mcu_fd_sc_mcu7t5v0__dffrnq_1
X_1037_ _0098_ net53 clknet_3_0__leaf_clk_spi sr[5] VDD VDD VSS VSS gf180mcu_fd_sc_mcu7t5v0__dffrnq_1
X_1038_ _0099_ net53 clknet_3_0__leaf_clk_spi sr[6] VDD VDD VSS VSS gf180mcu_fd_sc_mcu7t5v0__dffrnq_1
X_1039_ _0100_ net53 clknet_3_0__leaf_clk_spi sr[7] VDD VDD VSS VSS gf180mcu_fd_sc_mcu7t5v0__dffrnq_1
X_1040_ _0101_ net53 clknet_3_3__leaf_clk_spi sr[8] VDD VDD VSS VSS gf180mcu_fd_sc_mcu7t5v0__dffrnq_1
X_1041_ _0102_ net53 clknet_3_1__leaf_clk_spi sr[9] VDD VDD VSS VSS gf180mcu_fd_sc_mcu7t5v0__dffrnq_1
X_1042_ _0103_ net53 clknet_3_1__leaf_clk_spi sr[10] VDD VDD VSS VSS gf180mcu_fd_sc_mcu7t5v0__dffrnq_1
X_1043_ _0104_ net53 clknet_3_1__leaf_clk_spi sr[11] VDD VDD VSS VSS gf180mcu_fd_sc_mcu7t5v0__dffrnq_1
X_1044_ _0105_ net53 clknet_3_4__leaf_clk_spi sr[12] VDD VDD VSS VSS gf180mcu_fd_sc_mcu7t5v0__dffrnq_1
X_1045_ _0106_ net53 clknet_3_4__leaf_clk_spi sr[13] VDD VDD VSS VSS gf180mcu_fd_sc_mcu7t5v0__dffrnq_1
X_1046_ _0107_ net53 clknet_3_4__leaf_clk_spi sr[14] VDD VDD VSS VSS gf180mcu_fd_sc_mcu7t5v0__dffrnq_1
X_1047_ _0108_ net4 clknet_3_5__leaf_clk_spi rd[0] VDD VDD VSS VSS gf180mcu_fd_sc_mcu7t5v0__dffrnq_1
X_1048_ _0109_ net4 clknet_3_5__leaf_clk_spi rd[1] VDD VDD VSS VSS gf180mcu_fd_sc_mcu7t5v0__dffrnq_1
X_1049_ _0110_ net52 clknet_3_5__leaf_clk_spi rd[2] VDD VDD VSS VSS gf180mcu_fd_sc_mcu7t5v0__dffrnq_1
X_1050_ _0111_ net52 clknet_3_7__leaf_clk_spi rd[3] VDD VDD VSS VSS gf180mcu_fd_sc_mcu7t5v0__dffrnq_1
X_1051_ _0112_ net52 clknet_3_5__leaf_clk_spi rd[4] VDD VDD VSS VSS gf180mcu_fd_sc_mcu7t5v0__dffrnq_1
X_1052_ _0113_ net52 clknet_3_7__leaf_clk_spi rd[5] VDD VDD VSS VSS gf180mcu_fd_sc_mcu7t5v0__dffrnq_1
X_1053_ _0114_ net52 clknet_3_7__leaf_clk_spi rd[6] VDD VDD VSS VSS gf180mcu_fd_sc_mcu7t5v0__dffrnq_1
X_1054_ _0115_ net52 clknet_3_6__leaf_clk_spi rd[7] VDD VDD VSS VSS gf180mcu_fd_sc_mcu7t5v0__dffrnq_1
X_1055_ _0116_ net51 clknet_3_6__leaf_clk_spi rd[8] VDD VDD VSS VSS gf180mcu_fd_sc_mcu7t5v0__dffrnq_1
X_1056_ _0117_ net51 clknet_3_7__leaf_clk_spi rd[9] VDD VDD VSS VSS gf180mcu_fd_sc_mcu7t5v0__dffrnq_1
X_1057_ _0118_ net51 clknet_3_7__leaf_clk_spi rd[10] VDD VDD VSS VSS gf180mcu_fd_sc_mcu7t5v0__dffrnq_1
X_1058_ _0119_ net4 clknet_3_7__leaf_clk_spi rd[11] VDD VDD VSS VSS gf180mcu_fd_sc_mcu7t5v0__dffrnq_1
X_1059_ _0120_ net4 clknet_3_5__leaf_clk_spi rnw VDD VDD VSS VSS gf180mcu_fd_sc_mcu7t5v0__dffrnq_1
X_1060_ _0052_ r_ck[1] rip[6].q net44 VDD VDD VSS VSS gf180mcu_fd_sc_mcu7t5v0__dffnrnq_1
X_1061_ _0051_ r_ck[1] rip[5].q rip[6].q VDD VDD VSS VSS gf180mcu_fd_sc_mcu7t5v0__dffnrnq_1
X_1062_ _0050_ r_ck[1] rip[4].q rip[5].q VDD VDD VSS VSS gf180mcu_fd_sc_mcu7t5v0__dffnrnq_1
X_1063_ _0049_ r_ck[1] net46 rip[4].q VDD VDD VSS VSS gf180mcu_fd_sc_mcu7t5v0__dffnrnq_1
X_1064_ _0048_ r_ck[1] rip[2].q net46 VDD VDD VSS VSS gf180mcu_fd_sc_mcu7t5v0__dffnrnq_1
X_1065_ _0047_ r_ck[1] net45 rip[2].q VDD VDD VSS VSS gf180mcu_fd_sc_mcu7t5v0__dffnrnq_1
X_1066_ _0046_ r_ck[1] rip[0].q net45 VDD VDD VSS VSS gf180mcu_fd_sc_mcu7t5v0__dffnrnq_1
X_1067_ _0045_ r_ck[1] clknet_1_0__leaf_ck_regs rip[0].q VDD VDD VSS VSS gf180mcu_fd_sc_mcu7t5v0__dffrnq_1
X_1068_ s_cken[1] r_ck[1] clknet_1_1__leaf_ck_regs g_en VDD VDD VSS VSS gf180mcu_fd_sc_mcu7t5v0__dffnrnq_1
X_1069_ ck_en r_ck[1] clknet_1_0__leaf_ck_regs s_cken[0] VDD VDD VSS VSS gf180mcu_fd_sc_mcu7t5v0__dffrnq_1
X_1070_ s_cken[0] r_ck[1] clknet_1_0__leaf_ck_regs s_cken[1] VDD VDD VSS VSS gf180mcu_fd_sc_mcu7t5v0__dffrnq_1
X_1071_ net57 net51 clknet_1_1__leaf_ck_regs r_ck[0] VDD VDD VSS VSS gf180mcu_fd_sc_mcu7t5v0__dffrnq_1
X_1071__58 net57 VDD VDD VSS VSS gf180mcu_fd_sc_mcu7t5v0__tieh
X_1072_ r_ck[0] net51 clknet_1_1__leaf_ck_regs r_ck[1] VDD VDD VSS VSS gf180mcu_fd_sc_mcu7t5v0__dffrnq_4
X_1073_ _0014_ net50 clknet_2_0__leaf_clk_dec net13 VDD VDD VSS VSS gf180mcu_fd_sc_mcu7t5v0__dffrnq_1
X_1074_ _0025_ net50 clknet_2_0__leaf_clk_dec net24 VDD VDD VSS VSS gf180mcu_fd_sc_mcu7t5v0__dffrnq_1
X_1075_ _0036_ net50 clknet_2_0__leaf_clk_dec net35 VDD VDD VSS VSS gf180mcu_fd_sc_mcu7t5v0__dffrnq_1
X_1076_ _0038_ net50 clknet_2_0__leaf_clk_dec net37 VDD VDD VSS VSS gf180mcu_fd_sc_mcu7t5v0__dffrnq_1
X_1077_ _0039_ net50 clknet_2_0__leaf_clk_dec net38 VDD VDD VSS VSS gf180mcu_fd_sc_mcu7t5v0__dffrnq_1
X_1078_ _0040_ net50 clknet_2_0__leaf_clk_dec net39 VDD VDD VSS VSS gf180mcu_fd_sc_mcu7t5v0__dffrnq_1
X_1079_ _0041_ net50 clknet_2_1__leaf_clk_dec net40 VDD VDD VSS VSS gf180mcu_fd_sc_mcu7t5v0__dffrnq_1
X_1080_ _0042_ net50 clknet_2_1__leaf_clk_dec net41 VDD VDD VSS VSS gf180mcu_fd_sc_mcu7t5v0__dffrnq_1
X_1081_ _0043_ net50 clknet_2_1__leaf_clk_dec net42 VDD VDD VSS VSS gf180mcu_fd_sc_mcu7t5v0__dffrnq_1
X_1082_ _0044_ net50 clknet_2_1__leaf_clk_dec net43 VDD VDD VSS VSS gf180mcu_fd_sc_mcu7t5v0__dffrnq_1
X_1083_ _0015_ net50 clknet_2_1__leaf_clk_dec net14 VDD VDD VSS VSS gf180mcu_fd_sc_mcu7t5v0__dffrnq_1
X_1084_ _0016_ net50 clknet_2_0__leaf_clk_dec net15 VDD VDD VSS VSS gf180mcu_fd_sc_mcu7t5v0__dffrnq_1
X_1085_ _0017_ net50 clknet_2_1__leaf_clk_dec net16 VDD VDD VSS VSS gf180mcu_fd_sc_mcu7t5v0__dffrnq_1
X_1086_ _0018_ net50 clknet_2_3__leaf_clk_dec net17 VDD VDD VSS VSS gf180mcu_fd_sc_mcu7t5v0__dffrnq_1
X_1087_ _0019_ net50 clknet_2_3__leaf_clk_dec net18 VDD VDD VSS VSS gf180mcu_fd_sc_mcu7t5v0__dffrnq_1
X_1088_ _0020_ net50 clknet_2_3__leaf_clk_dec net19 VDD VDD VSS VSS gf180mcu_fd_sc_mcu7t5v0__dffrnq_1
X_1089_ _0021_ net50 clknet_2_3__leaf_clk_dec net20 VDD VDD VSS VSS gf180mcu_fd_sc_mcu7t5v0__dffsnq_1
X_1090_ _0022_ net50 clknet_2_3__leaf_clk_dec net21 VDD VDD VSS VSS gf180mcu_fd_sc_mcu7t5v0__dffsnq_1
X_1091_ _0023_ net50 clknet_2_3__leaf_clk_dec net22 VDD VDD VSS VSS gf180mcu_fd_sc_mcu7t5v0__dffsnq_1
X_1092_ _0024_ net50 clknet_2_3__leaf_clk_dec net23 VDD VDD VSS VSS gf180mcu_fd_sc_mcu7t5v0__dffsnq_1
X_1093_ _0026_ net50 clknet_2_3__leaf_clk_dec net25 VDD VDD VSS VSS gf180mcu_fd_sc_mcu7t5v0__dffsnq_1
X_1094_ _0027_ net50 clknet_2_3__leaf_clk_dec net26 VDD VDD VSS VSS gf180mcu_fd_sc_mcu7t5v0__dffsnq_1
X_1095_ _0028_ net50 clknet_2_2__leaf_clk_dec net27 VDD VDD VSS VSS gf180mcu_fd_sc_mcu7t5v0__dffsnq_1
X_1096_ _0029_ net50 clknet_2_3__leaf_clk_dec net28 VDD VDD VSS VSS gf180mcu_fd_sc_mcu7t5v0__dffsnq_1
X_1097_ _0030_ net50 clknet_2_3__leaf_clk_dec net29 VDD VDD VSS VSS gf180mcu_fd_sc_mcu7t5v0__dffsnq_1
X_1098_ _0031_ net51 clknet_2_3__leaf_clk_dec net30 VDD VDD VSS VSS gf180mcu_fd_sc_mcu7t5v0__dffsnq_1
X_1099_ _0032_ net51 clknet_2_3__leaf_clk_dec net31 VDD VDD VSS VSS gf180mcu_fd_sc_mcu7t5v0__dffsnq_1
X_1100_ _0033_ net51 clknet_2_2__leaf_clk_dec net32 VDD VDD VSS VSS gf180mcu_fd_sc_mcu7t5v0__dffsnq_1
X_1101_ _0034_ net51 clknet_2_2__leaf_clk_dec net33 VDD VDD VSS VSS gf180mcu_fd_sc_mcu7t5v0__dffsnq_1
X_1102_ _0035_ net51 clknet_2_2__leaf_clk_dec net34 VDD VDD VSS VSS gf180mcu_fd_sc_mcu7t5v0__dffsnq_1
X_1103_ _0037_ net51 clknet_2_2__leaf_clk_dec net36 VDD VDD VSS VSS gf180mcu_fd_sc_mcu7t5v0__dffsnq_1
X_1104_ _0008_ net50 clknet_2_0__leaf_clk_dec net7 VDD VDD VSS VSS gf180mcu_fd_sc_mcu7t5v0__dffsnq_1
X_1105_ _0009_ net50 clknet_2_1__leaf_clk_dec net8 VDD VDD VSS VSS gf180mcu_fd_sc_mcu7t5v0__dffsnq_1
X_1106_ _0010_ net50 clknet_2_1__leaf_clk_dec net9 VDD VDD VSS VSS gf180mcu_fd_sc_mcu7t5v0__dffsnq_1
X_1107_ _0011_ net50 clknet_2_1__leaf_clk_dec net10 VDD VDD VSS VSS gf180mcu_fd_sc_mcu7t5v0__dffsnq_1
X_1108_ _0012_ net50 clknet_2_1__leaf_clk_dec net11 VDD VDD VSS VSS gf180mcu_fd_sc_mcu7t5v0__dffsnq_1
X_1109_ eff_q[8] net51 clknet_2_2__leaf_clk_dec eff_int[0] VDD VDD VSS VSS gf180mcu_fd_sc_mcu7t5v0__dffrnq_1
X_1110_ eff_q[9] net51 clknet_2_2__leaf_clk_dec eff_int[1] VDD VDD VSS VSS gf180mcu_fd_sc_mcu7t5v0__dffrnq_1
X_1111_ eff_q[10] net51 clknet_2_2__leaf_clk_dec eff_int[2] VDD VDD VSS VSS gf180mcu_fd_sc_mcu7t5v0__dffrnq_1
X_1112_ eff_q[11] net51 clknet_2_0__leaf_clk_dec eff_int[3] VDD VDD VSS VSS gf180mcu_fd_sc_mcu7t5v0__dffrnq_1
X_1113_ eff_q[12] net51 clknet_2_1__leaf_clk_dec eff_int[4] VDD VDD VSS VSS gf180mcu_fd_sc_mcu7t5v0__dffrnq_1
X_1114_ eff_q[13] net51 clknet_2_0__leaf_clk_dec eff_int[5] VDD VDD VSS VSS gf180mcu_fd_sc_mcu7t5v0__dffrnq_1
X_1115_ eff_q[14] net51 clknet_2_1__leaf_clk_dec eff_int[6] VDD VDD VSS VSS gf180mcu_fd_sc_mcu7t5v0__dffrnq_1
X_1116_ eff_q[15] net51 clknet_2_2__leaf_clk_dec eff_int[7] VDD VDD VSS VSS gf180mcu_fd_sc_mcu7t5v0__dffrnq_1
X_1117_ eff_q[16] net51 clknet_2_1__leaf_clk_dec eff_int[8] VDD VDD VSS VSS gf180mcu_fd_sc_mcu7t5v0__dffrnq_1
X_1118_ eff_q[17] net51 clknet_2_2__leaf_clk_dec eff_int[9] VDD VDD VSS VSS gf180mcu_fd_sc_mcu7t5v0__dffsnq_1
X_1119_ _0013_ net50 clknet_1_0__leaf_clk_sd net12 VDD VDD VSS VSS gf180mcu_fd_sc_mcu7t5v0__dffsnq_1
X_1120_ _0000_ net50 clknet_1_1__leaf_clk_sd acc[0] VDD VDD VSS VSS gf180mcu_fd_sc_mcu7t5v0__dffrnq_1
X_1121_ _0001_ net50 clknet_1_1__leaf_clk_sd acc[1] VDD VDD VSS VSS gf180mcu_fd_sc_mcu7t5v0__dffrnq_1
X_1122_ _0002_ net52 clknet_1_1__leaf_clk_sd acc[2] VDD VDD VSS VSS gf180mcu_fd_sc_mcu7t5v0__dffrnq_1
X_1123_ _0003_ net52 clknet_1_0__leaf_clk_sd acc[3] VDD VDD VSS VSS gf180mcu_fd_sc_mcu7t5v0__dffrnq_1
X_1124_ _0004_ net52 clknet_1_0__leaf_clk_sd acc[4] VDD VDD VSS VSS gf180mcu_fd_sc_mcu7t5v0__dffrnq_1
X_1125_ _0005_ net52 clknet_1_0__leaf_clk_sd acc[5] VDD VDD VSS VSS gf180mcu_fd_sc_mcu7t5v0__dffrnq_1
X_1126_ _0006_ net50 clknet_1_0__leaf_clk_sd acc[6] VDD VDD VSS VSS gf180mcu_fd_sc_mcu7t5v0__dffrnq_1
X_1127_ _0007_ net50 clknet_1_0__leaf_clk_sd acc[7] VDD VDD VSS VSS gf180mcu_fd_sc_mcu7t5v0__dffrnq_1
X_1128_ eff[0] net51 clknet_1_1__leaf_clk_eff eff_q[0] VDD VDD VSS VSS gf180mcu_fd_sc_mcu7t5v0__dffrnq_1
X_1129_ eff[1] net52 clknet_1_0__leaf_clk_eff eff_q[1] VDD VDD VSS VSS gf180mcu_fd_sc_mcu7t5v0__dffrnq_1
X_1130_ eff[2] net52 clknet_1_0__leaf_clk_eff eff_q[2] VDD VDD VSS VSS gf180mcu_fd_sc_mcu7t5v0__dffrnq_1
X_1131_ eff[3] net52 clknet_1_0__leaf_clk_eff eff_q[3] VDD VDD VSS VSS gf180mcu_fd_sc_mcu7t5v0__dffrnq_1
X_1132_ eff[4] net52 clknet_1_0__leaf_clk_eff eff_q[4] VDD VDD VSS VSS gf180mcu_fd_sc_mcu7t5v0__dffrnq_1
X_1133_ eff[5] net52 clknet_1_0__leaf_clk_eff eff_q[5] VDD VDD VSS VSS gf180mcu_fd_sc_mcu7t5v0__dffrnq_1
X_1134_ eff[6] net52 clknet_1_0__leaf_clk_eff eff_q[6] VDD VDD VSS VSS gf180mcu_fd_sc_mcu7t5v0__dffrnq_1
X_1135_ eff[7] net52 clknet_1_0__leaf_clk_eff eff_q[7] VDD VDD VSS VSS gf180mcu_fd_sc_mcu7t5v0__dffrnq_1
X_1136_ eff[8] net51 clknet_1_1__leaf_clk_eff eff_q[8] VDD VDD VSS VSS gf180mcu_fd_sc_mcu7t5v0__dffrnq_1
X_1137_ eff[9] net51 clknet_1_1__leaf_clk_eff eff_q[9] VDD VDD VSS VSS gf180mcu_fd_sc_mcu7t5v0__dffrnq_1
X_1138_ eff[10] net51 clknet_1_1__leaf_clk_eff eff_q[10] VDD VDD VSS VSS gf180mcu_fd_sc_mcu7t5v0__dffrnq_1
X_1139_ eff[11] net51 clknet_1_1__leaf_clk_eff eff_q[11] VDD VDD VSS VSS gf180mcu_fd_sc_mcu7t5v0__dffrnq_1
X_1140_ eff[12] net51 clknet_1_1__leaf_clk_eff eff_q[12] VDD VDD VSS VSS gf180mcu_fd_sc_mcu7t5v0__dffrnq_1
X_1141_ eff[13] net51 clknet_1_1__leaf_clk_eff eff_q[13] VDD VDD VSS VSS gf180mcu_fd_sc_mcu7t5v0__dffrnq_1
X_1142_ eff[14] net51 clknet_1_0__leaf_clk_eff eff_q[14] VDD VDD VSS VSS gf180mcu_fd_sc_mcu7t5v0__dffrnq_1
X_1143_ eff[15] net51 clknet_1_0__leaf_clk_eff eff_q[15] VDD VDD VSS VSS gf180mcu_fd_sc_mcu7t5v0__dffrnq_1
X_1144_ eff[16] net51 clknet_1_1__leaf_clk_eff eff_q[16] VDD VDD VSS VSS gf180mcu_fd_sc_mcu7t5v0__dffrnq_1
X_1145_ eff[17] net51 clknet_1_1__leaf_clk_eff eff_q[17] VDD VDD VSS VSS gf180mcu_fd_sc_mcu7t5v0__dffsnq_1
X_1146_ net5 net4 clknet_1_0__leaf_clk_regs s_sclk[0] VDD VDD VSS VSS gf180mcu_fd_sc_mcu7t5v0__dffrnq_1
X_1147_ s_sclk[0] net4 clknet_1_0__leaf_clk_regs s_sclk[1] VDD VDD VSS VSS gf180mcu_fd_sc_mcu7t5v0__dffrnq_1
X_1148_ s_sclk[1] net4 clknet_1_0__leaf_clk_regs s_sclk[2] VDD VDD VSS VSS gf180mcu_fd_sc_mcu7t5v0__dffrnq_1
X_1149_ net1 net4 clknet_1_0__leaf_clk_regs s_cs[0] VDD VDD VSS VSS gf180mcu_fd_sc_mcu7t5v0__dffsnq_1
X_1150_ s_cs[0] net4 clknet_1_1__leaf_clk_regs s_cs[1] VDD VDD VSS VSS gf180mcu_fd_sc_mcu7t5v0__dffsnq_1
X_1151_ s_cs[1] net52 clknet_1_1__leaf_clk_regs s_cs[2] VDD VDD VSS VSS gf180mcu_fd_sc_mcu7t5v0__dffsnq_1
X_1152_ net3 net4 clknet_1_0__leaf_clk_regs s_mosi[0] VDD VDD VSS VSS gf180mcu_fd_sc_mcu7t5v0__dffrnq_1
X_1153_ s_mosi[0] net4 clknet_1_0__leaf_clk_regs s_mosi[1] VDD VDD VSS VSS gf180mcu_fd_sc_mcu7t5v0__dffrnq_1
X_1154_ net2 net4 clknet_1_1__leaf_clk_regs s_fsk[0] VDD VDD VSS VSS gf180mcu_fd_sc_mcu7t5v0__dffrnq_1
X_1155_ s_fsk[0] net4 clknet_1_1__leaf_clk_regs s_fsk[1] VDD VDD VSS VSS gf180mcu_fd_sc_mcu7t5v0__dffrnq_2
X_1156_ s_fsk[1] net52 clknet_1_1__leaf_clk_regs s_fsk[2] VDD VDD VSS VSS gf180mcu_fd_sc_mcu7t5v0__dffrnq_1
Xclkbuf_0_ck ck clknet_0_ck VDD VDD VSS VSS gf180mcu_fd_sc_mcu7t5v0__clkbuf_4
Xclkbuf_0_ck_regs ck_regs clknet_0_ck_regs VDD VDD VSS VSS gf180mcu_fd_sc_mcu7t5v0__clkbuf_4
Xclkbuf_0_clk clk clknet_0_clk VDD VDD VSS VSS gf180mcu_fd_sc_mcu7t5v0__clkbuf_4
Xclkbuf_0_clk_dec clk_dec clknet_0_clk_dec VDD VDD VSS VSS gf180mcu_fd_sc_mcu7t5v0__clkbuf_4
Xclkbuf_0_clk_eff clk_eff clknet_0_clk_eff VDD VDD VSS VSS gf180mcu_fd_sc_mcu7t5v0__clkbuf_4
Xclkbuf_0_clk_regs clk_regs clknet_0_clk_regs VDD VDD VSS VSS gf180mcu_fd_sc_mcu7t5v0__clkbuf_4
Xclkbuf_0_clk_sd clk_sd clknet_0_clk_sd VDD VDD VSS VSS gf180mcu_fd_sc_mcu7t5v0__clkbuf_4
Xclkbuf_0_clk_spi clk_spi clknet_0_clk_spi VDD VDD VSS VSS gf180mcu_fd_sc_mcu7t5v0__clkbuf_4
Xclkbuf_1_0__f_ck clknet_0_ck clknet_1_0__leaf_ck VDD VDD VSS VSS gf180mcu_fd_sc_mcu7t5v0__clkbuf_4
Xclkbuf_1_0__f_ck_regs clknet_0_ck_regs clknet_1_0__leaf_ck_regs VDD VDD VSS VSS gf180mcu_fd_sc_mcu7t5v0__clkbuf_4
Xclkbuf_1_0__f_clk delaynet_0_clk clknet_1_0__leaf_clk VDD VDD VSS VSS gf180mcu_fd_sc_mcu7t5v0__clkbuf_4
Xclkbuf_1_0__f_clk_eff clknet_0_clk_eff clknet_1_0__leaf_clk_eff VDD VDD VSS VSS gf180mcu_fd_sc_mcu7t5v0__clkbuf_4
Xclkbuf_1_0__f_clk_regs clknet_0_clk_regs clknet_1_0__leaf_clk_regs VDD VDD VSS VSS gf180mcu_fd_sc_mcu7t5v0__clkbuf_4
Xclkbuf_1_0__f_clk_sd clknet_0_clk_sd clknet_1_0__leaf_clk_sd VDD VDD VSS VSS gf180mcu_fd_sc_mcu7t5v0__clkbuf_4
Xclkbuf_1_1__f_ck_regs clknet_0_ck_regs clknet_1_1__leaf_ck_regs VDD VDD VSS VSS gf180mcu_fd_sc_mcu7t5v0__clkbuf_4
Xclkbuf_1_1__f_clk clknet_0_clk clknet_1_1__leaf_clk VDD VDD VSS VSS gf180mcu_fd_sc_mcu7t5v0__clkbuf_4
Xclkbuf_1_1__f_clk_eff clknet_0_clk_eff clknet_1_1__leaf_clk_eff VDD VDD VSS VSS gf180mcu_fd_sc_mcu7t5v0__clkbuf_4
Xclkbuf_1_1__f_clk_regs clknet_0_clk_regs clknet_1_1__leaf_clk_regs VDD VDD VSS VSS gf180mcu_fd_sc_mcu7t5v0__clkbuf_4
Xclkbuf_1_1__f_clk_sd clknet_0_clk_sd clknet_1_1__leaf_clk_sd VDD VDD VSS VSS gf180mcu_fd_sc_mcu7t5v0__clkbuf_4
Xclkbuf_2_0__f_clk_dec clknet_0_clk_dec clknet_2_0__leaf_clk_dec VDD VDD VSS VSS gf180mcu_fd_sc_mcu7t5v0__clkbuf_4
Xclkbuf_2_1__f_clk_dec clknet_0_clk_dec clknet_2_1__leaf_clk_dec VDD VDD VSS VSS gf180mcu_fd_sc_mcu7t5v0__clkbuf_4
Xclkbuf_2_2__f_clk_dec clknet_0_clk_dec clknet_2_2__leaf_clk_dec VDD VDD VSS VSS gf180mcu_fd_sc_mcu7t5v0__clkbuf_4
Xclkbuf_2_3__f_clk_dec clknet_0_clk_dec clknet_2_3__leaf_clk_dec VDD VDD VSS VSS gf180mcu_fd_sc_mcu7t5v0__clkbuf_4
Xclkbuf_3_0__f_clk_spi clknet_0_clk_spi clknet_3_0__leaf_clk_spi VDD VDD VSS VSS gf180mcu_fd_sc_mcu7t5v0__clkbuf_4
Xclkbuf_3_1__f_clk_spi clknet_0_clk_spi clknet_3_1__leaf_clk_spi VDD VDD VSS VSS gf180mcu_fd_sc_mcu7t5v0__clkbuf_4
Xclkbuf_3_2__f_clk_spi clknet_0_clk_spi clknet_3_2__leaf_clk_spi VDD VDD VSS VSS gf180mcu_fd_sc_mcu7t5v0__clkbuf_4
Xclkbuf_3_3__f_clk_spi clknet_0_clk_spi clknet_3_3__leaf_clk_spi VDD VDD VSS VSS gf180mcu_fd_sc_mcu7t5v0__clkbuf_4
Xclkbuf_3_4__f_clk_spi clknet_0_clk_spi clknet_3_4__leaf_clk_spi VDD VDD VSS VSS gf180mcu_fd_sc_mcu7t5v0__clkbuf_4
Xclkbuf_3_5__f_clk_spi clknet_0_clk_spi clknet_3_5__leaf_clk_spi VDD VDD VSS VSS gf180mcu_fd_sc_mcu7t5v0__clkbuf_4
Xclkbuf_3_6__f_clk_spi clknet_0_clk_spi clknet_3_6__leaf_clk_spi VDD VDD VSS VSS gf180mcu_fd_sc_mcu7t5v0__clkbuf_4
Xclkbuf_3_7__f_clk_spi clknet_0_clk_spi clknet_3_7__leaf_clk_spi VDD VDD VSS VSS gf180mcu_fd_sc_mcu7t5v0__clkbuf_4
Xclkbuf_regs_0_clk delaynet_4_clk clk_regs VDD VDD VSS VSS gf180mcu_fd_sc_mcu7t5v0__clkbuf_4
Xclkbuf_regs_1_ck ck ck_regs VDD VDD VSS VSS gf180mcu_fd_sc_mcu7t5v0__clkbuf_4
Xclkload0 clknet_1_1__leaf_clk_regs nc_clkload0_Z VDD VDD VSS VSS gf180mcu_fd_sc_mcu7t5v0__clkbuf_2
Xclkload1 clknet_3_0__leaf_clk_spi nc_clkload1_Z VDD VDD VSS VSS gf180mcu_fd_sc_mcu7t5v0__clkbuf_2
Xclkload10 clknet_2_0__leaf_clk_dec nc_clkload10_ZN VDD VDD VSS VSS gf180mcu_fd_sc_mcu7t5v0__inv_2
Xclkload11 clknet_2_1__leaf_clk_dec nc_clkload11_Z VDD VDD VSS VSS gf180mcu_fd_sc_mcu7t5v0__clkbuf_2
Xclkload12 clknet_2_2__leaf_clk_dec nc_clkload12_ZN VDD VDD VSS VSS gf180mcu_fd_sc_mcu7t5v0__inv_2
Xclkload13 clknet_1_1__leaf_ck_regs nc_clkload13_Z VDD VDD VSS VSS gf180mcu_fd_sc_mcu7t5v0__clkbuf_2
Xclkload2 clknet_3_1__leaf_clk_spi nc_clkload2_ZN VDD VDD VSS VSS gf180mcu_fd_sc_mcu7t5v0__inv_4
Xclkload3 clknet_3_2__leaf_clk_spi nc_clkload3_ZN VDD VDD VSS VSS gf180mcu_fd_sc_mcu7t5v0__inv_4
Xclkload4 clknet_3_3__leaf_clk_spi nc_clkload4_ZN VDD VDD VSS VSS gf180mcu_fd_sc_mcu7t5v0__clkinv_8
Xclkload5 clknet_3_4__leaf_clk_spi nc_clkload5_ZN VDD VDD VSS VSS gf180mcu_fd_sc_mcu7t5v0__inv_3
Xclkload6 clknet_3_6__leaf_clk_spi nc_clkload6_ZN VDD VDD VSS VSS gf180mcu_fd_sc_mcu7t5v0__inv_4
Xclkload7 clknet_3_7__leaf_clk_spi nc_clkload7_ZN VDD VDD VSS VSS gf180mcu_fd_sc_mcu7t5v0__inv_4
Xclkload8 clknet_1_1__leaf_clk_sd nc_clkload8_ZN VDD VDD VSS VSS gf180mcu_fd_sc_mcu7t5v0__inv_2
Xclkload9 clknet_1_0__leaf_clk_eff nc_clkload9_Z VDD VDD VSS VSS gf180mcu_fd_sc_mcu7t5v0__clkbuf_2
Xdelaybuf_0_clk clknet_0_clk delaynet_0_clk VDD VDD VSS VSS gf180mcu_fd_sc_mcu7t5v0__clkbuf_4
Xdelaybuf_1_clk clk delaynet_1_clk VDD VDD VSS VSS gf180mcu_fd_sc_mcu7t5v0__clkbuf_4
Xdelaybuf_2_clk delaynet_1_clk delaynet_2_clk VDD VDD VSS VSS gf180mcu_fd_sc_mcu7t5v0__clkbuf_4
Xdelaybuf_3_clk delaynet_2_clk delaynet_3_clk VDD VDD VSS VSS gf180mcu_fd_sc_mcu7t5v0__clkbuf_4
Xdelaybuf_4_clk delaynet_3_clk delaynet_4_clk VDD VDD VSS VSS gf180mcu_fd_sc_mcu7t5v0__clkbuf_4
Xg_dec_icg clknet_1_1__leaf_clk g_dec.en net clk_dec VDD VDD VSS VSS gf180mcu_fd_sc_mcu7t5v0__icgtp_1
Xg_dec_icg_54 net VDD VDD VSS VSS gf180mcu_fd_sc_mcu7t5v0__tiel
Xg_eff_icg clknet_1_0__leaf_clk g_eff.en net54 clk_eff VDD VDD VSS VSS gf180mcu_fd_sc_mcu7t5v0__icgtp_1
Xg_eff_icg_55 net54 VDD VDD VSS VSS gf180mcu_fd_sc_mcu7t5v0__tiel
Xg_sd_icg clknet_1_0__leaf_clk g_sd.en net55 clk_sd VDD VDD VSS VSS gf180mcu_fd_sc_mcu7t5v0__icgtp_1
Xg_sd_icg_56 net55 VDD VDD VSS VSS gf180mcu_fd_sc_mcu7t5v0__tiel
Xg_spi_icg clknet_1_1__leaf_clk en_spi net56 clk_spi VDD VDD VSS VSS gf180mcu_fd_sc_mcu7t5v0__icgtp_1
Xg_spi_icg_57 net56 VDD VDD VSS VSS gf180mcu_fd_sc_mcu7t5v0__tiel
Xhold92 fsk net91 VDD VDD VSS VSS gf180mcu_fd_sc_mcu7t5v0__dlyc_1
Xhold93 sclk net92 VDD VDD VSS VSS gf180mcu_fd_sc_mcu7t5v0__dlyc_1
Xhold94 mosi net93 VDD VDD VSS VSS gf180mcu_fd_sc_mcu7t5v0__dlyc_1
Xinput1 cs_n net1 VDD VDD VSS VSS gf180mcu_fd_sc_mcu7t5v0__buf_1
Xinput2 net91 net2 VDD VDD VSS VSS gf180mcu_fd_sc_mcu7t5v0__buf_1
Xinput3 net93 net3 VDD VDD VSS VSS gf180mcu_fd_sc_mcu7t5v0__buf_1
Xinput4 rst_n net4 VDD VDD VSS VSS gf180mcu_fd_sc_mcu7t5v0__buf_2
Xinput5 net92 net5 VDD VDD VSS VSS gf180mcu_fd_sc_mcu7t5v0__buf_1
Xload_slew50 net51 net50 VDD VDD VSS VSS gf180mcu_fd_sc_mcu7t5v0__buf_12
Xload_slew51 net4 net51 VDD VDD VSS VSS gf180mcu_fd_sc_mcu7t5v0__buf_12
Xload_slew52 net4 net52 VDD VDD VSS VSS gf180mcu_fd_sc_mcu7t5v0__buf_12
Xload_slew53 net4 net53 VDD VDD VSS VSS gf180mcu_fd_sc_mcu7t5v0__buf_16
Xmax_cap49 _0370_ net49 VDD VDD VSS VSS gf180mcu_fd_sc_mcu7t5v0__clkbuf_3
Xoutput10 net10 dac_bn[3] VDD VDD VSS VSS gf180mcu_fd_sc_mcu7t5v0__buf_1
Xoutput11 net11 dac_bn[4] VDD VDD VSS VSS gf180mcu_fd_sc_mcu7t5v0__buf_1
Xoutput12 net12 dac_sdn VDD VDD VSS VSS gf180mcu_fd_sc_mcu7t5v0__buf_1
Xoutput13 net13 dac_tn[0] VDD VDD VSS VSS gf180mcu_fd_sc_mcu7t5v0__buf_1
Xoutput14 net14 dac_tn[10] VDD VDD VSS VSS gf180mcu_fd_sc_mcu7t5v0__buf_1
Xoutput15 net15 dac_tn[11] VDD VDD VSS VSS gf180mcu_fd_sc_mcu7t5v0__buf_1
Xoutput16 net16 dac_tn[12] VDD VDD VSS VSS gf180mcu_fd_sc_mcu7t5v0__buf_1
Xoutput17 net17 dac_tn[13] VDD VDD VSS VSS gf180mcu_fd_sc_mcu7t5v0__buf_1
Xoutput18 net18 dac_tn[14] VDD VDD VSS VSS gf180mcu_fd_sc_mcu7t5v0__buf_1
Xoutput19 net19 dac_tn[15] VDD VDD VSS VSS gf180mcu_fd_sc_mcu7t5v0__buf_1
Xoutput20 net20 dac_tn[16] VDD VDD VSS VSS gf180mcu_fd_sc_mcu7t5v0__buf_1
Xoutput21 net21 dac_tn[17] VDD VDD VSS VSS gf180mcu_fd_sc_mcu7t5v0__buf_1
Xoutput22 net22 dac_tn[18] VDD VDD VSS VSS gf180mcu_fd_sc_mcu7t5v0__buf_1
Xoutput23 net23 dac_tn[19] VDD VDD VSS VSS gf180mcu_fd_sc_mcu7t5v0__buf_1
Xoutput24 net24 dac_tn[1] VDD VDD VSS VSS gf180mcu_fd_sc_mcu7t5v0__buf_1
Xoutput25 net25 dac_tn[20] VDD VDD VSS VSS gf180mcu_fd_sc_mcu7t5v0__buf_1
Xoutput26 net26 dac_tn[21] VDD VDD VSS VSS gf180mcu_fd_sc_mcu7t5v0__buf_1
Xoutput27 net27 dac_tn[22] VDD VDD VSS VSS gf180mcu_fd_sc_mcu7t5v0__buf_1
Xoutput28 net28 dac_tn[23] VDD VDD VSS VSS gf180mcu_fd_sc_mcu7t5v0__buf_1
Xoutput29 net29 dac_tn[24] VDD VDD VSS VSS gf180mcu_fd_sc_mcu7t5v0__buf_1
Xoutput30 net30 dac_tn[25] VDD VDD VSS VSS gf180mcu_fd_sc_mcu7t5v0__buf_1
Xoutput31 net31 dac_tn[26] VDD VDD VSS VSS gf180mcu_fd_sc_mcu7t5v0__buf_1
Xoutput32 net32 dac_tn[27] VDD VDD VSS VSS gf180mcu_fd_sc_mcu7t5v0__buf_1
Xoutput33 net33 dac_tn[28] VDD VDD VSS VSS gf180mcu_fd_sc_mcu7t5v0__buf_1
Xoutput34 net34 dac_tn[29] VDD VDD VSS VSS gf180mcu_fd_sc_mcu7t5v0__buf_1
Xoutput35 net35 dac_tn[2] VDD VDD VSS VSS gf180mcu_fd_sc_mcu7t5v0__buf_1
Xoutput36 net36 dac_tn[30] VDD VDD VSS VSS gf180mcu_fd_sc_mcu7t5v0__buf_1
Xoutput37 net37 dac_tn[3] VDD VDD VSS VSS gf180mcu_fd_sc_mcu7t5v0__buf_1
Xoutput38 net38 dac_tn[4] VDD VDD VSS VSS gf180mcu_fd_sc_mcu7t5v0__buf_1
Xoutput39 net39 dac_tn[5] VDD VDD VSS VSS gf180mcu_fd_sc_mcu7t5v0__buf_1
Xoutput40 net40 dac_tn[6] VDD VDD VSS VSS gf180mcu_fd_sc_mcu7t5v0__buf_1
Xoutput41 net41 dac_tn[7] VDD VDD VSS VSS gf180mcu_fd_sc_mcu7t5v0__buf_1
Xoutput42 net42 dac_tn[8] VDD VDD VSS VSS gf180mcu_fd_sc_mcu7t5v0__buf_1
Xoutput43 net43 dac_tn[9] VDD VDD VSS VSS gf180mcu_fd_sc_mcu7t5v0__buf_1
Xoutput44 net44 div1024 VDD VDD VSS VSS gf180mcu_fd_sc_mcu7t5v0__buf_1
Xoutput45 net45 div16 VDD VDD VSS VSS gf180mcu_fd_sc_mcu7t5v0__buf_1
Xoutput46 net46 div64 VDD VDD VSS VSS gf180mcu_fd_sc_mcu7t5v0__buf_1
Xoutput47 net47 miso VDD VDD VSS VSS gf180mcu_fd_sc_mcu7t5v0__buf_1
Xoutput6 net6 ck_o VDD VDD VSS VSS gf180mcu_fd_sc_mcu7t5v0__buf_1
Xoutput7 net7 dac_bn[0] VDD VDD VSS VSS gf180mcu_fd_sc_mcu7t5v0__buf_1
Xoutput8 net8 dac_bn[1] VDD VDD VSS VSS gf180mcu_fd_sc_mcu7t5v0__buf_1
Xoutput9 net9 dac_bn[2] VDD VDD VSS VSS gf180mcu_fd_sc_mcu7t5v0__buf_1
Xrebuffer59 _0283_ net58 VDD VDD VSS VSS gf180mcu_fd_sc_mcu7t5v0__buf_8
Xrebuffer60 _0283_ net59 VDD VDD VSS VSS gf180mcu_fd_sc_mcu7t5v0__buf_8
Xrebuffer61 _0280_ net60 VDD VDD VSS VSS gf180mcu_fd_sc_mcu7t5v0__buf_8
Xrebuffer62 _0280_ net61 VDD VDD VSS VSS gf180mcu_fd_sc_mcu7t5v0__buf_8
Xrebuffer63 _0191_ net62 VDD VDD VSS VSS gf180mcu_fd_sc_mcu7t5v0__buf_8
Xwire48 _0370_ net48 VDD VDD VSS VSS gf180mcu_fd_sc_mcu7t5v0__clkbuf_3
.ends tx_fine

.subckt mdac VDD VSS vg vbnf ns30 ns28 ns26 ns24 ns22 ns20 ns18 ns16 ns14 ns12 ns10 ns8 ns6 ns4 ns2 nb4 nb2 nb0 nsd nb1 nb3 ns1 ns3 ns5 ns7 ns9 ns11 ns13 ns15 ns17 ns19 ns21 ns23 ns25 ns27 ns29 ns31
X0 pb pb VDD VDD pfet_03v3 w=1.000u l=4.000u
X1 pb pb VDD VDD pfet_03v3 w=1.000u l=4.000u
X2 pb pb VDD VDD pfet_03v3 w=1.000u l=4.000u
X3 pb pb VDD VDD pfet_03v3 w=1.000u l=4.000u
X4 pb pb VDD VDD pfet_03v3 w=1.000u l=4.000u
X5 pb pb VDD VDD pfet_03v3 w=1.000u l=4.000u
X6 pb pb VDD VDD pfet_03v3 w=1.000u l=4.000u
X7 pb pb VDD VDD pfet_03v3 w=1.000u l=4.000u
X8 pb pb VDD VDD pfet_03v3 w=1.000u l=4.000u
X9 pb pb VDD VDD pfet_03v3 w=1.000u l=4.000u
X10 pb pb VDD VDD pfet_03v3 w=1.000u l=4.000u
X11 pb pb VDD VDD pfet_03v3 w=1.000u l=4.000u
X12 pb pb VDD VDD pfet_03v3 w=1.000u l=4.000u
X13 pb pb VDD VDD pfet_03v3 w=1.000u l=4.000u
X14 pb pb VDD VDD pfet_03v3 w=1.000u l=4.000u
X15 pb pb VDD VDD pfet_03v3 w=1.000u l=4.000u
X16 pb pb VDD VDD pfet_03v3 w=1.000u l=4.000u
X17 pb pb VDD VDD pfet_03v3 w=1.000u l=4.000u
X18 pb pb VDD VDD pfet_03v3 w=1.000u l=4.000u
X19 pb pb VDD VDD pfet_03v3 w=1.000u l=4.000u
X20 pb pb VDD VDD pfet_03v3 w=1.000u l=4.000u
X21 pb pb VDD VDD pfet_03v3 w=1.000u l=4.000u
X22 pb pb VDD VDD pfet_03v3 w=1.000u l=4.000u
X23 pb pb VDD VDD pfet_03v3 w=1.000u l=4.000u
X24 pb pb VDD VDD pfet_03v3 w=1.000u l=4.000u
X25 pb pb VDD VDD pfet_03v3 w=1.000u l=4.000u
X26 pb pb VDD VDD pfet_03v3 w=1.000u l=4.000u
X27 pb pb VDD VDD pfet_03v3 w=1.000u l=4.000u
X28 pb pb VDD VDD pfet_03v3 w=1.000u l=4.000u
X29 pb pb VDD VDD pfet_03v3 w=1.000u l=4.000u
X30 pb pb VDD VDD pfet_03v3 w=1.000u l=4.000u
X31 pb pb VDD VDD pfet_03v3 w=1.000u l=4.000u
X32 mo pb VDD VDD pfet_03v3 w=1.000u l=4.000u
X33 mo pb VDD VDD pfet_03v3 w=1.000u l=4.000u
X34 mo pb VDD VDD pfet_03v3 w=1.000u l=4.000u
X35 mo pb VDD VDD pfet_03v3 w=1.000u l=4.000u
X36 mo pb VDD VDD pfet_03v3 w=1.000u l=4.000u
X37 mo pb VDD VDD pfet_03v3 w=1.000u l=4.000u
X38 mo pb VDD VDD pfet_03v3 w=1.000u l=4.000u
X39 mo pb VDD VDD pfet_03v3 w=1.000u l=4.000u
X40 mo pb VDD VDD pfet_03v3 w=1.000u l=4.000u
X41 mo pb VDD VDD pfet_03v3 w=1.000u l=4.000u
X42 mo pb VDD VDD pfet_03v3 w=1.000u l=4.000u
X43 mo pb VDD VDD pfet_03v3 w=1.000u l=4.000u
X44 mo pb VDD VDD pfet_03v3 w=1.000u l=4.000u
X45 mo pb VDD VDD pfet_03v3 w=1.000u l=4.000u
X46 mo pb VDD VDD pfet_03v3 w=1.000u l=4.000u
X47 mo pb VDD VDD pfet_03v3 w=1.000u l=4.000u
X48 mo pb VDD VDD pfet_03v3 w=1.000u l=4.000u
X49 mo pb VDD VDD pfet_03v3 w=1.000u l=4.000u
X50 mo pb VDD VDD pfet_03v3 w=1.000u l=4.000u
X51 mo pb VDD VDD pfet_03v3 w=1.000u l=4.000u
X52 mo pb VDD VDD pfet_03v3 w=1.000u l=4.000u
X53 mo pb VDD VDD pfet_03v3 w=1.000u l=4.000u
X54 mo pb VDD VDD pfet_03v3 w=1.000u l=4.000u
X55 mo pb VDD VDD pfet_03v3 w=1.000u l=4.000u
X56 mo pb VDD VDD pfet_03v3 w=1.000u l=4.000u
X57 mo pb VDD VDD pfet_03v3 w=1.000u l=4.000u
X58 mo pb VDD VDD pfet_03v3 w=1.000u l=4.000u
X59 mo pb VDD VDD pfet_03v3 w=1.000u l=4.000u
X60 mo pb VDD VDD pfet_03v3 w=1.000u l=4.000u
X61 mo pb VDD VDD pfet_03v3 w=1.000u l=4.000u
X62 mo pb VDD VDD pfet_03v3 w=1.000u l=4.000u
X63 mo pb VDD VDD pfet_03v3 w=1.000u l=4.000u
X64 cs30 pb VDD VDD pfet_03v3 w=1.000u l=4.000u
X65 cs30 pb VDD VDD pfet_03v3 w=1.000u l=4.000u
X66 cs30 pb VDD VDD pfet_03v3 w=1.000u l=4.000u
X67 cs30 pb VDD VDD pfet_03v3 w=1.000u l=4.000u
X68 cs30 pb VDD VDD pfet_03v3 w=1.000u l=4.000u
X69 cs30 pb VDD VDD pfet_03v3 w=1.000u l=4.000u
X70 cs30 pb VDD VDD pfet_03v3 w=1.000u l=4.000u
X71 cs30 pb VDD VDD pfet_03v3 w=1.000u l=4.000u
X72 cs30 pb VDD VDD pfet_03v3 w=1.000u l=4.000u
X73 cs30 pb VDD VDD pfet_03v3 w=1.000u l=4.000u
X74 cs30 pb VDD VDD pfet_03v3 w=1.000u l=4.000u
X75 cs30 pb VDD VDD pfet_03v3 w=1.000u l=4.000u
X76 cs30 pb VDD VDD pfet_03v3 w=1.000u l=4.000u
X77 cs30 pb VDD VDD pfet_03v3 w=1.000u l=4.000u
X78 cs30 pb VDD VDD pfet_03v3 w=1.000u l=4.000u
X79 cs30 pb VDD VDD pfet_03v3 w=1.000u l=4.000u
X80 cs30 pb VDD VDD pfet_03v3 w=1.000u l=4.000u
X81 cs30 pb VDD VDD pfet_03v3 w=1.000u l=4.000u
X82 cs30 pb VDD VDD pfet_03v3 w=1.000u l=4.000u
X83 cs30 pb VDD VDD pfet_03v3 w=1.000u l=4.000u
X84 cs30 pb VDD VDD pfet_03v3 w=1.000u l=4.000u
X85 cs30 pb VDD VDD pfet_03v3 w=1.000u l=4.000u
X86 cs30 pb VDD VDD pfet_03v3 w=1.000u l=4.000u
X87 cs30 pb VDD VDD pfet_03v3 w=1.000u l=4.000u
X88 cs30 pb VDD VDD pfet_03v3 w=1.000u l=4.000u
X89 cs30 pb VDD VDD pfet_03v3 w=1.000u l=4.000u
X90 cs30 pb VDD VDD pfet_03v3 w=1.000u l=4.000u
X91 cs30 pb VDD VDD pfet_03v3 w=1.000u l=4.000u
X92 cs30 pb VDD VDD pfet_03v3 w=1.000u l=4.000u
X93 cs30 pb VDD VDD pfet_03v3 w=1.000u l=4.000u
X94 cs30 pb VDD VDD pfet_03v3 w=1.000u l=4.000u
X95 cs30 pb VDD VDD pfet_03v3 w=1.000u l=4.000u
X96 mo ns30 cs30 VDD pfet_03v3 w=1.000u l=0.280u
X97 md mo cs30 VDD pfet_03v3 w=1.000u l=0.280u
X98 cs28 pb VDD VDD pfet_03v3 w=1.000u l=4.000u
X99 cs28 pb VDD VDD pfet_03v3 w=1.000u l=4.000u
X100 cs28 pb VDD VDD pfet_03v3 w=1.000u l=4.000u
X101 cs28 pb VDD VDD pfet_03v3 w=1.000u l=4.000u
X102 cs28 pb VDD VDD pfet_03v3 w=1.000u l=4.000u
X103 cs28 pb VDD VDD pfet_03v3 w=1.000u l=4.000u
X104 cs28 pb VDD VDD pfet_03v3 w=1.000u l=4.000u
X105 cs28 pb VDD VDD pfet_03v3 w=1.000u l=4.000u
X106 cs28 pb VDD VDD pfet_03v3 w=1.000u l=4.000u
X107 cs28 pb VDD VDD pfet_03v3 w=1.000u l=4.000u
X108 cs28 pb VDD VDD pfet_03v3 w=1.000u l=4.000u
X109 cs28 pb VDD VDD pfet_03v3 w=1.000u l=4.000u
X110 cs28 pb VDD VDD pfet_03v3 w=1.000u l=4.000u
X111 cs28 pb VDD VDD pfet_03v3 w=1.000u l=4.000u
X112 cs28 pb VDD VDD pfet_03v3 w=1.000u l=4.000u
X113 cs28 pb VDD VDD pfet_03v3 w=1.000u l=4.000u
X114 cs28 pb VDD VDD pfet_03v3 w=1.000u l=4.000u
X115 cs28 pb VDD VDD pfet_03v3 w=1.000u l=4.000u
X116 cs28 pb VDD VDD pfet_03v3 w=1.000u l=4.000u
X117 cs28 pb VDD VDD pfet_03v3 w=1.000u l=4.000u
X118 cs28 pb VDD VDD pfet_03v3 w=1.000u l=4.000u
X119 cs28 pb VDD VDD pfet_03v3 w=1.000u l=4.000u
X120 cs28 pb VDD VDD pfet_03v3 w=1.000u l=4.000u
X121 cs28 pb VDD VDD pfet_03v3 w=1.000u l=4.000u
X122 cs28 pb VDD VDD pfet_03v3 w=1.000u l=4.000u
X123 cs28 pb VDD VDD pfet_03v3 w=1.000u l=4.000u
X124 cs28 pb VDD VDD pfet_03v3 w=1.000u l=4.000u
X125 cs28 pb VDD VDD pfet_03v3 w=1.000u l=4.000u
X126 cs28 pb VDD VDD pfet_03v3 w=1.000u l=4.000u
X127 cs28 pb VDD VDD pfet_03v3 w=1.000u l=4.000u
X128 cs28 pb VDD VDD pfet_03v3 w=1.000u l=4.000u
X129 cs28 pb VDD VDD pfet_03v3 w=1.000u l=4.000u
X130 mo ns28 cs28 VDD pfet_03v3 w=1.000u l=0.280u
X131 md mo cs28 VDD pfet_03v3 w=1.000u l=0.280u
X132 cs26 pb VDD VDD pfet_03v3 w=1.000u l=4.000u
X133 cs26 pb VDD VDD pfet_03v3 w=1.000u l=4.000u
X134 cs26 pb VDD VDD pfet_03v3 w=1.000u l=4.000u
X135 cs26 pb VDD VDD pfet_03v3 w=1.000u l=4.000u
X136 cs26 pb VDD VDD pfet_03v3 w=1.000u l=4.000u
X137 cs26 pb VDD VDD pfet_03v3 w=1.000u l=4.000u
X138 cs26 pb VDD VDD pfet_03v3 w=1.000u l=4.000u
X139 cs26 pb VDD VDD pfet_03v3 w=1.000u l=4.000u
X140 cs26 pb VDD VDD pfet_03v3 w=1.000u l=4.000u
X141 cs26 pb VDD VDD pfet_03v3 w=1.000u l=4.000u
X142 cs26 pb VDD VDD pfet_03v3 w=1.000u l=4.000u
X143 cs26 pb VDD VDD pfet_03v3 w=1.000u l=4.000u
X144 cs26 pb VDD VDD pfet_03v3 w=1.000u l=4.000u
X145 cs26 pb VDD VDD pfet_03v3 w=1.000u l=4.000u
X146 cs26 pb VDD VDD pfet_03v3 w=1.000u l=4.000u
X147 cs26 pb VDD VDD pfet_03v3 w=1.000u l=4.000u
X148 cs26 pb VDD VDD pfet_03v3 w=1.000u l=4.000u
X149 cs26 pb VDD VDD pfet_03v3 w=1.000u l=4.000u
X150 cs26 pb VDD VDD pfet_03v3 w=1.000u l=4.000u
X151 cs26 pb VDD VDD pfet_03v3 w=1.000u l=4.000u
X152 cs26 pb VDD VDD pfet_03v3 w=1.000u l=4.000u
X153 cs26 pb VDD VDD pfet_03v3 w=1.000u l=4.000u
X154 cs26 pb VDD VDD pfet_03v3 w=1.000u l=4.000u
X155 cs26 pb VDD VDD pfet_03v3 w=1.000u l=4.000u
X156 cs26 pb VDD VDD pfet_03v3 w=1.000u l=4.000u
X157 cs26 pb VDD VDD pfet_03v3 w=1.000u l=4.000u
X158 cs26 pb VDD VDD pfet_03v3 w=1.000u l=4.000u
X159 cs26 pb VDD VDD pfet_03v3 w=1.000u l=4.000u
X160 cs26 pb VDD VDD pfet_03v3 w=1.000u l=4.000u
X161 cs26 pb VDD VDD pfet_03v3 w=1.000u l=4.000u
X162 cs26 pb VDD VDD pfet_03v3 w=1.000u l=4.000u
X163 cs26 pb VDD VDD pfet_03v3 w=1.000u l=4.000u
X164 mo ns26 cs26 VDD pfet_03v3 w=1.000u l=0.280u
X165 md mo cs26 VDD pfet_03v3 w=1.000u l=0.280u
X166 cs24 pb VDD VDD pfet_03v3 w=1.000u l=4.000u
X167 cs24 pb VDD VDD pfet_03v3 w=1.000u l=4.000u
X168 cs24 pb VDD VDD pfet_03v3 w=1.000u l=4.000u
X169 cs24 pb VDD VDD pfet_03v3 w=1.000u l=4.000u
X170 cs24 pb VDD VDD pfet_03v3 w=1.000u l=4.000u
X171 cs24 pb VDD VDD pfet_03v3 w=1.000u l=4.000u
X172 cs24 pb VDD VDD pfet_03v3 w=1.000u l=4.000u
X173 cs24 pb VDD VDD pfet_03v3 w=1.000u l=4.000u
X174 cs24 pb VDD VDD pfet_03v3 w=1.000u l=4.000u
X175 cs24 pb VDD VDD pfet_03v3 w=1.000u l=4.000u
X176 cs24 pb VDD VDD pfet_03v3 w=1.000u l=4.000u
X177 cs24 pb VDD VDD pfet_03v3 w=1.000u l=4.000u
X178 cs24 pb VDD VDD pfet_03v3 w=1.000u l=4.000u
X179 cs24 pb VDD VDD pfet_03v3 w=1.000u l=4.000u
X180 cs24 pb VDD VDD pfet_03v3 w=1.000u l=4.000u
X181 cs24 pb VDD VDD pfet_03v3 w=1.000u l=4.000u
X182 cs24 pb VDD VDD pfet_03v3 w=1.000u l=4.000u
X183 cs24 pb VDD VDD pfet_03v3 w=1.000u l=4.000u
X184 cs24 pb VDD VDD pfet_03v3 w=1.000u l=4.000u
X185 cs24 pb VDD VDD pfet_03v3 w=1.000u l=4.000u
X186 cs24 pb VDD VDD pfet_03v3 w=1.000u l=4.000u
X187 cs24 pb VDD VDD pfet_03v3 w=1.000u l=4.000u
X188 cs24 pb VDD VDD pfet_03v3 w=1.000u l=4.000u
X189 cs24 pb VDD VDD pfet_03v3 w=1.000u l=4.000u
X190 cs24 pb VDD VDD pfet_03v3 w=1.000u l=4.000u
X191 cs24 pb VDD VDD pfet_03v3 w=1.000u l=4.000u
X192 cs24 pb VDD VDD pfet_03v3 w=1.000u l=4.000u
X193 cs24 pb VDD VDD pfet_03v3 w=1.000u l=4.000u
X194 cs24 pb VDD VDD pfet_03v3 w=1.000u l=4.000u
X195 cs24 pb VDD VDD pfet_03v3 w=1.000u l=4.000u
X196 cs24 pb VDD VDD pfet_03v3 w=1.000u l=4.000u
X197 cs24 pb VDD VDD pfet_03v3 w=1.000u l=4.000u
X198 mo ns24 cs24 VDD pfet_03v3 w=1.000u l=0.280u
X199 md mo cs24 VDD pfet_03v3 w=1.000u l=0.280u
X200 cs22 pb VDD VDD pfet_03v3 w=1.000u l=4.000u
X201 cs22 pb VDD VDD pfet_03v3 w=1.000u l=4.000u
X202 cs22 pb VDD VDD pfet_03v3 w=1.000u l=4.000u
X203 cs22 pb VDD VDD pfet_03v3 w=1.000u l=4.000u
X204 cs22 pb VDD VDD pfet_03v3 w=1.000u l=4.000u
X205 cs22 pb VDD VDD pfet_03v3 w=1.000u l=4.000u
X206 cs22 pb VDD VDD pfet_03v3 w=1.000u l=4.000u
X207 cs22 pb VDD VDD pfet_03v3 w=1.000u l=4.000u
X208 cs22 pb VDD VDD pfet_03v3 w=1.000u l=4.000u
X209 cs22 pb VDD VDD pfet_03v3 w=1.000u l=4.000u
X210 cs22 pb VDD VDD pfet_03v3 w=1.000u l=4.000u
X211 cs22 pb VDD VDD pfet_03v3 w=1.000u l=4.000u
X212 cs22 pb VDD VDD pfet_03v3 w=1.000u l=4.000u
X213 cs22 pb VDD VDD pfet_03v3 w=1.000u l=4.000u
X214 cs22 pb VDD VDD pfet_03v3 w=1.000u l=4.000u
X215 cs22 pb VDD VDD pfet_03v3 w=1.000u l=4.000u
X216 cs22 pb VDD VDD pfet_03v3 w=1.000u l=4.000u
X217 cs22 pb VDD VDD pfet_03v3 w=1.000u l=4.000u
X218 cs22 pb VDD VDD pfet_03v3 w=1.000u l=4.000u
X219 cs22 pb VDD VDD pfet_03v3 w=1.000u l=4.000u
X220 cs22 pb VDD VDD pfet_03v3 w=1.000u l=4.000u
X221 cs22 pb VDD VDD pfet_03v3 w=1.000u l=4.000u
X222 cs22 pb VDD VDD pfet_03v3 w=1.000u l=4.000u
X223 cs22 pb VDD VDD pfet_03v3 w=1.000u l=4.000u
X224 cs22 pb VDD VDD pfet_03v3 w=1.000u l=4.000u
X225 cs22 pb VDD VDD pfet_03v3 w=1.000u l=4.000u
X226 cs22 pb VDD VDD pfet_03v3 w=1.000u l=4.000u
X227 cs22 pb VDD VDD pfet_03v3 w=1.000u l=4.000u
X228 cs22 pb VDD VDD pfet_03v3 w=1.000u l=4.000u
X229 cs22 pb VDD VDD pfet_03v3 w=1.000u l=4.000u
X230 cs22 pb VDD VDD pfet_03v3 w=1.000u l=4.000u
X231 cs22 pb VDD VDD pfet_03v3 w=1.000u l=4.000u
X232 mo ns22 cs22 VDD pfet_03v3 w=1.000u l=0.280u
X233 md mo cs22 VDD pfet_03v3 w=1.000u l=0.280u
X234 cs20 pb VDD VDD pfet_03v3 w=1.000u l=4.000u
X235 cs20 pb VDD VDD pfet_03v3 w=1.000u l=4.000u
X236 cs20 pb VDD VDD pfet_03v3 w=1.000u l=4.000u
X237 cs20 pb VDD VDD pfet_03v3 w=1.000u l=4.000u
X238 cs20 pb VDD VDD pfet_03v3 w=1.000u l=4.000u
X239 cs20 pb VDD VDD pfet_03v3 w=1.000u l=4.000u
X240 cs20 pb VDD VDD pfet_03v3 w=1.000u l=4.000u
X241 cs20 pb VDD VDD pfet_03v3 w=1.000u l=4.000u
X242 cs20 pb VDD VDD pfet_03v3 w=1.000u l=4.000u
X243 cs20 pb VDD VDD pfet_03v3 w=1.000u l=4.000u
X244 cs20 pb VDD VDD pfet_03v3 w=1.000u l=4.000u
X245 cs20 pb VDD VDD pfet_03v3 w=1.000u l=4.000u
X246 cs20 pb VDD VDD pfet_03v3 w=1.000u l=4.000u
X247 cs20 pb VDD VDD pfet_03v3 w=1.000u l=4.000u
X248 cs20 pb VDD VDD pfet_03v3 w=1.000u l=4.000u
X249 cs20 pb VDD VDD pfet_03v3 w=1.000u l=4.000u
X250 cs20 pb VDD VDD pfet_03v3 w=1.000u l=4.000u
X251 cs20 pb VDD VDD pfet_03v3 w=1.000u l=4.000u
X252 cs20 pb VDD VDD pfet_03v3 w=1.000u l=4.000u
X253 cs20 pb VDD VDD pfet_03v3 w=1.000u l=4.000u
X254 cs20 pb VDD VDD pfet_03v3 w=1.000u l=4.000u
X255 cs20 pb VDD VDD pfet_03v3 w=1.000u l=4.000u
X256 cs20 pb VDD VDD pfet_03v3 w=1.000u l=4.000u
X257 cs20 pb VDD VDD pfet_03v3 w=1.000u l=4.000u
X258 cs20 pb VDD VDD pfet_03v3 w=1.000u l=4.000u
X259 cs20 pb VDD VDD pfet_03v3 w=1.000u l=4.000u
X260 cs20 pb VDD VDD pfet_03v3 w=1.000u l=4.000u
X261 cs20 pb VDD VDD pfet_03v3 w=1.000u l=4.000u
X262 cs20 pb VDD VDD pfet_03v3 w=1.000u l=4.000u
X263 cs20 pb VDD VDD pfet_03v3 w=1.000u l=4.000u
X264 cs20 pb VDD VDD pfet_03v3 w=1.000u l=4.000u
X265 cs20 pb VDD VDD pfet_03v3 w=1.000u l=4.000u
X266 mo ns20 cs20 VDD pfet_03v3 w=1.000u l=0.280u
X267 md mo cs20 VDD pfet_03v3 w=1.000u l=0.280u
X268 cs18 pb VDD VDD pfet_03v3 w=1.000u l=4.000u
X269 cs18 pb VDD VDD pfet_03v3 w=1.000u l=4.000u
X270 cs18 pb VDD VDD pfet_03v3 w=1.000u l=4.000u
X271 cs18 pb VDD VDD pfet_03v3 w=1.000u l=4.000u
X272 cs18 pb VDD VDD pfet_03v3 w=1.000u l=4.000u
X273 cs18 pb VDD VDD pfet_03v3 w=1.000u l=4.000u
X274 cs18 pb VDD VDD pfet_03v3 w=1.000u l=4.000u
X275 cs18 pb VDD VDD pfet_03v3 w=1.000u l=4.000u
X276 cs18 pb VDD VDD pfet_03v3 w=1.000u l=4.000u
X277 cs18 pb VDD VDD pfet_03v3 w=1.000u l=4.000u
X278 cs18 pb VDD VDD pfet_03v3 w=1.000u l=4.000u
X279 cs18 pb VDD VDD pfet_03v3 w=1.000u l=4.000u
X280 cs18 pb VDD VDD pfet_03v3 w=1.000u l=4.000u
X281 cs18 pb VDD VDD pfet_03v3 w=1.000u l=4.000u
X282 cs18 pb VDD VDD pfet_03v3 w=1.000u l=4.000u
X283 cs18 pb VDD VDD pfet_03v3 w=1.000u l=4.000u
X284 cs18 pb VDD VDD pfet_03v3 w=1.000u l=4.000u
X285 cs18 pb VDD VDD pfet_03v3 w=1.000u l=4.000u
X286 cs18 pb VDD VDD pfet_03v3 w=1.000u l=4.000u
X287 cs18 pb VDD VDD pfet_03v3 w=1.000u l=4.000u
X288 cs18 pb VDD VDD pfet_03v3 w=1.000u l=4.000u
X289 cs18 pb VDD VDD pfet_03v3 w=1.000u l=4.000u
X290 cs18 pb VDD VDD pfet_03v3 w=1.000u l=4.000u
X291 cs18 pb VDD VDD pfet_03v3 w=1.000u l=4.000u
X292 cs18 pb VDD VDD pfet_03v3 w=1.000u l=4.000u
X293 cs18 pb VDD VDD pfet_03v3 w=1.000u l=4.000u
X294 cs18 pb VDD VDD pfet_03v3 w=1.000u l=4.000u
X295 cs18 pb VDD VDD pfet_03v3 w=1.000u l=4.000u
X296 cs18 pb VDD VDD pfet_03v3 w=1.000u l=4.000u
X297 cs18 pb VDD VDD pfet_03v3 w=1.000u l=4.000u
X298 cs18 pb VDD VDD pfet_03v3 w=1.000u l=4.000u
X299 cs18 pb VDD VDD pfet_03v3 w=1.000u l=4.000u
X300 mo ns18 cs18 VDD pfet_03v3 w=1.000u l=0.280u
X301 md mo cs18 VDD pfet_03v3 w=1.000u l=0.280u
X302 cs16 pb VDD VDD pfet_03v3 w=1.000u l=4.000u
X303 cs16 pb VDD VDD pfet_03v3 w=1.000u l=4.000u
X304 cs16 pb VDD VDD pfet_03v3 w=1.000u l=4.000u
X305 cs16 pb VDD VDD pfet_03v3 w=1.000u l=4.000u
X306 cs16 pb VDD VDD pfet_03v3 w=1.000u l=4.000u
X307 cs16 pb VDD VDD pfet_03v3 w=1.000u l=4.000u
X308 cs16 pb VDD VDD pfet_03v3 w=1.000u l=4.000u
X309 cs16 pb VDD VDD pfet_03v3 w=1.000u l=4.000u
X310 cs16 pb VDD VDD pfet_03v3 w=1.000u l=4.000u
X311 cs16 pb VDD VDD pfet_03v3 w=1.000u l=4.000u
X312 cs16 pb VDD VDD pfet_03v3 w=1.000u l=4.000u
X313 cs16 pb VDD VDD pfet_03v3 w=1.000u l=4.000u
X314 cs16 pb VDD VDD pfet_03v3 w=1.000u l=4.000u
X315 cs16 pb VDD VDD pfet_03v3 w=1.000u l=4.000u
X316 cs16 pb VDD VDD pfet_03v3 w=1.000u l=4.000u
X317 cs16 pb VDD VDD pfet_03v3 w=1.000u l=4.000u
X318 cs16 pb VDD VDD pfet_03v3 w=1.000u l=4.000u
X319 cs16 pb VDD VDD pfet_03v3 w=1.000u l=4.000u
X320 cs16 pb VDD VDD pfet_03v3 w=1.000u l=4.000u
X321 cs16 pb VDD VDD pfet_03v3 w=1.000u l=4.000u
X322 cs16 pb VDD VDD pfet_03v3 w=1.000u l=4.000u
X323 cs16 pb VDD VDD pfet_03v3 w=1.000u l=4.000u
X324 cs16 pb VDD VDD pfet_03v3 w=1.000u l=4.000u
X325 cs16 pb VDD VDD pfet_03v3 w=1.000u l=4.000u
X326 cs16 pb VDD VDD pfet_03v3 w=1.000u l=4.000u
X327 cs16 pb VDD VDD pfet_03v3 w=1.000u l=4.000u
X328 cs16 pb VDD VDD pfet_03v3 w=1.000u l=4.000u
X329 cs16 pb VDD VDD pfet_03v3 w=1.000u l=4.000u
X330 cs16 pb VDD VDD pfet_03v3 w=1.000u l=4.000u
X331 cs16 pb VDD VDD pfet_03v3 w=1.000u l=4.000u
X332 cs16 pb VDD VDD pfet_03v3 w=1.000u l=4.000u
X333 cs16 pb VDD VDD pfet_03v3 w=1.000u l=4.000u
X334 mo ns16 cs16 VDD pfet_03v3 w=1.000u l=0.280u
X335 md mo cs16 VDD pfet_03v3 w=1.000u l=0.280u
X336 cs14 pb VDD VDD pfet_03v3 w=1.000u l=4.000u
X337 cs14 pb VDD VDD pfet_03v3 w=1.000u l=4.000u
X338 cs14 pb VDD VDD pfet_03v3 w=1.000u l=4.000u
X339 cs14 pb VDD VDD pfet_03v3 w=1.000u l=4.000u
X340 cs14 pb VDD VDD pfet_03v3 w=1.000u l=4.000u
X341 cs14 pb VDD VDD pfet_03v3 w=1.000u l=4.000u
X342 cs14 pb VDD VDD pfet_03v3 w=1.000u l=4.000u
X343 cs14 pb VDD VDD pfet_03v3 w=1.000u l=4.000u
X344 cs14 pb VDD VDD pfet_03v3 w=1.000u l=4.000u
X345 cs14 pb VDD VDD pfet_03v3 w=1.000u l=4.000u
X346 cs14 pb VDD VDD pfet_03v3 w=1.000u l=4.000u
X347 cs14 pb VDD VDD pfet_03v3 w=1.000u l=4.000u
X348 cs14 pb VDD VDD pfet_03v3 w=1.000u l=4.000u
X349 cs14 pb VDD VDD pfet_03v3 w=1.000u l=4.000u
X350 cs14 pb VDD VDD pfet_03v3 w=1.000u l=4.000u
X351 cs14 pb VDD VDD pfet_03v3 w=1.000u l=4.000u
X352 cs14 pb VDD VDD pfet_03v3 w=1.000u l=4.000u
X353 cs14 pb VDD VDD pfet_03v3 w=1.000u l=4.000u
X354 cs14 pb VDD VDD pfet_03v3 w=1.000u l=4.000u
X355 cs14 pb VDD VDD pfet_03v3 w=1.000u l=4.000u
X356 cs14 pb VDD VDD pfet_03v3 w=1.000u l=4.000u
X357 cs14 pb VDD VDD pfet_03v3 w=1.000u l=4.000u
X358 cs14 pb VDD VDD pfet_03v3 w=1.000u l=4.000u
X359 cs14 pb VDD VDD pfet_03v3 w=1.000u l=4.000u
X360 cs14 pb VDD VDD pfet_03v3 w=1.000u l=4.000u
X361 cs14 pb VDD VDD pfet_03v3 w=1.000u l=4.000u
X362 cs14 pb VDD VDD pfet_03v3 w=1.000u l=4.000u
X363 cs14 pb VDD VDD pfet_03v3 w=1.000u l=4.000u
X364 cs14 pb VDD VDD pfet_03v3 w=1.000u l=4.000u
X365 cs14 pb VDD VDD pfet_03v3 w=1.000u l=4.000u
X366 cs14 pb VDD VDD pfet_03v3 w=1.000u l=4.000u
X367 cs14 pb VDD VDD pfet_03v3 w=1.000u l=4.000u
X368 mo ns14 cs14 VDD pfet_03v3 w=1.000u l=0.280u
X369 md mo cs14 VDD pfet_03v3 w=1.000u l=0.280u
X370 cs12 pb VDD VDD pfet_03v3 w=1.000u l=4.000u
X371 cs12 pb VDD VDD pfet_03v3 w=1.000u l=4.000u
X372 cs12 pb VDD VDD pfet_03v3 w=1.000u l=4.000u
X373 cs12 pb VDD VDD pfet_03v3 w=1.000u l=4.000u
X374 cs12 pb VDD VDD pfet_03v3 w=1.000u l=4.000u
X375 cs12 pb VDD VDD pfet_03v3 w=1.000u l=4.000u
X376 cs12 pb VDD VDD pfet_03v3 w=1.000u l=4.000u
X377 cs12 pb VDD VDD pfet_03v3 w=1.000u l=4.000u
X378 cs12 pb VDD VDD pfet_03v3 w=1.000u l=4.000u
X379 cs12 pb VDD VDD pfet_03v3 w=1.000u l=4.000u
X380 cs12 pb VDD VDD pfet_03v3 w=1.000u l=4.000u
X381 cs12 pb VDD VDD pfet_03v3 w=1.000u l=4.000u
X382 cs12 pb VDD VDD pfet_03v3 w=1.000u l=4.000u
X383 cs12 pb VDD VDD pfet_03v3 w=1.000u l=4.000u
X384 cs12 pb VDD VDD pfet_03v3 w=1.000u l=4.000u
X385 cs12 pb VDD VDD pfet_03v3 w=1.000u l=4.000u
X386 cs12 pb VDD VDD pfet_03v3 w=1.000u l=4.000u
X387 cs12 pb VDD VDD pfet_03v3 w=1.000u l=4.000u
X388 cs12 pb VDD VDD pfet_03v3 w=1.000u l=4.000u
X389 cs12 pb VDD VDD pfet_03v3 w=1.000u l=4.000u
X390 cs12 pb VDD VDD pfet_03v3 w=1.000u l=4.000u
X391 cs12 pb VDD VDD pfet_03v3 w=1.000u l=4.000u
X392 cs12 pb VDD VDD pfet_03v3 w=1.000u l=4.000u
X393 cs12 pb VDD VDD pfet_03v3 w=1.000u l=4.000u
X394 cs12 pb VDD VDD pfet_03v3 w=1.000u l=4.000u
X395 cs12 pb VDD VDD pfet_03v3 w=1.000u l=4.000u
X396 cs12 pb VDD VDD pfet_03v3 w=1.000u l=4.000u
X397 cs12 pb VDD VDD pfet_03v3 w=1.000u l=4.000u
X398 cs12 pb VDD VDD pfet_03v3 w=1.000u l=4.000u
X399 cs12 pb VDD VDD pfet_03v3 w=1.000u l=4.000u
X400 cs12 pb VDD VDD pfet_03v3 w=1.000u l=4.000u
X401 cs12 pb VDD VDD pfet_03v3 w=1.000u l=4.000u
X402 mo ns12 cs12 VDD pfet_03v3 w=1.000u l=0.280u
X403 md mo cs12 VDD pfet_03v3 w=1.000u l=0.280u
X404 cs10 pb VDD VDD pfet_03v3 w=1.000u l=4.000u
X405 cs10 pb VDD VDD pfet_03v3 w=1.000u l=4.000u
X406 cs10 pb VDD VDD pfet_03v3 w=1.000u l=4.000u
X407 cs10 pb VDD VDD pfet_03v3 w=1.000u l=4.000u
X408 cs10 pb VDD VDD pfet_03v3 w=1.000u l=4.000u
X409 cs10 pb VDD VDD pfet_03v3 w=1.000u l=4.000u
X410 cs10 pb VDD VDD pfet_03v3 w=1.000u l=4.000u
X411 cs10 pb VDD VDD pfet_03v3 w=1.000u l=4.000u
X412 cs10 pb VDD VDD pfet_03v3 w=1.000u l=4.000u
X413 cs10 pb VDD VDD pfet_03v3 w=1.000u l=4.000u
X414 cs10 pb VDD VDD pfet_03v3 w=1.000u l=4.000u
X415 cs10 pb VDD VDD pfet_03v3 w=1.000u l=4.000u
X416 cs10 pb VDD VDD pfet_03v3 w=1.000u l=4.000u
X417 cs10 pb VDD VDD pfet_03v3 w=1.000u l=4.000u
X418 cs10 pb VDD VDD pfet_03v3 w=1.000u l=4.000u
X419 cs10 pb VDD VDD pfet_03v3 w=1.000u l=4.000u
X420 cs10 pb VDD VDD pfet_03v3 w=1.000u l=4.000u
X421 cs10 pb VDD VDD pfet_03v3 w=1.000u l=4.000u
X422 cs10 pb VDD VDD pfet_03v3 w=1.000u l=4.000u
X423 cs10 pb VDD VDD pfet_03v3 w=1.000u l=4.000u
X424 cs10 pb VDD VDD pfet_03v3 w=1.000u l=4.000u
X425 cs10 pb VDD VDD pfet_03v3 w=1.000u l=4.000u
X426 cs10 pb VDD VDD pfet_03v3 w=1.000u l=4.000u
X427 cs10 pb VDD VDD pfet_03v3 w=1.000u l=4.000u
X428 cs10 pb VDD VDD pfet_03v3 w=1.000u l=4.000u
X429 cs10 pb VDD VDD pfet_03v3 w=1.000u l=4.000u
X430 cs10 pb VDD VDD pfet_03v3 w=1.000u l=4.000u
X431 cs10 pb VDD VDD pfet_03v3 w=1.000u l=4.000u
X432 cs10 pb VDD VDD pfet_03v3 w=1.000u l=4.000u
X433 cs10 pb VDD VDD pfet_03v3 w=1.000u l=4.000u
X434 cs10 pb VDD VDD pfet_03v3 w=1.000u l=4.000u
X435 cs10 pb VDD VDD pfet_03v3 w=1.000u l=4.000u
X436 mo ns10 cs10 VDD pfet_03v3 w=1.000u l=0.280u
X437 md mo cs10 VDD pfet_03v3 w=1.000u l=0.280u
X438 cs8 pb VDD VDD pfet_03v3 w=1.000u l=4.000u
X439 cs8 pb VDD VDD pfet_03v3 w=1.000u l=4.000u
X440 cs8 pb VDD VDD pfet_03v3 w=1.000u l=4.000u
X441 cs8 pb VDD VDD pfet_03v3 w=1.000u l=4.000u
X442 cs8 pb VDD VDD pfet_03v3 w=1.000u l=4.000u
X443 cs8 pb VDD VDD pfet_03v3 w=1.000u l=4.000u
X444 cs8 pb VDD VDD pfet_03v3 w=1.000u l=4.000u
X445 cs8 pb VDD VDD pfet_03v3 w=1.000u l=4.000u
X446 cs8 pb VDD VDD pfet_03v3 w=1.000u l=4.000u
X447 cs8 pb VDD VDD pfet_03v3 w=1.000u l=4.000u
X448 cs8 pb VDD VDD pfet_03v3 w=1.000u l=4.000u
X449 cs8 pb VDD VDD pfet_03v3 w=1.000u l=4.000u
X450 cs8 pb VDD VDD pfet_03v3 w=1.000u l=4.000u
X451 cs8 pb VDD VDD pfet_03v3 w=1.000u l=4.000u
X452 cs8 pb VDD VDD pfet_03v3 w=1.000u l=4.000u
X453 cs8 pb VDD VDD pfet_03v3 w=1.000u l=4.000u
X454 cs8 pb VDD VDD pfet_03v3 w=1.000u l=4.000u
X455 cs8 pb VDD VDD pfet_03v3 w=1.000u l=4.000u
X456 cs8 pb VDD VDD pfet_03v3 w=1.000u l=4.000u
X457 cs8 pb VDD VDD pfet_03v3 w=1.000u l=4.000u
X458 cs8 pb VDD VDD pfet_03v3 w=1.000u l=4.000u
X459 cs8 pb VDD VDD pfet_03v3 w=1.000u l=4.000u
X460 cs8 pb VDD VDD pfet_03v3 w=1.000u l=4.000u
X461 cs8 pb VDD VDD pfet_03v3 w=1.000u l=4.000u
X462 cs8 pb VDD VDD pfet_03v3 w=1.000u l=4.000u
X463 cs8 pb VDD VDD pfet_03v3 w=1.000u l=4.000u
X464 cs8 pb VDD VDD pfet_03v3 w=1.000u l=4.000u
X465 cs8 pb VDD VDD pfet_03v3 w=1.000u l=4.000u
X466 cs8 pb VDD VDD pfet_03v3 w=1.000u l=4.000u
X467 cs8 pb VDD VDD pfet_03v3 w=1.000u l=4.000u
X468 cs8 pb VDD VDD pfet_03v3 w=1.000u l=4.000u
X469 cs8 pb VDD VDD pfet_03v3 w=1.000u l=4.000u
X470 mo ns8 cs8 VDD pfet_03v3 w=1.000u l=0.280u
X471 md mo cs8 VDD pfet_03v3 w=1.000u l=0.280u
X472 cs6 pb VDD VDD pfet_03v3 w=1.000u l=4.000u
X473 cs6 pb VDD VDD pfet_03v3 w=1.000u l=4.000u
X474 cs6 pb VDD VDD pfet_03v3 w=1.000u l=4.000u
X475 cs6 pb VDD VDD pfet_03v3 w=1.000u l=4.000u
X476 cs6 pb VDD VDD pfet_03v3 w=1.000u l=4.000u
X477 cs6 pb VDD VDD pfet_03v3 w=1.000u l=4.000u
X478 cs6 pb VDD VDD pfet_03v3 w=1.000u l=4.000u
X479 cs6 pb VDD VDD pfet_03v3 w=1.000u l=4.000u
X480 cs6 pb VDD VDD pfet_03v3 w=1.000u l=4.000u
X481 cs6 pb VDD VDD pfet_03v3 w=1.000u l=4.000u
X482 cs6 pb VDD VDD pfet_03v3 w=1.000u l=4.000u
X483 cs6 pb VDD VDD pfet_03v3 w=1.000u l=4.000u
X484 cs6 pb VDD VDD pfet_03v3 w=1.000u l=4.000u
X485 cs6 pb VDD VDD pfet_03v3 w=1.000u l=4.000u
X486 cs6 pb VDD VDD pfet_03v3 w=1.000u l=4.000u
X487 cs6 pb VDD VDD pfet_03v3 w=1.000u l=4.000u
X488 cs6 pb VDD VDD pfet_03v3 w=1.000u l=4.000u
X489 cs6 pb VDD VDD pfet_03v3 w=1.000u l=4.000u
X490 cs6 pb VDD VDD pfet_03v3 w=1.000u l=4.000u
X491 cs6 pb VDD VDD pfet_03v3 w=1.000u l=4.000u
X492 cs6 pb VDD VDD pfet_03v3 w=1.000u l=4.000u
X493 cs6 pb VDD VDD pfet_03v3 w=1.000u l=4.000u
X494 cs6 pb VDD VDD pfet_03v3 w=1.000u l=4.000u
X495 cs6 pb VDD VDD pfet_03v3 w=1.000u l=4.000u
X496 cs6 pb VDD VDD pfet_03v3 w=1.000u l=4.000u
X497 cs6 pb VDD VDD pfet_03v3 w=1.000u l=4.000u
X498 cs6 pb VDD VDD pfet_03v3 w=1.000u l=4.000u
X499 cs6 pb VDD VDD pfet_03v3 w=1.000u l=4.000u
X500 cs6 pb VDD VDD pfet_03v3 w=1.000u l=4.000u
X501 cs6 pb VDD VDD pfet_03v3 w=1.000u l=4.000u
X502 cs6 pb VDD VDD pfet_03v3 w=1.000u l=4.000u
X503 cs6 pb VDD VDD pfet_03v3 w=1.000u l=4.000u
X504 mo ns6 cs6 VDD pfet_03v3 w=1.000u l=0.280u
X505 md mo cs6 VDD pfet_03v3 w=1.000u l=0.280u
X506 cs4 pb VDD VDD pfet_03v3 w=1.000u l=4.000u
X507 cs4 pb VDD VDD pfet_03v3 w=1.000u l=4.000u
X508 cs4 pb VDD VDD pfet_03v3 w=1.000u l=4.000u
X509 cs4 pb VDD VDD pfet_03v3 w=1.000u l=4.000u
X510 cs4 pb VDD VDD pfet_03v3 w=1.000u l=4.000u
X511 cs4 pb VDD VDD pfet_03v3 w=1.000u l=4.000u
X512 cs4 pb VDD VDD pfet_03v3 w=1.000u l=4.000u
X513 cs4 pb VDD VDD pfet_03v3 w=1.000u l=4.000u
X514 cs4 pb VDD VDD pfet_03v3 w=1.000u l=4.000u
X515 cs4 pb VDD VDD pfet_03v3 w=1.000u l=4.000u
X516 cs4 pb VDD VDD pfet_03v3 w=1.000u l=4.000u
X517 cs4 pb VDD VDD pfet_03v3 w=1.000u l=4.000u
X518 cs4 pb VDD VDD pfet_03v3 w=1.000u l=4.000u
X519 cs4 pb VDD VDD pfet_03v3 w=1.000u l=4.000u
X520 cs4 pb VDD VDD pfet_03v3 w=1.000u l=4.000u
X521 cs4 pb VDD VDD pfet_03v3 w=1.000u l=4.000u
X522 cs4 pb VDD VDD pfet_03v3 w=1.000u l=4.000u
X523 cs4 pb VDD VDD pfet_03v3 w=1.000u l=4.000u
X524 cs4 pb VDD VDD pfet_03v3 w=1.000u l=4.000u
X525 cs4 pb VDD VDD pfet_03v3 w=1.000u l=4.000u
X526 cs4 pb VDD VDD pfet_03v3 w=1.000u l=4.000u
X527 cs4 pb VDD VDD pfet_03v3 w=1.000u l=4.000u
X528 cs4 pb VDD VDD pfet_03v3 w=1.000u l=4.000u
X529 cs4 pb VDD VDD pfet_03v3 w=1.000u l=4.000u
X530 cs4 pb VDD VDD pfet_03v3 w=1.000u l=4.000u
X531 cs4 pb VDD VDD pfet_03v3 w=1.000u l=4.000u
X532 cs4 pb VDD VDD pfet_03v3 w=1.000u l=4.000u
X533 cs4 pb VDD VDD pfet_03v3 w=1.000u l=4.000u
X534 cs4 pb VDD VDD pfet_03v3 w=1.000u l=4.000u
X535 cs4 pb VDD VDD pfet_03v3 w=1.000u l=4.000u
X536 cs4 pb VDD VDD pfet_03v3 w=1.000u l=4.000u
X537 cs4 pb VDD VDD pfet_03v3 w=1.000u l=4.000u
X538 mo ns4 cs4 VDD pfet_03v3 w=1.000u l=0.280u
X539 md mo cs4 VDD pfet_03v3 w=1.000u l=0.280u
X540 cs2 pb VDD VDD pfet_03v3 w=1.000u l=4.000u
X541 cs2 pb VDD VDD pfet_03v3 w=1.000u l=4.000u
X542 cs2 pb VDD VDD pfet_03v3 w=1.000u l=4.000u
X543 cs2 pb VDD VDD pfet_03v3 w=1.000u l=4.000u
X544 cs2 pb VDD VDD pfet_03v3 w=1.000u l=4.000u
X545 cs2 pb VDD VDD pfet_03v3 w=1.000u l=4.000u
X546 cs2 pb VDD VDD pfet_03v3 w=1.000u l=4.000u
X547 cs2 pb VDD VDD pfet_03v3 w=1.000u l=4.000u
X548 cs2 pb VDD VDD pfet_03v3 w=1.000u l=4.000u
X549 cs2 pb VDD VDD pfet_03v3 w=1.000u l=4.000u
X550 cs2 pb VDD VDD pfet_03v3 w=1.000u l=4.000u
X551 cs2 pb VDD VDD pfet_03v3 w=1.000u l=4.000u
X552 cs2 pb VDD VDD pfet_03v3 w=1.000u l=4.000u
X553 cs2 pb VDD VDD pfet_03v3 w=1.000u l=4.000u
X554 cs2 pb VDD VDD pfet_03v3 w=1.000u l=4.000u
X555 cs2 pb VDD VDD pfet_03v3 w=1.000u l=4.000u
X556 cs2 pb VDD VDD pfet_03v3 w=1.000u l=4.000u
X557 cs2 pb VDD VDD pfet_03v3 w=1.000u l=4.000u
X558 cs2 pb VDD VDD pfet_03v3 w=1.000u l=4.000u
X559 cs2 pb VDD VDD pfet_03v3 w=1.000u l=4.000u
X560 cs2 pb VDD VDD pfet_03v3 w=1.000u l=4.000u
X561 cs2 pb VDD VDD pfet_03v3 w=1.000u l=4.000u
X562 cs2 pb VDD VDD pfet_03v3 w=1.000u l=4.000u
X563 cs2 pb VDD VDD pfet_03v3 w=1.000u l=4.000u
X564 cs2 pb VDD VDD pfet_03v3 w=1.000u l=4.000u
X565 cs2 pb VDD VDD pfet_03v3 w=1.000u l=4.000u
X566 cs2 pb VDD VDD pfet_03v3 w=1.000u l=4.000u
X567 cs2 pb VDD VDD pfet_03v3 w=1.000u l=4.000u
X568 cs2 pb VDD VDD pfet_03v3 w=1.000u l=4.000u
X569 cs2 pb VDD VDD pfet_03v3 w=1.000u l=4.000u
X570 cs2 pb VDD VDD pfet_03v3 w=1.000u l=4.000u
X571 cs2 pb VDD VDD pfet_03v3 w=1.000u l=4.000u
X572 mo ns2 cs2 VDD pfet_03v3 w=1.000u l=0.280u
X573 md mo cs2 VDD pfet_03v3 w=1.000u l=0.280u
X574 cb4 pb VDD VDD pfet_03v3 w=1.000u l=4.000u
X575 cb4 pb VDD VDD pfet_03v3 w=1.000u l=4.000u
X576 cb4 pb VDD VDD pfet_03v3 w=1.000u l=4.000u
X577 cb4 pb VDD VDD pfet_03v3 w=1.000u l=4.000u
X578 cb4 pb VDD VDD pfet_03v3 w=1.000u l=4.000u
X579 cb4 pb VDD VDD pfet_03v3 w=1.000u l=4.000u
X580 cb4 pb VDD VDD pfet_03v3 w=1.000u l=4.000u
X581 cb4 pb VDD VDD pfet_03v3 w=1.000u l=4.000u
X582 cb4 pb VDD VDD pfet_03v3 w=1.000u l=4.000u
X583 cb4 pb VDD VDD pfet_03v3 w=1.000u l=4.000u
X584 cb4 pb VDD VDD pfet_03v3 w=1.000u l=4.000u
X585 cb4 pb VDD VDD pfet_03v3 w=1.000u l=4.000u
X586 cb4 pb VDD VDD pfet_03v3 w=1.000u l=4.000u
X587 cb4 pb VDD VDD pfet_03v3 w=1.000u l=4.000u
X588 cb4 pb VDD VDD pfet_03v3 w=1.000u l=4.000u
X589 cb4 pb VDD VDD pfet_03v3 w=1.000u l=4.000u
X590 VDD pb VDD VDD pfet_03v3 w=1.000u l=4.000u
X591 VDD pb VDD VDD pfet_03v3 w=1.000u l=4.000u
X592 VDD pb VDD VDD pfet_03v3 w=1.000u l=4.000u
X593 VDD pb VDD VDD pfet_03v3 w=1.000u l=4.000u
X594 VDD pb VDD VDD pfet_03v3 w=1.000u l=4.000u
X595 VDD pb VDD VDD pfet_03v3 w=1.000u l=4.000u
X596 VDD pb VDD VDD pfet_03v3 w=1.000u l=4.000u
X597 VDD pb VDD VDD pfet_03v3 w=1.000u l=4.000u
X598 VDD pb VDD VDD pfet_03v3 w=1.000u l=4.000u
X599 VDD pb VDD VDD pfet_03v3 w=1.000u l=4.000u
X600 VDD pb VDD VDD pfet_03v3 w=1.000u l=4.000u
X601 VDD pb VDD VDD pfet_03v3 w=1.000u l=4.000u
X602 VDD pb VDD VDD pfet_03v3 w=1.000u l=4.000u
X603 VDD pb VDD VDD pfet_03v3 w=1.000u l=4.000u
X604 VDD pb VDD VDD pfet_03v3 w=1.000u l=4.000u
X605 VDD pb VDD VDD pfet_03v3 w=1.000u l=4.000u
X606 mo nb4 cb4 VDD pfet_03v3 w=1.000u l=0.280u
X607 md mo cb4 VDD pfet_03v3 w=1.000u l=0.280u
X608 cb2 pb VDD VDD pfet_03v3 w=1.000u l=4.000u
X609 cb2 pb VDD VDD pfet_03v3 w=1.000u l=4.000u
X610 cb2 pb VDD VDD pfet_03v3 w=1.000u l=4.000u
X611 cb2 pb VDD VDD pfet_03v3 w=1.000u l=4.000u
X612 VDD pb VDD VDD pfet_03v3 w=1.000u l=4.000u
X613 VDD pb VDD VDD pfet_03v3 w=1.000u l=4.000u
X614 VDD pb VDD VDD pfet_03v3 w=1.000u l=4.000u
X615 VDD pb VDD VDD pfet_03v3 w=1.000u l=4.000u
X616 VDD pb VDD VDD pfet_03v3 w=1.000u l=4.000u
X617 VDD pb VDD VDD pfet_03v3 w=1.000u l=4.000u
X618 VDD pb VDD VDD pfet_03v3 w=1.000u l=4.000u
X619 VDD pb VDD VDD pfet_03v3 w=1.000u l=4.000u
X620 VDD pb VDD VDD pfet_03v3 w=1.000u l=4.000u
X621 VDD pb VDD VDD pfet_03v3 w=1.000u l=4.000u
X622 VDD pb VDD VDD pfet_03v3 w=1.000u l=4.000u
X623 VDD pb VDD VDD pfet_03v3 w=1.000u l=4.000u
X624 VDD pb VDD VDD pfet_03v3 w=1.000u l=4.000u
X625 VDD pb VDD VDD pfet_03v3 w=1.000u l=4.000u
X626 VDD pb VDD VDD pfet_03v3 w=1.000u l=4.000u
X627 VDD pb VDD VDD pfet_03v3 w=1.000u l=4.000u
X628 VDD pb VDD VDD pfet_03v3 w=1.000u l=4.000u
X629 VDD pb VDD VDD pfet_03v3 w=1.000u l=4.000u
X630 VDD pb VDD VDD pfet_03v3 w=1.000u l=4.000u
X631 VDD pb VDD VDD pfet_03v3 w=1.000u l=4.000u
X632 VDD pb VDD VDD pfet_03v3 w=1.000u l=4.000u
X633 VDD pb VDD VDD pfet_03v3 w=1.000u l=4.000u
X634 VDD pb VDD VDD pfet_03v3 w=1.000u l=4.000u
X635 VDD pb VDD VDD pfet_03v3 w=1.000u l=4.000u
X636 VDD pb VDD VDD pfet_03v3 w=1.000u l=4.000u
X637 VDD pb VDD VDD pfet_03v3 w=1.000u l=4.000u
X638 VDD pb VDD VDD pfet_03v3 w=1.000u l=4.000u
X639 VDD pb VDD VDD pfet_03v3 w=1.000u l=4.000u
X640 mo nb2 cb2 VDD pfet_03v3 w=1.000u l=0.280u
X641 md mo cb2 VDD pfet_03v3 w=1.000u l=0.280u
X642 cb0 pb VDD VDD pfet_03v3 w=1.000u l=4.000u
X643 VDD pb VDD VDD pfet_03v3 w=1.000u l=4.000u
X644 VDD pb VDD VDD pfet_03v3 w=1.000u l=4.000u
X645 VDD pb VDD VDD pfet_03v3 w=1.000u l=4.000u
X646 VDD pb VDD VDD pfet_03v3 w=1.000u l=4.000u
X647 VDD pb VDD VDD pfet_03v3 w=1.000u l=4.000u
X648 VDD pb VDD VDD pfet_03v3 w=1.000u l=4.000u
X649 VDD pb VDD VDD pfet_03v3 w=1.000u l=4.000u
X650 VDD pb VDD VDD pfet_03v3 w=1.000u l=4.000u
X651 VDD pb VDD VDD pfet_03v3 w=1.000u l=4.000u
X652 VDD pb VDD VDD pfet_03v3 w=1.000u l=4.000u
X653 VDD pb VDD VDD pfet_03v3 w=1.000u l=4.000u
X654 VDD pb VDD VDD pfet_03v3 w=1.000u l=4.000u
X655 VDD pb VDD VDD pfet_03v3 w=1.000u l=4.000u
X656 VDD pb VDD VDD pfet_03v3 w=1.000u l=4.000u
X657 VDD pb VDD VDD pfet_03v3 w=1.000u l=4.000u
X658 VDD pb VDD VDD pfet_03v3 w=1.000u l=4.000u
X659 VDD pb VDD VDD pfet_03v3 w=1.000u l=4.000u
X660 VDD pb VDD VDD pfet_03v3 w=1.000u l=4.000u
X661 VDD pb VDD VDD pfet_03v3 w=1.000u l=4.000u
X662 VDD pb VDD VDD pfet_03v3 w=1.000u l=4.000u
X663 VDD pb VDD VDD pfet_03v3 w=1.000u l=4.000u
X664 VDD pb VDD VDD pfet_03v3 w=1.000u l=4.000u
X665 VDD pb VDD VDD pfet_03v3 w=1.000u l=4.000u
X666 VDD pb VDD VDD pfet_03v3 w=1.000u l=4.000u
X667 VDD pb VDD VDD pfet_03v3 w=1.000u l=4.000u
X668 VDD pb VDD VDD pfet_03v3 w=1.000u l=4.000u
X669 VDD pb VDD VDD pfet_03v3 w=1.000u l=4.000u
X670 VDD pb VDD VDD pfet_03v3 w=1.000u l=4.000u
X671 VDD pb VDD VDD pfet_03v3 w=1.000u l=4.000u
X672 VDD pb VDD VDD pfet_03v3 w=1.000u l=4.000u
X673 VDD pb VDD VDD pfet_03v3 w=1.000u l=4.000u
X674 mo nb0 cb0 VDD pfet_03v3 w=1.000u l=0.280u
X675 md mo cb0 VDD pfet_03v3 w=1.000u l=0.280u
X676 csd pb VDD VDD pfet_03v3 w=1.000u l=4.000u
X677 VDD pb VDD VDD pfet_03v3 w=1.000u l=4.000u
X678 VDD pb VDD VDD pfet_03v3 w=1.000u l=4.000u
X679 VDD pb VDD VDD pfet_03v3 w=1.000u l=4.000u
X680 VDD pb VDD VDD pfet_03v3 w=1.000u l=4.000u
X681 VDD pb VDD VDD pfet_03v3 w=1.000u l=4.000u
X682 VDD pb VDD VDD pfet_03v3 w=1.000u l=4.000u
X683 VDD pb VDD VDD pfet_03v3 w=1.000u l=4.000u
X684 VDD pb VDD VDD pfet_03v3 w=1.000u l=4.000u
X685 VDD pb VDD VDD pfet_03v3 w=1.000u l=4.000u
X686 VDD pb VDD VDD pfet_03v3 w=1.000u l=4.000u
X687 VDD pb VDD VDD pfet_03v3 w=1.000u l=4.000u
X688 VDD pb VDD VDD pfet_03v3 w=1.000u l=4.000u
X689 VDD pb VDD VDD pfet_03v3 w=1.000u l=4.000u
X690 VDD pb VDD VDD pfet_03v3 w=1.000u l=4.000u
X691 VDD pb VDD VDD pfet_03v3 w=1.000u l=4.000u
X692 VDD pb VDD VDD pfet_03v3 w=1.000u l=4.000u
X693 VDD pb VDD VDD pfet_03v3 w=1.000u l=4.000u
X694 VDD pb VDD VDD pfet_03v3 w=1.000u l=4.000u
X695 VDD pb VDD VDD pfet_03v3 w=1.000u l=4.000u
X696 VDD pb VDD VDD pfet_03v3 w=1.000u l=4.000u
X697 VDD pb VDD VDD pfet_03v3 w=1.000u l=4.000u
X698 VDD pb VDD VDD pfet_03v3 w=1.000u l=4.000u
X699 VDD pb VDD VDD pfet_03v3 w=1.000u l=4.000u
X700 VDD pb VDD VDD pfet_03v3 w=1.000u l=4.000u
X701 VDD pb VDD VDD pfet_03v3 w=1.000u l=4.000u
X702 VDD pb VDD VDD pfet_03v3 w=1.000u l=4.000u
X703 VDD pb VDD VDD pfet_03v3 w=1.000u l=4.000u
X704 VDD pb VDD VDD pfet_03v3 w=1.000u l=4.000u
X705 VDD pb VDD VDD pfet_03v3 w=1.000u l=4.000u
X706 VDD pb VDD VDD pfet_03v3 w=1.000u l=4.000u
X707 VDD pb VDD VDD pfet_03v3 w=1.000u l=4.000u
X708 mo nsd csd VDD pfet_03v3 w=1.000u l=0.280u
X709 md mo csd VDD pfet_03v3 w=1.000u l=0.280u
X710 cb1 pb VDD VDD pfet_03v3 w=1.000u l=4.000u
X711 cb1 pb VDD VDD pfet_03v3 w=1.000u l=4.000u
X712 VDD pb VDD VDD pfet_03v3 w=1.000u l=4.000u
X713 VDD pb VDD VDD pfet_03v3 w=1.000u l=4.000u
X714 VDD pb VDD VDD pfet_03v3 w=1.000u l=4.000u
X715 VDD pb VDD VDD pfet_03v3 w=1.000u l=4.000u
X716 VDD pb VDD VDD pfet_03v3 w=1.000u l=4.000u
X717 VDD pb VDD VDD pfet_03v3 w=1.000u l=4.000u
X718 VDD pb VDD VDD pfet_03v3 w=1.000u l=4.000u
X719 VDD pb VDD VDD pfet_03v3 w=1.000u l=4.000u
X720 VDD pb VDD VDD pfet_03v3 w=1.000u l=4.000u
X721 VDD pb VDD VDD pfet_03v3 w=1.000u l=4.000u
X722 VDD pb VDD VDD pfet_03v3 w=1.000u l=4.000u
X723 VDD pb VDD VDD pfet_03v3 w=1.000u l=4.000u
X724 VDD pb VDD VDD pfet_03v3 w=1.000u l=4.000u
X725 VDD pb VDD VDD pfet_03v3 w=1.000u l=4.000u
X726 VDD pb VDD VDD pfet_03v3 w=1.000u l=4.000u
X727 VDD pb VDD VDD pfet_03v3 w=1.000u l=4.000u
X728 VDD pb VDD VDD pfet_03v3 w=1.000u l=4.000u
X729 VDD pb VDD VDD pfet_03v3 w=1.000u l=4.000u
X730 VDD pb VDD VDD pfet_03v3 w=1.000u l=4.000u
X731 VDD pb VDD VDD pfet_03v3 w=1.000u l=4.000u
X732 VDD pb VDD VDD pfet_03v3 w=1.000u l=4.000u
X733 VDD pb VDD VDD pfet_03v3 w=1.000u l=4.000u
X734 VDD pb VDD VDD pfet_03v3 w=1.000u l=4.000u
X735 VDD pb VDD VDD pfet_03v3 w=1.000u l=4.000u
X736 VDD pb VDD VDD pfet_03v3 w=1.000u l=4.000u
X737 VDD pb VDD VDD pfet_03v3 w=1.000u l=4.000u
X738 VDD pb VDD VDD pfet_03v3 w=1.000u l=4.000u
X739 VDD pb VDD VDD pfet_03v3 w=1.000u l=4.000u
X740 VDD pb VDD VDD pfet_03v3 w=1.000u l=4.000u
X741 VDD pb VDD VDD pfet_03v3 w=1.000u l=4.000u
X742 mo nb1 cb1 VDD pfet_03v3 w=1.000u l=0.280u
X743 md mo cb1 VDD pfet_03v3 w=1.000u l=0.280u
X744 cb3 pb VDD VDD pfet_03v3 w=1.000u l=4.000u
X745 cb3 pb VDD VDD pfet_03v3 w=1.000u l=4.000u
X746 cb3 pb VDD VDD pfet_03v3 w=1.000u l=4.000u
X747 cb3 pb VDD VDD pfet_03v3 w=1.000u l=4.000u
X748 cb3 pb VDD VDD pfet_03v3 w=1.000u l=4.000u
X749 cb3 pb VDD VDD pfet_03v3 w=1.000u l=4.000u
X750 cb3 pb VDD VDD pfet_03v3 w=1.000u l=4.000u
X751 cb3 pb VDD VDD pfet_03v3 w=1.000u l=4.000u
X752 VDD pb VDD VDD pfet_03v3 w=1.000u l=4.000u
X753 VDD pb VDD VDD pfet_03v3 w=1.000u l=4.000u
X754 VDD pb VDD VDD pfet_03v3 w=1.000u l=4.000u
X755 VDD pb VDD VDD pfet_03v3 w=1.000u l=4.000u
X756 VDD pb VDD VDD pfet_03v3 w=1.000u l=4.000u
X757 VDD pb VDD VDD pfet_03v3 w=1.000u l=4.000u
X758 VDD pb VDD VDD pfet_03v3 w=1.000u l=4.000u
X759 VDD pb VDD VDD pfet_03v3 w=1.000u l=4.000u
X760 VDD pb VDD VDD pfet_03v3 w=1.000u l=4.000u
X761 VDD pb VDD VDD pfet_03v3 w=1.000u l=4.000u
X762 VDD pb VDD VDD pfet_03v3 w=1.000u l=4.000u
X763 VDD pb VDD VDD pfet_03v3 w=1.000u l=4.000u
X764 VDD pb VDD VDD pfet_03v3 w=1.000u l=4.000u
X765 VDD pb VDD VDD pfet_03v3 w=1.000u l=4.000u
X766 VDD pb VDD VDD pfet_03v3 w=1.000u l=4.000u
X767 VDD pb VDD VDD pfet_03v3 w=1.000u l=4.000u
X768 VDD pb VDD VDD pfet_03v3 w=1.000u l=4.000u
X769 VDD pb VDD VDD pfet_03v3 w=1.000u l=4.000u
X770 VDD pb VDD VDD pfet_03v3 w=1.000u l=4.000u
X771 VDD pb VDD VDD pfet_03v3 w=1.000u l=4.000u
X772 VDD pb VDD VDD pfet_03v3 w=1.000u l=4.000u
X773 VDD pb VDD VDD pfet_03v3 w=1.000u l=4.000u
X774 VDD pb VDD VDD pfet_03v3 w=1.000u l=4.000u
X775 VDD pb VDD VDD pfet_03v3 w=1.000u l=4.000u
X776 mo nb3 cb3 VDD pfet_03v3 w=1.000u l=0.280u
X777 md mo cb3 VDD pfet_03v3 w=1.000u l=0.280u
X778 cs1 pb VDD VDD pfet_03v3 w=1.000u l=4.000u
X779 cs1 pb VDD VDD pfet_03v3 w=1.000u l=4.000u
X780 cs1 pb VDD VDD pfet_03v3 w=1.000u l=4.000u
X781 cs1 pb VDD VDD pfet_03v3 w=1.000u l=4.000u
X782 cs1 pb VDD VDD pfet_03v3 w=1.000u l=4.000u
X783 cs1 pb VDD VDD pfet_03v3 w=1.000u l=4.000u
X784 cs1 pb VDD VDD pfet_03v3 w=1.000u l=4.000u
X785 cs1 pb VDD VDD pfet_03v3 w=1.000u l=4.000u
X786 cs1 pb VDD VDD pfet_03v3 w=1.000u l=4.000u
X787 cs1 pb VDD VDD pfet_03v3 w=1.000u l=4.000u
X788 cs1 pb VDD VDD pfet_03v3 w=1.000u l=4.000u
X789 cs1 pb VDD VDD pfet_03v3 w=1.000u l=4.000u
X790 cs1 pb VDD VDD pfet_03v3 w=1.000u l=4.000u
X791 cs1 pb VDD VDD pfet_03v3 w=1.000u l=4.000u
X792 cs1 pb VDD VDD pfet_03v3 w=1.000u l=4.000u
X793 cs1 pb VDD VDD pfet_03v3 w=1.000u l=4.000u
X794 cs1 pb VDD VDD pfet_03v3 w=1.000u l=4.000u
X795 cs1 pb VDD VDD pfet_03v3 w=1.000u l=4.000u
X796 cs1 pb VDD VDD pfet_03v3 w=1.000u l=4.000u
X797 cs1 pb VDD VDD pfet_03v3 w=1.000u l=4.000u
X798 cs1 pb VDD VDD pfet_03v3 w=1.000u l=4.000u
X799 cs1 pb VDD VDD pfet_03v3 w=1.000u l=4.000u
X800 cs1 pb VDD VDD pfet_03v3 w=1.000u l=4.000u
X801 cs1 pb VDD VDD pfet_03v3 w=1.000u l=4.000u
X802 cs1 pb VDD VDD pfet_03v3 w=1.000u l=4.000u
X803 cs1 pb VDD VDD pfet_03v3 w=1.000u l=4.000u
X804 cs1 pb VDD VDD pfet_03v3 w=1.000u l=4.000u
X805 cs1 pb VDD VDD pfet_03v3 w=1.000u l=4.000u
X806 cs1 pb VDD VDD pfet_03v3 w=1.000u l=4.000u
X807 cs1 pb VDD VDD pfet_03v3 w=1.000u l=4.000u
X808 cs1 pb VDD VDD pfet_03v3 w=1.000u l=4.000u
X809 cs1 pb VDD VDD pfet_03v3 w=1.000u l=4.000u
X810 mo ns1 cs1 VDD pfet_03v3 w=1.000u l=0.280u
X811 md mo cs1 VDD pfet_03v3 w=1.000u l=0.280u
X812 cs3 pb VDD VDD pfet_03v3 w=1.000u l=4.000u
X813 cs3 pb VDD VDD pfet_03v3 w=1.000u l=4.000u
X814 cs3 pb VDD VDD pfet_03v3 w=1.000u l=4.000u
X815 cs3 pb VDD VDD pfet_03v3 w=1.000u l=4.000u
X816 cs3 pb VDD VDD pfet_03v3 w=1.000u l=4.000u
X817 cs3 pb VDD VDD pfet_03v3 w=1.000u l=4.000u
X818 cs3 pb VDD VDD pfet_03v3 w=1.000u l=4.000u
X819 cs3 pb VDD VDD pfet_03v3 w=1.000u l=4.000u
X820 cs3 pb VDD VDD pfet_03v3 w=1.000u l=4.000u
X821 cs3 pb VDD VDD pfet_03v3 w=1.000u l=4.000u
X822 cs3 pb VDD VDD pfet_03v3 w=1.000u l=4.000u
X823 cs3 pb VDD VDD pfet_03v3 w=1.000u l=4.000u
X824 cs3 pb VDD VDD pfet_03v3 w=1.000u l=4.000u
X825 cs3 pb VDD VDD pfet_03v3 w=1.000u l=4.000u
X826 cs3 pb VDD VDD pfet_03v3 w=1.000u l=4.000u
X827 cs3 pb VDD VDD pfet_03v3 w=1.000u l=4.000u
X828 cs3 pb VDD VDD pfet_03v3 w=1.000u l=4.000u
X829 cs3 pb VDD VDD pfet_03v3 w=1.000u l=4.000u
X830 cs3 pb VDD VDD pfet_03v3 w=1.000u l=4.000u
X831 cs3 pb VDD VDD pfet_03v3 w=1.000u l=4.000u
X832 cs3 pb VDD VDD pfet_03v3 w=1.000u l=4.000u
X833 cs3 pb VDD VDD pfet_03v3 w=1.000u l=4.000u
X834 cs3 pb VDD VDD pfet_03v3 w=1.000u l=4.000u
X835 cs3 pb VDD VDD pfet_03v3 w=1.000u l=4.000u
X836 cs3 pb VDD VDD pfet_03v3 w=1.000u l=4.000u
X837 cs3 pb VDD VDD pfet_03v3 w=1.000u l=4.000u
X838 cs3 pb VDD VDD pfet_03v3 w=1.000u l=4.000u
X839 cs3 pb VDD VDD pfet_03v3 w=1.000u l=4.000u
X840 cs3 pb VDD VDD pfet_03v3 w=1.000u l=4.000u
X841 cs3 pb VDD VDD pfet_03v3 w=1.000u l=4.000u
X842 cs3 pb VDD VDD pfet_03v3 w=1.000u l=4.000u
X843 cs3 pb VDD VDD pfet_03v3 w=1.000u l=4.000u
X844 mo ns3 cs3 VDD pfet_03v3 w=1.000u l=0.280u
X845 md mo cs3 VDD pfet_03v3 w=1.000u l=0.280u
X846 cs5 pb VDD VDD pfet_03v3 w=1.000u l=4.000u
X847 cs5 pb VDD VDD pfet_03v3 w=1.000u l=4.000u
X848 cs5 pb VDD VDD pfet_03v3 w=1.000u l=4.000u
X849 cs5 pb VDD VDD pfet_03v3 w=1.000u l=4.000u
X850 cs5 pb VDD VDD pfet_03v3 w=1.000u l=4.000u
X851 cs5 pb VDD VDD pfet_03v3 w=1.000u l=4.000u
X852 cs5 pb VDD VDD pfet_03v3 w=1.000u l=4.000u
X853 cs5 pb VDD VDD pfet_03v3 w=1.000u l=4.000u
X854 cs5 pb VDD VDD pfet_03v3 w=1.000u l=4.000u
X855 cs5 pb VDD VDD pfet_03v3 w=1.000u l=4.000u
X856 cs5 pb VDD VDD pfet_03v3 w=1.000u l=4.000u
X857 cs5 pb VDD VDD pfet_03v3 w=1.000u l=4.000u
X858 cs5 pb VDD VDD pfet_03v3 w=1.000u l=4.000u
X859 cs5 pb VDD VDD pfet_03v3 w=1.000u l=4.000u
X860 cs5 pb VDD VDD pfet_03v3 w=1.000u l=4.000u
X861 cs5 pb VDD VDD pfet_03v3 w=1.000u l=4.000u
X862 cs5 pb VDD VDD pfet_03v3 w=1.000u l=4.000u
X863 cs5 pb VDD VDD pfet_03v3 w=1.000u l=4.000u
X864 cs5 pb VDD VDD pfet_03v3 w=1.000u l=4.000u
X865 cs5 pb VDD VDD pfet_03v3 w=1.000u l=4.000u
X866 cs5 pb VDD VDD pfet_03v3 w=1.000u l=4.000u
X867 cs5 pb VDD VDD pfet_03v3 w=1.000u l=4.000u
X868 cs5 pb VDD VDD pfet_03v3 w=1.000u l=4.000u
X869 cs5 pb VDD VDD pfet_03v3 w=1.000u l=4.000u
X870 cs5 pb VDD VDD pfet_03v3 w=1.000u l=4.000u
X871 cs5 pb VDD VDD pfet_03v3 w=1.000u l=4.000u
X872 cs5 pb VDD VDD pfet_03v3 w=1.000u l=4.000u
X873 cs5 pb VDD VDD pfet_03v3 w=1.000u l=4.000u
X874 cs5 pb VDD VDD pfet_03v3 w=1.000u l=4.000u
X875 cs5 pb VDD VDD pfet_03v3 w=1.000u l=4.000u
X876 cs5 pb VDD VDD pfet_03v3 w=1.000u l=4.000u
X877 cs5 pb VDD VDD pfet_03v3 w=1.000u l=4.000u
X878 mo ns5 cs5 VDD pfet_03v3 w=1.000u l=0.280u
X879 md mo cs5 VDD pfet_03v3 w=1.000u l=0.280u
X880 cs7 pb VDD VDD pfet_03v3 w=1.000u l=4.000u
X881 cs7 pb VDD VDD pfet_03v3 w=1.000u l=4.000u
X882 cs7 pb VDD VDD pfet_03v3 w=1.000u l=4.000u
X883 cs7 pb VDD VDD pfet_03v3 w=1.000u l=4.000u
X884 cs7 pb VDD VDD pfet_03v3 w=1.000u l=4.000u
X885 cs7 pb VDD VDD pfet_03v3 w=1.000u l=4.000u
X886 cs7 pb VDD VDD pfet_03v3 w=1.000u l=4.000u
X887 cs7 pb VDD VDD pfet_03v3 w=1.000u l=4.000u
X888 cs7 pb VDD VDD pfet_03v3 w=1.000u l=4.000u
X889 cs7 pb VDD VDD pfet_03v3 w=1.000u l=4.000u
X890 cs7 pb VDD VDD pfet_03v3 w=1.000u l=4.000u
X891 cs7 pb VDD VDD pfet_03v3 w=1.000u l=4.000u
X892 cs7 pb VDD VDD pfet_03v3 w=1.000u l=4.000u
X893 cs7 pb VDD VDD pfet_03v3 w=1.000u l=4.000u
X894 cs7 pb VDD VDD pfet_03v3 w=1.000u l=4.000u
X895 cs7 pb VDD VDD pfet_03v3 w=1.000u l=4.000u
X896 cs7 pb VDD VDD pfet_03v3 w=1.000u l=4.000u
X897 cs7 pb VDD VDD pfet_03v3 w=1.000u l=4.000u
X898 cs7 pb VDD VDD pfet_03v3 w=1.000u l=4.000u
X899 cs7 pb VDD VDD pfet_03v3 w=1.000u l=4.000u
X900 cs7 pb VDD VDD pfet_03v3 w=1.000u l=4.000u
X901 cs7 pb VDD VDD pfet_03v3 w=1.000u l=4.000u
X902 cs7 pb VDD VDD pfet_03v3 w=1.000u l=4.000u
X903 cs7 pb VDD VDD pfet_03v3 w=1.000u l=4.000u
X904 cs7 pb VDD VDD pfet_03v3 w=1.000u l=4.000u
X905 cs7 pb VDD VDD pfet_03v3 w=1.000u l=4.000u
X906 cs7 pb VDD VDD pfet_03v3 w=1.000u l=4.000u
X907 cs7 pb VDD VDD pfet_03v3 w=1.000u l=4.000u
X908 cs7 pb VDD VDD pfet_03v3 w=1.000u l=4.000u
X909 cs7 pb VDD VDD pfet_03v3 w=1.000u l=4.000u
X910 cs7 pb VDD VDD pfet_03v3 w=1.000u l=4.000u
X911 cs7 pb VDD VDD pfet_03v3 w=1.000u l=4.000u
X912 mo ns7 cs7 VDD pfet_03v3 w=1.000u l=0.280u
X913 md mo cs7 VDD pfet_03v3 w=1.000u l=0.280u
X914 cs9 pb VDD VDD pfet_03v3 w=1.000u l=4.000u
X915 cs9 pb VDD VDD pfet_03v3 w=1.000u l=4.000u
X916 cs9 pb VDD VDD pfet_03v3 w=1.000u l=4.000u
X917 cs9 pb VDD VDD pfet_03v3 w=1.000u l=4.000u
X918 cs9 pb VDD VDD pfet_03v3 w=1.000u l=4.000u
X919 cs9 pb VDD VDD pfet_03v3 w=1.000u l=4.000u
X920 cs9 pb VDD VDD pfet_03v3 w=1.000u l=4.000u
X921 cs9 pb VDD VDD pfet_03v3 w=1.000u l=4.000u
X922 cs9 pb VDD VDD pfet_03v3 w=1.000u l=4.000u
X923 cs9 pb VDD VDD pfet_03v3 w=1.000u l=4.000u
X924 cs9 pb VDD VDD pfet_03v3 w=1.000u l=4.000u
X925 cs9 pb VDD VDD pfet_03v3 w=1.000u l=4.000u
X926 cs9 pb VDD VDD pfet_03v3 w=1.000u l=4.000u
X927 cs9 pb VDD VDD pfet_03v3 w=1.000u l=4.000u
X928 cs9 pb VDD VDD pfet_03v3 w=1.000u l=4.000u
X929 cs9 pb VDD VDD pfet_03v3 w=1.000u l=4.000u
X930 cs9 pb VDD VDD pfet_03v3 w=1.000u l=4.000u
X931 cs9 pb VDD VDD pfet_03v3 w=1.000u l=4.000u
X932 cs9 pb VDD VDD pfet_03v3 w=1.000u l=4.000u
X933 cs9 pb VDD VDD pfet_03v3 w=1.000u l=4.000u
X934 cs9 pb VDD VDD pfet_03v3 w=1.000u l=4.000u
X935 cs9 pb VDD VDD pfet_03v3 w=1.000u l=4.000u
X936 cs9 pb VDD VDD pfet_03v3 w=1.000u l=4.000u
X937 cs9 pb VDD VDD pfet_03v3 w=1.000u l=4.000u
X938 cs9 pb VDD VDD pfet_03v3 w=1.000u l=4.000u
X939 cs9 pb VDD VDD pfet_03v3 w=1.000u l=4.000u
X940 cs9 pb VDD VDD pfet_03v3 w=1.000u l=4.000u
X941 cs9 pb VDD VDD pfet_03v3 w=1.000u l=4.000u
X942 cs9 pb VDD VDD pfet_03v3 w=1.000u l=4.000u
X943 cs9 pb VDD VDD pfet_03v3 w=1.000u l=4.000u
X944 cs9 pb VDD VDD pfet_03v3 w=1.000u l=4.000u
X945 cs9 pb VDD VDD pfet_03v3 w=1.000u l=4.000u
X946 mo ns9 cs9 VDD pfet_03v3 w=1.000u l=0.280u
X947 md mo cs9 VDD pfet_03v3 w=1.000u l=0.280u
X948 cs11 pb VDD VDD pfet_03v3 w=1.000u l=4.000u
X949 cs11 pb VDD VDD pfet_03v3 w=1.000u l=4.000u
X950 cs11 pb VDD VDD pfet_03v3 w=1.000u l=4.000u
X951 cs11 pb VDD VDD pfet_03v3 w=1.000u l=4.000u
X952 cs11 pb VDD VDD pfet_03v3 w=1.000u l=4.000u
X953 cs11 pb VDD VDD pfet_03v3 w=1.000u l=4.000u
X954 cs11 pb VDD VDD pfet_03v3 w=1.000u l=4.000u
X955 cs11 pb VDD VDD pfet_03v3 w=1.000u l=4.000u
X956 cs11 pb VDD VDD pfet_03v3 w=1.000u l=4.000u
X957 cs11 pb VDD VDD pfet_03v3 w=1.000u l=4.000u
X958 cs11 pb VDD VDD pfet_03v3 w=1.000u l=4.000u
X959 cs11 pb VDD VDD pfet_03v3 w=1.000u l=4.000u
X960 cs11 pb VDD VDD pfet_03v3 w=1.000u l=4.000u
X961 cs11 pb VDD VDD pfet_03v3 w=1.000u l=4.000u
X962 cs11 pb VDD VDD pfet_03v3 w=1.000u l=4.000u
X963 cs11 pb VDD VDD pfet_03v3 w=1.000u l=4.000u
X964 cs11 pb VDD VDD pfet_03v3 w=1.000u l=4.000u
X965 cs11 pb VDD VDD pfet_03v3 w=1.000u l=4.000u
X966 cs11 pb VDD VDD pfet_03v3 w=1.000u l=4.000u
X967 cs11 pb VDD VDD pfet_03v3 w=1.000u l=4.000u
X968 cs11 pb VDD VDD pfet_03v3 w=1.000u l=4.000u
X969 cs11 pb VDD VDD pfet_03v3 w=1.000u l=4.000u
X970 cs11 pb VDD VDD pfet_03v3 w=1.000u l=4.000u
X971 cs11 pb VDD VDD pfet_03v3 w=1.000u l=4.000u
X972 cs11 pb VDD VDD pfet_03v3 w=1.000u l=4.000u
X973 cs11 pb VDD VDD pfet_03v3 w=1.000u l=4.000u
X974 cs11 pb VDD VDD pfet_03v3 w=1.000u l=4.000u
X975 cs11 pb VDD VDD pfet_03v3 w=1.000u l=4.000u
X976 cs11 pb VDD VDD pfet_03v3 w=1.000u l=4.000u
X977 cs11 pb VDD VDD pfet_03v3 w=1.000u l=4.000u
X978 cs11 pb VDD VDD pfet_03v3 w=1.000u l=4.000u
X979 cs11 pb VDD VDD pfet_03v3 w=1.000u l=4.000u
X980 mo ns11 cs11 VDD pfet_03v3 w=1.000u l=0.280u
X981 md mo cs11 VDD pfet_03v3 w=1.000u l=0.280u
X982 cs13 pb VDD VDD pfet_03v3 w=1.000u l=4.000u
X983 cs13 pb VDD VDD pfet_03v3 w=1.000u l=4.000u
X984 cs13 pb VDD VDD pfet_03v3 w=1.000u l=4.000u
X985 cs13 pb VDD VDD pfet_03v3 w=1.000u l=4.000u
X986 cs13 pb VDD VDD pfet_03v3 w=1.000u l=4.000u
X987 cs13 pb VDD VDD pfet_03v3 w=1.000u l=4.000u
X988 cs13 pb VDD VDD pfet_03v3 w=1.000u l=4.000u
X989 cs13 pb VDD VDD pfet_03v3 w=1.000u l=4.000u
X990 cs13 pb VDD VDD pfet_03v3 w=1.000u l=4.000u
X991 cs13 pb VDD VDD pfet_03v3 w=1.000u l=4.000u
X992 cs13 pb VDD VDD pfet_03v3 w=1.000u l=4.000u
X993 cs13 pb VDD VDD pfet_03v3 w=1.000u l=4.000u
X994 cs13 pb VDD VDD pfet_03v3 w=1.000u l=4.000u
X995 cs13 pb VDD VDD pfet_03v3 w=1.000u l=4.000u
X996 cs13 pb VDD VDD pfet_03v3 w=1.000u l=4.000u
X997 cs13 pb VDD VDD pfet_03v3 w=1.000u l=4.000u
X998 cs13 pb VDD VDD pfet_03v3 w=1.000u l=4.000u
X999 cs13 pb VDD VDD pfet_03v3 w=1.000u l=4.000u
X1000 cs13 pb VDD VDD pfet_03v3 w=1.000u l=4.000u
X1001 cs13 pb VDD VDD pfet_03v3 w=1.000u l=4.000u
X1002 cs13 pb VDD VDD pfet_03v3 w=1.000u l=4.000u
X1003 cs13 pb VDD VDD pfet_03v3 w=1.000u l=4.000u
X1004 cs13 pb VDD VDD pfet_03v3 w=1.000u l=4.000u
X1005 cs13 pb VDD VDD pfet_03v3 w=1.000u l=4.000u
X1006 cs13 pb VDD VDD pfet_03v3 w=1.000u l=4.000u
X1007 cs13 pb VDD VDD pfet_03v3 w=1.000u l=4.000u
X1008 cs13 pb VDD VDD pfet_03v3 w=1.000u l=4.000u
X1009 cs13 pb VDD VDD pfet_03v3 w=1.000u l=4.000u
X1010 cs13 pb VDD VDD pfet_03v3 w=1.000u l=4.000u
X1011 cs13 pb VDD VDD pfet_03v3 w=1.000u l=4.000u
X1012 cs13 pb VDD VDD pfet_03v3 w=1.000u l=4.000u
X1013 cs13 pb VDD VDD pfet_03v3 w=1.000u l=4.000u
X1014 mo ns13 cs13 VDD pfet_03v3 w=1.000u l=0.280u
X1015 md mo cs13 VDD pfet_03v3 w=1.000u l=0.280u
X1016 cs15 pb VDD VDD pfet_03v3 w=1.000u l=4.000u
X1017 cs15 pb VDD VDD pfet_03v3 w=1.000u l=4.000u
X1018 cs15 pb VDD VDD pfet_03v3 w=1.000u l=4.000u
X1019 cs15 pb VDD VDD pfet_03v3 w=1.000u l=4.000u
X1020 cs15 pb VDD VDD pfet_03v3 w=1.000u l=4.000u
X1021 cs15 pb VDD VDD pfet_03v3 w=1.000u l=4.000u
X1022 cs15 pb VDD VDD pfet_03v3 w=1.000u l=4.000u
X1023 cs15 pb VDD VDD pfet_03v3 w=1.000u l=4.000u
X1024 cs15 pb VDD VDD pfet_03v3 w=1.000u l=4.000u
X1025 cs15 pb VDD VDD pfet_03v3 w=1.000u l=4.000u
X1026 cs15 pb VDD VDD pfet_03v3 w=1.000u l=4.000u
X1027 cs15 pb VDD VDD pfet_03v3 w=1.000u l=4.000u
X1028 cs15 pb VDD VDD pfet_03v3 w=1.000u l=4.000u
X1029 cs15 pb VDD VDD pfet_03v3 w=1.000u l=4.000u
X1030 cs15 pb VDD VDD pfet_03v3 w=1.000u l=4.000u
X1031 cs15 pb VDD VDD pfet_03v3 w=1.000u l=4.000u
X1032 cs15 pb VDD VDD pfet_03v3 w=1.000u l=4.000u
X1033 cs15 pb VDD VDD pfet_03v3 w=1.000u l=4.000u
X1034 cs15 pb VDD VDD pfet_03v3 w=1.000u l=4.000u
X1035 cs15 pb VDD VDD pfet_03v3 w=1.000u l=4.000u
X1036 cs15 pb VDD VDD pfet_03v3 w=1.000u l=4.000u
X1037 cs15 pb VDD VDD pfet_03v3 w=1.000u l=4.000u
X1038 cs15 pb VDD VDD pfet_03v3 w=1.000u l=4.000u
X1039 cs15 pb VDD VDD pfet_03v3 w=1.000u l=4.000u
X1040 cs15 pb VDD VDD pfet_03v3 w=1.000u l=4.000u
X1041 cs15 pb VDD VDD pfet_03v3 w=1.000u l=4.000u
X1042 cs15 pb VDD VDD pfet_03v3 w=1.000u l=4.000u
X1043 cs15 pb VDD VDD pfet_03v3 w=1.000u l=4.000u
X1044 cs15 pb VDD VDD pfet_03v3 w=1.000u l=4.000u
X1045 cs15 pb VDD VDD pfet_03v3 w=1.000u l=4.000u
X1046 cs15 pb VDD VDD pfet_03v3 w=1.000u l=4.000u
X1047 cs15 pb VDD VDD pfet_03v3 w=1.000u l=4.000u
X1048 mo ns15 cs15 VDD pfet_03v3 w=1.000u l=0.280u
X1049 md mo cs15 VDD pfet_03v3 w=1.000u l=0.280u
X1050 cs17 pb VDD VDD pfet_03v3 w=1.000u l=4.000u
X1051 cs17 pb VDD VDD pfet_03v3 w=1.000u l=4.000u
X1052 cs17 pb VDD VDD pfet_03v3 w=1.000u l=4.000u
X1053 cs17 pb VDD VDD pfet_03v3 w=1.000u l=4.000u
X1054 cs17 pb VDD VDD pfet_03v3 w=1.000u l=4.000u
X1055 cs17 pb VDD VDD pfet_03v3 w=1.000u l=4.000u
X1056 cs17 pb VDD VDD pfet_03v3 w=1.000u l=4.000u
X1057 cs17 pb VDD VDD pfet_03v3 w=1.000u l=4.000u
X1058 cs17 pb VDD VDD pfet_03v3 w=1.000u l=4.000u
X1059 cs17 pb VDD VDD pfet_03v3 w=1.000u l=4.000u
X1060 cs17 pb VDD VDD pfet_03v3 w=1.000u l=4.000u
X1061 cs17 pb VDD VDD pfet_03v3 w=1.000u l=4.000u
X1062 cs17 pb VDD VDD pfet_03v3 w=1.000u l=4.000u
X1063 cs17 pb VDD VDD pfet_03v3 w=1.000u l=4.000u
X1064 cs17 pb VDD VDD pfet_03v3 w=1.000u l=4.000u
X1065 cs17 pb VDD VDD pfet_03v3 w=1.000u l=4.000u
X1066 cs17 pb VDD VDD pfet_03v3 w=1.000u l=4.000u
X1067 cs17 pb VDD VDD pfet_03v3 w=1.000u l=4.000u
X1068 cs17 pb VDD VDD pfet_03v3 w=1.000u l=4.000u
X1069 cs17 pb VDD VDD pfet_03v3 w=1.000u l=4.000u
X1070 cs17 pb VDD VDD pfet_03v3 w=1.000u l=4.000u
X1071 cs17 pb VDD VDD pfet_03v3 w=1.000u l=4.000u
X1072 cs17 pb VDD VDD pfet_03v3 w=1.000u l=4.000u
X1073 cs17 pb VDD VDD pfet_03v3 w=1.000u l=4.000u
X1074 cs17 pb VDD VDD pfet_03v3 w=1.000u l=4.000u
X1075 cs17 pb VDD VDD pfet_03v3 w=1.000u l=4.000u
X1076 cs17 pb VDD VDD pfet_03v3 w=1.000u l=4.000u
X1077 cs17 pb VDD VDD pfet_03v3 w=1.000u l=4.000u
X1078 cs17 pb VDD VDD pfet_03v3 w=1.000u l=4.000u
X1079 cs17 pb VDD VDD pfet_03v3 w=1.000u l=4.000u
X1080 cs17 pb VDD VDD pfet_03v3 w=1.000u l=4.000u
X1081 cs17 pb VDD VDD pfet_03v3 w=1.000u l=4.000u
X1082 mo ns17 cs17 VDD pfet_03v3 w=1.000u l=0.280u
X1083 md mo cs17 VDD pfet_03v3 w=1.000u l=0.280u
X1084 cs19 pb VDD VDD pfet_03v3 w=1.000u l=4.000u
X1085 cs19 pb VDD VDD pfet_03v3 w=1.000u l=4.000u
X1086 cs19 pb VDD VDD pfet_03v3 w=1.000u l=4.000u
X1087 cs19 pb VDD VDD pfet_03v3 w=1.000u l=4.000u
X1088 cs19 pb VDD VDD pfet_03v3 w=1.000u l=4.000u
X1089 cs19 pb VDD VDD pfet_03v3 w=1.000u l=4.000u
X1090 cs19 pb VDD VDD pfet_03v3 w=1.000u l=4.000u
X1091 cs19 pb VDD VDD pfet_03v3 w=1.000u l=4.000u
X1092 cs19 pb VDD VDD pfet_03v3 w=1.000u l=4.000u
X1093 cs19 pb VDD VDD pfet_03v3 w=1.000u l=4.000u
X1094 cs19 pb VDD VDD pfet_03v3 w=1.000u l=4.000u
X1095 cs19 pb VDD VDD pfet_03v3 w=1.000u l=4.000u
X1096 cs19 pb VDD VDD pfet_03v3 w=1.000u l=4.000u
X1097 cs19 pb VDD VDD pfet_03v3 w=1.000u l=4.000u
X1098 cs19 pb VDD VDD pfet_03v3 w=1.000u l=4.000u
X1099 cs19 pb VDD VDD pfet_03v3 w=1.000u l=4.000u
X1100 cs19 pb VDD VDD pfet_03v3 w=1.000u l=4.000u
X1101 cs19 pb VDD VDD pfet_03v3 w=1.000u l=4.000u
X1102 cs19 pb VDD VDD pfet_03v3 w=1.000u l=4.000u
X1103 cs19 pb VDD VDD pfet_03v3 w=1.000u l=4.000u
X1104 cs19 pb VDD VDD pfet_03v3 w=1.000u l=4.000u
X1105 cs19 pb VDD VDD pfet_03v3 w=1.000u l=4.000u
X1106 cs19 pb VDD VDD pfet_03v3 w=1.000u l=4.000u
X1107 cs19 pb VDD VDD pfet_03v3 w=1.000u l=4.000u
X1108 cs19 pb VDD VDD pfet_03v3 w=1.000u l=4.000u
X1109 cs19 pb VDD VDD pfet_03v3 w=1.000u l=4.000u
X1110 cs19 pb VDD VDD pfet_03v3 w=1.000u l=4.000u
X1111 cs19 pb VDD VDD pfet_03v3 w=1.000u l=4.000u
X1112 cs19 pb VDD VDD pfet_03v3 w=1.000u l=4.000u
X1113 cs19 pb VDD VDD pfet_03v3 w=1.000u l=4.000u
X1114 cs19 pb VDD VDD pfet_03v3 w=1.000u l=4.000u
X1115 cs19 pb VDD VDD pfet_03v3 w=1.000u l=4.000u
X1116 mo ns19 cs19 VDD pfet_03v3 w=1.000u l=0.280u
X1117 md mo cs19 VDD pfet_03v3 w=1.000u l=0.280u
X1118 cs21 pb VDD VDD pfet_03v3 w=1.000u l=4.000u
X1119 cs21 pb VDD VDD pfet_03v3 w=1.000u l=4.000u
X1120 cs21 pb VDD VDD pfet_03v3 w=1.000u l=4.000u
X1121 cs21 pb VDD VDD pfet_03v3 w=1.000u l=4.000u
X1122 cs21 pb VDD VDD pfet_03v3 w=1.000u l=4.000u
X1123 cs21 pb VDD VDD pfet_03v3 w=1.000u l=4.000u
X1124 cs21 pb VDD VDD pfet_03v3 w=1.000u l=4.000u
X1125 cs21 pb VDD VDD pfet_03v3 w=1.000u l=4.000u
X1126 cs21 pb VDD VDD pfet_03v3 w=1.000u l=4.000u
X1127 cs21 pb VDD VDD pfet_03v3 w=1.000u l=4.000u
X1128 cs21 pb VDD VDD pfet_03v3 w=1.000u l=4.000u
X1129 cs21 pb VDD VDD pfet_03v3 w=1.000u l=4.000u
X1130 cs21 pb VDD VDD pfet_03v3 w=1.000u l=4.000u
X1131 cs21 pb VDD VDD pfet_03v3 w=1.000u l=4.000u
X1132 cs21 pb VDD VDD pfet_03v3 w=1.000u l=4.000u
X1133 cs21 pb VDD VDD pfet_03v3 w=1.000u l=4.000u
X1134 cs21 pb VDD VDD pfet_03v3 w=1.000u l=4.000u
X1135 cs21 pb VDD VDD pfet_03v3 w=1.000u l=4.000u
X1136 cs21 pb VDD VDD pfet_03v3 w=1.000u l=4.000u
X1137 cs21 pb VDD VDD pfet_03v3 w=1.000u l=4.000u
X1138 cs21 pb VDD VDD pfet_03v3 w=1.000u l=4.000u
X1139 cs21 pb VDD VDD pfet_03v3 w=1.000u l=4.000u
X1140 cs21 pb VDD VDD pfet_03v3 w=1.000u l=4.000u
X1141 cs21 pb VDD VDD pfet_03v3 w=1.000u l=4.000u
X1142 cs21 pb VDD VDD pfet_03v3 w=1.000u l=4.000u
X1143 cs21 pb VDD VDD pfet_03v3 w=1.000u l=4.000u
X1144 cs21 pb VDD VDD pfet_03v3 w=1.000u l=4.000u
X1145 cs21 pb VDD VDD pfet_03v3 w=1.000u l=4.000u
X1146 cs21 pb VDD VDD pfet_03v3 w=1.000u l=4.000u
X1147 cs21 pb VDD VDD pfet_03v3 w=1.000u l=4.000u
X1148 cs21 pb VDD VDD pfet_03v3 w=1.000u l=4.000u
X1149 cs21 pb VDD VDD pfet_03v3 w=1.000u l=4.000u
X1150 mo ns21 cs21 VDD pfet_03v3 w=1.000u l=0.280u
X1151 md mo cs21 VDD pfet_03v3 w=1.000u l=0.280u
X1152 cs23 pb VDD VDD pfet_03v3 w=1.000u l=4.000u
X1153 cs23 pb VDD VDD pfet_03v3 w=1.000u l=4.000u
X1154 cs23 pb VDD VDD pfet_03v3 w=1.000u l=4.000u
X1155 cs23 pb VDD VDD pfet_03v3 w=1.000u l=4.000u
X1156 cs23 pb VDD VDD pfet_03v3 w=1.000u l=4.000u
X1157 cs23 pb VDD VDD pfet_03v3 w=1.000u l=4.000u
X1158 cs23 pb VDD VDD pfet_03v3 w=1.000u l=4.000u
X1159 cs23 pb VDD VDD pfet_03v3 w=1.000u l=4.000u
X1160 cs23 pb VDD VDD pfet_03v3 w=1.000u l=4.000u
X1161 cs23 pb VDD VDD pfet_03v3 w=1.000u l=4.000u
X1162 cs23 pb VDD VDD pfet_03v3 w=1.000u l=4.000u
X1163 cs23 pb VDD VDD pfet_03v3 w=1.000u l=4.000u
X1164 cs23 pb VDD VDD pfet_03v3 w=1.000u l=4.000u
X1165 cs23 pb VDD VDD pfet_03v3 w=1.000u l=4.000u
X1166 cs23 pb VDD VDD pfet_03v3 w=1.000u l=4.000u
X1167 cs23 pb VDD VDD pfet_03v3 w=1.000u l=4.000u
X1168 cs23 pb VDD VDD pfet_03v3 w=1.000u l=4.000u
X1169 cs23 pb VDD VDD pfet_03v3 w=1.000u l=4.000u
X1170 cs23 pb VDD VDD pfet_03v3 w=1.000u l=4.000u
X1171 cs23 pb VDD VDD pfet_03v3 w=1.000u l=4.000u
X1172 cs23 pb VDD VDD pfet_03v3 w=1.000u l=4.000u
X1173 cs23 pb VDD VDD pfet_03v3 w=1.000u l=4.000u
X1174 cs23 pb VDD VDD pfet_03v3 w=1.000u l=4.000u
X1175 cs23 pb VDD VDD pfet_03v3 w=1.000u l=4.000u
X1176 cs23 pb VDD VDD pfet_03v3 w=1.000u l=4.000u
X1177 cs23 pb VDD VDD pfet_03v3 w=1.000u l=4.000u
X1178 cs23 pb VDD VDD pfet_03v3 w=1.000u l=4.000u
X1179 cs23 pb VDD VDD pfet_03v3 w=1.000u l=4.000u
X1180 cs23 pb VDD VDD pfet_03v3 w=1.000u l=4.000u
X1181 cs23 pb VDD VDD pfet_03v3 w=1.000u l=4.000u
X1182 cs23 pb VDD VDD pfet_03v3 w=1.000u l=4.000u
X1183 cs23 pb VDD VDD pfet_03v3 w=1.000u l=4.000u
X1184 mo ns23 cs23 VDD pfet_03v3 w=1.000u l=0.280u
X1185 md mo cs23 VDD pfet_03v3 w=1.000u l=0.280u
X1186 cs25 pb VDD VDD pfet_03v3 w=1.000u l=4.000u
X1187 cs25 pb VDD VDD pfet_03v3 w=1.000u l=4.000u
X1188 cs25 pb VDD VDD pfet_03v3 w=1.000u l=4.000u
X1189 cs25 pb VDD VDD pfet_03v3 w=1.000u l=4.000u
X1190 cs25 pb VDD VDD pfet_03v3 w=1.000u l=4.000u
X1191 cs25 pb VDD VDD pfet_03v3 w=1.000u l=4.000u
X1192 cs25 pb VDD VDD pfet_03v3 w=1.000u l=4.000u
X1193 cs25 pb VDD VDD pfet_03v3 w=1.000u l=4.000u
X1194 cs25 pb VDD VDD pfet_03v3 w=1.000u l=4.000u
X1195 cs25 pb VDD VDD pfet_03v3 w=1.000u l=4.000u
X1196 cs25 pb VDD VDD pfet_03v3 w=1.000u l=4.000u
X1197 cs25 pb VDD VDD pfet_03v3 w=1.000u l=4.000u
X1198 cs25 pb VDD VDD pfet_03v3 w=1.000u l=4.000u
X1199 cs25 pb VDD VDD pfet_03v3 w=1.000u l=4.000u
X1200 cs25 pb VDD VDD pfet_03v3 w=1.000u l=4.000u
X1201 cs25 pb VDD VDD pfet_03v3 w=1.000u l=4.000u
X1202 cs25 pb VDD VDD pfet_03v3 w=1.000u l=4.000u
X1203 cs25 pb VDD VDD pfet_03v3 w=1.000u l=4.000u
X1204 cs25 pb VDD VDD pfet_03v3 w=1.000u l=4.000u
X1205 cs25 pb VDD VDD pfet_03v3 w=1.000u l=4.000u
X1206 cs25 pb VDD VDD pfet_03v3 w=1.000u l=4.000u
X1207 cs25 pb VDD VDD pfet_03v3 w=1.000u l=4.000u
X1208 cs25 pb VDD VDD pfet_03v3 w=1.000u l=4.000u
X1209 cs25 pb VDD VDD pfet_03v3 w=1.000u l=4.000u
X1210 cs25 pb VDD VDD pfet_03v3 w=1.000u l=4.000u
X1211 cs25 pb VDD VDD pfet_03v3 w=1.000u l=4.000u
X1212 cs25 pb VDD VDD pfet_03v3 w=1.000u l=4.000u
X1213 cs25 pb VDD VDD pfet_03v3 w=1.000u l=4.000u
X1214 cs25 pb VDD VDD pfet_03v3 w=1.000u l=4.000u
X1215 cs25 pb VDD VDD pfet_03v3 w=1.000u l=4.000u
X1216 cs25 pb VDD VDD pfet_03v3 w=1.000u l=4.000u
X1217 cs25 pb VDD VDD pfet_03v3 w=1.000u l=4.000u
X1218 mo ns25 cs25 VDD pfet_03v3 w=1.000u l=0.280u
X1219 md mo cs25 VDD pfet_03v3 w=1.000u l=0.280u
X1220 cs27 pb VDD VDD pfet_03v3 w=1.000u l=4.000u
X1221 cs27 pb VDD VDD pfet_03v3 w=1.000u l=4.000u
X1222 cs27 pb VDD VDD pfet_03v3 w=1.000u l=4.000u
X1223 cs27 pb VDD VDD pfet_03v3 w=1.000u l=4.000u
X1224 cs27 pb VDD VDD pfet_03v3 w=1.000u l=4.000u
X1225 cs27 pb VDD VDD pfet_03v3 w=1.000u l=4.000u
X1226 cs27 pb VDD VDD pfet_03v3 w=1.000u l=4.000u
X1227 cs27 pb VDD VDD pfet_03v3 w=1.000u l=4.000u
X1228 cs27 pb VDD VDD pfet_03v3 w=1.000u l=4.000u
X1229 cs27 pb VDD VDD pfet_03v3 w=1.000u l=4.000u
X1230 cs27 pb VDD VDD pfet_03v3 w=1.000u l=4.000u
X1231 cs27 pb VDD VDD pfet_03v3 w=1.000u l=4.000u
X1232 cs27 pb VDD VDD pfet_03v3 w=1.000u l=4.000u
X1233 cs27 pb VDD VDD pfet_03v3 w=1.000u l=4.000u
X1234 cs27 pb VDD VDD pfet_03v3 w=1.000u l=4.000u
X1235 cs27 pb VDD VDD pfet_03v3 w=1.000u l=4.000u
X1236 cs27 pb VDD VDD pfet_03v3 w=1.000u l=4.000u
X1237 cs27 pb VDD VDD pfet_03v3 w=1.000u l=4.000u
X1238 cs27 pb VDD VDD pfet_03v3 w=1.000u l=4.000u
X1239 cs27 pb VDD VDD pfet_03v3 w=1.000u l=4.000u
X1240 cs27 pb VDD VDD pfet_03v3 w=1.000u l=4.000u
X1241 cs27 pb VDD VDD pfet_03v3 w=1.000u l=4.000u
X1242 cs27 pb VDD VDD pfet_03v3 w=1.000u l=4.000u
X1243 cs27 pb VDD VDD pfet_03v3 w=1.000u l=4.000u
X1244 cs27 pb VDD VDD pfet_03v3 w=1.000u l=4.000u
X1245 cs27 pb VDD VDD pfet_03v3 w=1.000u l=4.000u
X1246 cs27 pb VDD VDD pfet_03v3 w=1.000u l=4.000u
X1247 cs27 pb VDD VDD pfet_03v3 w=1.000u l=4.000u
X1248 cs27 pb VDD VDD pfet_03v3 w=1.000u l=4.000u
X1249 cs27 pb VDD VDD pfet_03v3 w=1.000u l=4.000u
X1250 cs27 pb VDD VDD pfet_03v3 w=1.000u l=4.000u
X1251 cs27 pb VDD VDD pfet_03v3 w=1.000u l=4.000u
X1252 mo ns27 cs27 VDD pfet_03v3 w=1.000u l=0.280u
X1253 md mo cs27 VDD pfet_03v3 w=1.000u l=0.280u
X1254 cs29 pb VDD VDD pfet_03v3 w=1.000u l=4.000u
X1255 cs29 pb VDD VDD pfet_03v3 w=1.000u l=4.000u
X1256 cs29 pb VDD VDD pfet_03v3 w=1.000u l=4.000u
X1257 cs29 pb VDD VDD pfet_03v3 w=1.000u l=4.000u
X1258 cs29 pb VDD VDD pfet_03v3 w=1.000u l=4.000u
X1259 cs29 pb VDD VDD pfet_03v3 w=1.000u l=4.000u
X1260 cs29 pb VDD VDD pfet_03v3 w=1.000u l=4.000u
X1261 cs29 pb VDD VDD pfet_03v3 w=1.000u l=4.000u
X1262 cs29 pb VDD VDD pfet_03v3 w=1.000u l=4.000u
X1263 cs29 pb VDD VDD pfet_03v3 w=1.000u l=4.000u
X1264 cs29 pb VDD VDD pfet_03v3 w=1.000u l=4.000u
X1265 cs29 pb VDD VDD pfet_03v3 w=1.000u l=4.000u
X1266 cs29 pb VDD VDD pfet_03v3 w=1.000u l=4.000u
X1267 cs29 pb VDD VDD pfet_03v3 w=1.000u l=4.000u
X1268 cs29 pb VDD VDD pfet_03v3 w=1.000u l=4.000u
X1269 cs29 pb VDD VDD pfet_03v3 w=1.000u l=4.000u
X1270 cs29 pb VDD VDD pfet_03v3 w=1.000u l=4.000u
X1271 cs29 pb VDD VDD pfet_03v3 w=1.000u l=4.000u
X1272 cs29 pb VDD VDD pfet_03v3 w=1.000u l=4.000u
X1273 cs29 pb VDD VDD pfet_03v3 w=1.000u l=4.000u
X1274 cs29 pb VDD VDD pfet_03v3 w=1.000u l=4.000u
X1275 cs29 pb VDD VDD pfet_03v3 w=1.000u l=4.000u
X1276 cs29 pb VDD VDD pfet_03v3 w=1.000u l=4.000u
X1277 cs29 pb VDD VDD pfet_03v3 w=1.000u l=4.000u
X1278 cs29 pb VDD VDD pfet_03v3 w=1.000u l=4.000u
X1279 cs29 pb VDD VDD pfet_03v3 w=1.000u l=4.000u
X1280 cs29 pb VDD VDD pfet_03v3 w=1.000u l=4.000u
X1281 cs29 pb VDD VDD pfet_03v3 w=1.000u l=4.000u
X1282 cs29 pb VDD VDD pfet_03v3 w=1.000u l=4.000u
X1283 cs29 pb VDD VDD pfet_03v3 w=1.000u l=4.000u
X1284 cs29 pb VDD VDD pfet_03v3 w=1.000u l=4.000u
X1285 cs29 pb VDD VDD pfet_03v3 w=1.000u l=4.000u
X1286 mo ns29 cs29 VDD pfet_03v3 w=1.000u l=0.280u
X1287 md mo cs29 VDD pfet_03v3 w=1.000u l=0.280u
X1288 cs31 pb VDD VDD pfet_03v3 w=1.000u l=4.000u
X1289 cs31 pb VDD VDD pfet_03v3 w=1.000u l=4.000u
X1290 cs31 pb VDD VDD pfet_03v3 w=1.000u l=4.000u
X1291 cs31 pb VDD VDD pfet_03v3 w=1.000u l=4.000u
X1292 cs31 pb VDD VDD pfet_03v3 w=1.000u l=4.000u
X1293 cs31 pb VDD VDD pfet_03v3 w=1.000u l=4.000u
X1294 cs31 pb VDD VDD pfet_03v3 w=1.000u l=4.000u
X1295 cs31 pb VDD VDD pfet_03v3 w=1.000u l=4.000u
X1296 cs31 pb VDD VDD pfet_03v3 w=1.000u l=4.000u
X1297 cs31 pb VDD VDD pfet_03v3 w=1.000u l=4.000u
X1298 cs31 pb VDD VDD pfet_03v3 w=1.000u l=4.000u
X1299 cs31 pb VDD VDD pfet_03v3 w=1.000u l=4.000u
X1300 cs31 pb VDD VDD pfet_03v3 w=1.000u l=4.000u
X1301 cs31 pb VDD VDD pfet_03v3 w=1.000u l=4.000u
X1302 cs31 pb VDD VDD pfet_03v3 w=1.000u l=4.000u
X1303 cs31 pb VDD VDD pfet_03v3 w=1.000u l=4.000u
X1304 cs31 pb VDD VDD pfet_03v3 w=1.000u l=4.000u
X1305 cs31 pb VDD VDD pfet_03v3 w=1.000u l=4.000u
X1306 cs31 pb VDD VDD pfet_03v3 w=1.000u l=4.000u
X1307 cs31 pb VDD VDD pfet_03v3 w=1.000u l=4.000u
X1308 cs31 pb VDD VDD pfet_03v3 w=1.000u l=4.000u
X1309 cs31 pb VDD VDD pfet_03v3 w=1.000u l=4.000u
X1310 cs31 pb VDD VDD pfet_03v3 w=1.000u l=4.000u
X1311 cs31 pb VDD VDD pfet_03v3 w=1.000u l=4.000u
X1312 cs31 pb VDD VDD pfet_03v3 w=1.000u l=4.000u
X1313 cs31 pb VDD VDD pfet_03v3 w=1.000u l=4.000u
X1314 cs31 pb VDD VDD pfet_03v3 w=1.000u l=4.000u
X1315 cs31 pb VDD VDD pfet_03v3 w=1.000u l=4.000u
X1316 cs31 pb VDD VDD pfet_03v3 w=1.000u l=4.000u
X1317 cs31 pb VDD VDD pfet_03v3 w=1.000u l=4.000u
X1318 cs31 pb VDD VDD pfet_03v3 w=1.000u l=4.000u
X1319 cs31 pb VDD VDD pfet_03v3 w=1.000u l=4.000u
X1320 mo ns31 cs31 VDD pfet_03v3 w=1.000u l=0.280u
X1321 md mo cs31 VDD pfet_03v3 w=1.000u l=0.280u
X1322 pb pb VDD VDD pfet_03v3 w=1.000u l=4.000u
X1323 pb pb VDD VDD pfet_03v3 w=1.000u l=4.000u
X1324 pb pb VDD VDD pfet_03v3 w=1.000u l=4.000u
X1325 pb pb VDD VDD pfet_03v3 w=1.000u l=4.000u
X1326 pb pb VDD VDD pfet_03v3 w=1.000u l=4.000u
X1327 pb pb VDD VDD pfet_03v3 w=1.000u l=4.000u
X1328 pb pb VDD VDD pfet_03v3 w=1.000u l=4.000u
X1329 pb pb VDD VDD pfet_03v3 w=1.000u l=4.000u
X1330 pb pb VDD VDD pfet_03v3 w=1.000u l=4.000u
X1331 pb pb VDD VDD pfet_03v3 w=1.000u l=4.000u
X1332 pb pb VDD VDD pfet_03v3 w=1.000u l=4.000u
X1333 pb pb VDD VDD pfet_03v3 w=1.000u l=4.000u
X1334 pb pb VDD VDD pfet_03v3 w=1.000u l=4.000u
X1335 pb pb VDD VDD pfet_03v3 w=1.000u l=4.000u
X1336 pb pb VDD VDD pfet_03v3 w=1.000u l=4.000u
X1337 pb pb VDD VDD pfet_03v3 w=1.000u l=4.000u
X1338 pb pb VDD VDD pfet_03v3 w=1.000u l=4.000u
X1339 pb pb VDD VDD pfet_03v3 w=1.000u l=4.000u
X1340 pb pb VDD VDD pfet_03v3 w=1.000u l=4.000u
X1341 pb pb VDD VDD pfet_03v3 w=1.000u l=4.000u
X1342 pb pb VDD VDD pfet_03v3 w=1.000u l=4.000u
X1343 pb pb VDD VDD pfet_03v3 w=1.000u l=4.000u
X1344 pb pb VDD VDD pfet_03v3 w=1.000u l=4.000u
X1345 pb pb VDD VDD pfet_03v3 w=1.000u l=4.000u
X1346 pb pb VDD VDD pfet_03v3 w=1.000u l=4.000u
X1347 pb pb VDD VDD pfet_03v3 w=1.000u l=4.000u
X1348 pb pb VDD VDD pfet_03v3 w=1.000u l=4.000u
X1349 pb pb VDD VDD pfet_03v3 w=1.000u l=4.000u
X1350 pb pb VDD VDD pfet_03v3 w=1.000u l=4.000u
X1351 pb pb VDD VDD pfet_03v3 w=1.000u l=4.000u
X1352 pb pb VDD VDD pfet_03v3 w=1.000u l=4.000u
X1353 pb pb VDD VDD pfet_03v3 w=1.000u l=4.000u
X1354 mo mo VSS VSS nfet_03v3 w=1.200u l=5.335u
X1355 mo mo VSS VSS nfet_03v3 w=1.200u l=5.335u
X1356 mo mo VSS VSS nfet_03v3 w=1.200u l=5.335u
X1357 mo mo VSS VSS nfet_03v3 w=1.200u l=5.335u
X1358 mo mo VSS VSS nfet_03v3 w=1.200u l=5.335u
X1359 mo mo VSS VSS nfet_03v3 w=1.200u l=5.335u
X1360 mo mo VSS VSS nfet_03v3 w=1.200u l=5.335u
X1361 mo mo VSS VSS nfet_03v3 w=1.200u l=5.335u
X1362 mo mo VSS VSS nfet_03v3 w=1.200u l=5.335u
X1363 mo mo VSS VSS nfet_03v3 w=1.200u l=5.335u
X1364 mo mo VSS VSS nfet_03v3 w=1.200u l=5.335u
X1365 mo mo VSS VSS nfet_03v3 w=1.200u l=5.335u
X1366 mo mo VSS VSS nfet_03v3 w=1.200u l=5.335u
X1367 mo mo VSS VSS nfet_03v3 w=1.200u l=5.335u
X1368 mo mo VSS VSS nfet_03v3 w=1.200u l=5.335u
X1369 mo mo VSS VSS nfet_03v3 w=1.200u l=5.335u
X1370 mo mo VSS VSS nfet_03v3 w=1.200u l=5.335u
X1371 mo mo VSS VSS nfet_03v3 w=1.200u l=5.335u
X1372 mo mo VSS VSS nfet_03v3 w=1.200u l=5.335u
X1373 mo mo VSS VSS nfet_03v3 w=1.200u l=5.335u
X1374 mo mo VSS VSS nfet_03v3 w=1.200u l=5.335u
X1375 mo mo VSS VSS nfet_03v3 w=1.200u l=5.335u
X1376 mo mo VSS VSS nfet_03v3 w=1.200u l=5.335u
X1377 mo mo VSS VSS nfet_03v3 w=1.200u l=5.335u
X1378 mo mo VSS VSS nfet_03v3 w=1.200u l=5.335u
X1379 mo mo VSS VSS nfet_03v3 w=1.200u l=5.335u
X1380 mo mo VSS VSS nfet_03v3 w=1.200u l=5.335u
X1381 mo mo VSS VSS nfet_03v3 w=1.200u l=5.335u
X1382 mo mo VSS VSS nfet_03v3 w=1.200u l=5.335u
X1383 mo mo VSS VSS nfet_03v3 w=1.200u l=5.335u
X1384 vg mo VSS VSS nfet_03v3 w=1.200u l=5.335u
X1385 vg mo VSS VSS nfet_03v3 w=1.200u l=5.335u
X1386 vg mo VSS VSS nfet_03v3 w=1.200u l=5.335u
X1387 pb vbnf VSS VSS nfet_03v3 w=1.200u l=5.335u
X1388 md md VSS VSS nfet_03v3 w=3.400u l=1.000u
X1389 md md VSS VSS nfet_03v3 w=3.400u l=1.000u
.ends mdac

.subckt vctrl_pd a b
XRV a b b ppolyf_u_1k r_width=1e-6 r_length=193.910e-6
.ends vctrl_pd

.SUBCKT gf180mcu_fd_sc_mcu7t5v0__inv_1 I ZN VDD VNW VPW VSS
X_i_0 ZN I VSS VPW nfet_05v0 W=8.2e-07 L=6e-07
X_i_1 ZN I VDD VNW pfet_05v0 W=1.22e-06 L=5e-07
.ENDS

.SUBCKT gf180mcu_fd_sc_mcu7t5v0__tiel ZN VDD VNW VPW VSS
X_n_tran_1 VSS A ZN VPW nfet_05v0 W=8.2e-07 L=6e-07
X_transistor_0 VDD A A VNW pfet_05v0 W=1.22e-06 L=5e-07
.ENDS

.SUBCKT gf180mcu_fd_sc_mcu7t5v0__tieh Z VDD VNW VPW VSS
X_n_tran_1 VSS A A VPW nfet_05v0 W=0.82U L=0.600000U
X_p_tran_2 VDD A Z VNW pfet_05v0 W=1.22e-06 L=5e-07
.ENDS

.SUBCKT gf180mcu_fd_sc_mcu7t5v0__antenna I VDD VNW VPW VSS
D0 VPW I diode_nd2ps_06v0 AREA=0.2052p PJ=1.86u M=1
D1 I VNW diode_pd2nw_06v0 AREA=0.2052p PJ=1.86u M=1
.ENDS

.SUBCKT gf180mcu_fd_sc_mcu7t5v0__fill_2 VDD VNW VPW VSS
.ENDS

.SUBCKT gf180mcu_fd_sc_mcu7t5v0__fillcap_16 VDD VNW VPW VSS
X_i_17 net_3 net_2 VSS VPW nfet_05v0 W=8.2e-07 L=1e-06
X_i_17_23 net_4 net_5 VSS VPW nfet_05v0 W=8.2e-07 L=1e-06
X_i_17_24 net_7 net_9 VSS VPW nfet_05v0 W=8.2e-07 L=1e-06
X_i_17_23_55 net_6 net_8 VSS VPW nfet_05v0 W=8.2e-07 L=1e-06
X_i_19 VDD net_3 net_2 VNW pfet_05v0 W=1.22e-06 L=1e-06
X_i_19_7 VDD net_4 net_5 VNW pfet_05v0 W=1.22e-06 L=1e-06
X_i_19_33 VDD net_7 net_9 VNW pfet_05v0 W=1.22e-06 L=1e-06
X_i_19_7_23 VDD net_6 net_8 VNW pfet_05v0 W=1.22e-06 L=1e-06
.ENDS

.SUBCKT gf180mcu_fd_sc_mcu7t5v0__fillcap_4 VDD VNW VPW VSS
X_i_17 net_1 net_0 VSS VPW nfet_05v0 W=8.2e-07 L=1e-06
X_i_19 VDD net_1 net_0 VNW pfet_05v0 W=1.22e-06 L=1e-06
.ENDS

.SUBCKT gf180mcu_fd_sc_mcu7t5v0__fillcap_32 VDD VNW VPW VSS
X_i_17 net_3 net_2 VSS VPW nfet_05v0 W=8.2e-07 L=1e-06
X_i_17_23 net_4 net_5 VSS VPW nfet_05v0 W=8.2e-07 L=1e-06
X_i_17_24 net_7 net_9 VSS VPW nfet_05v0 W=8.2e-07 L=1e-06
X_i_17_23_55 net_6 net_8 VSS VPW nfet_05v0 W=8.2e-07 L=1e-06
X_i_17_27 net_17 net_14 VSS VPW nfet_05v0 W=8.2e-07 L=1e-06
X_i_17_23_63 net_16 net_15 VSS VPW nfet_05v0 W=8.2e-07 L=1e-06
X_i_17_24_22 net_13 net_11 VSS VPW nfet_05v0 W=8.2e-07 L=1e-06
X_i_17_23_55_93 net_12 net_10 VSS VPW nfet_05v0 W=8.2e-07 L=1e-06
X_i_19 VDD net_3 net_2 VNW pfet_05v0 W=1.22e-06 L=1e-06
X_i_19_7 VDD net_4 net_5 VNW pfet_05v0 W=1.22e-06 L=1e-06
X_i_19_33 VDD net_7 net_9 VNW pfet_05v0 W=1.22e-06 L=1e-06
X_i_19_7_23 VDD net_6 net_8 VNW pfet_05v0 W=1.22e-06 L=1e-06
X_i_19_94 VDD net_17 net_14 VNW pfet_05v0 W=1.22e-06 L=1e-06
X_i_19_7_87 VDD net_16 net_15 VNW pfet_05v0 W=1.22e-06 L=1e-06
X_i_19_33_95 VDD net_13 net_11 VNW pfet_05v0 W=1.22e-06 L=1e-06
X_i_19_7_23_23 VDD net_12 net_10 VNW pfet_05v0 W=1.22e-06 L=1e-06
.ENDS

.SUBCKT gf180mcu_fd_sc_mcu7t5v0__fill_1 VDD VNW VPW VSS
.ENDS

.SUBCKT gf180mcu_fd_sc_mcu7t5v0__fillcap_8 VDD VNW VPW VSS
X_i_17 net_3 net_2 VSS VPW nfet_05v0 W=8.2e-07 L=1e-06
X_i_17_23 net_4 net_5 VSS VPW nfet_05v0 W=8.2e-07 L=1e-06
X_i_19 VDD net_3 net_2 VNW pfet_05v0 W=1.22e-06 L=1e-06
X_i_19_7 VDD net_4 net_5 VNW pfet_05v0 W=1.22e-06 L=1e-06
.ENDS

.SUBCKT gf180mcu_fd_sc_mcu7t5v0__endcap VDD VNW VPW VSS
.ENDS

.SUBCKT gf180mcu_fd_sc_mcu7t5v0__filltie VDD VSS
.ENDS

.SUBCKT gf180mcu_fd_sc_mcu7t5v0__clkinv_1 I ZN VDD VNW VPW VSS
X_i_0 ZN I VSS VPW nfet_05v0 W=4.8e-07 L=6e-07
X_i_1 ZN I VDD VNW pfet_05v0 W=1.22e-06 L=5e-07
.ENDS

.SUBCKT gf180mcu_fd_sc_mcu7t5v0__oai21_1 A1 A2 B ZN VDD VNW VPW VSS
X_i_1 ZN A2 net_0 VPW nfet_05v0 W=8.2e-07 L=6e-07
X_i_0 net_0 A1 ZN VPW nfet_05v0 W=8.2e-07 L=6e-07
X_i_2 VSS B net_0 VPW nfet_05v0 W=8.2e-07 L=6e-07
X_i_4 net_1 A2 VDD VNW pfet_05v0 W=1.22e-06 L=5e-07
X_i_3 ZN A1 net_1 VNW pfet_05v0 W=1.22e-06 L=5e-07
X_i_5 VDD B ZN VNW pfet_05v0 W=1.13e-06 L=5e-07
.ENDS

.SUBCKT gf180mcu_fd_sc_mcu7t5v0__nand2_1 A1 A2 ZN VDD VNW VPW VSS
X_i_1 net_0 A2 VSS VPW nfet_05v0 W=8.2e-07 L=6e-07
X_i_0 ZN A1 net_0 VPW nfet_05v0 W=8.2e-07 L=6e-07
X_i_3 ZN A2 VDD VNW pfet_05v0 W=1.13e-06 L=5e-07
X_i_2 VDD A1 ZN VNW pfet_05v0 W=1.13e-06 L=5e-07
.ENDS

.SUBCKT gf180mcu_fd_sc_mcu7t5v0__nor2_1 A1 A2 ZN VDD VNW VPW VSS
X_i_1 ZN A2 VSS VPW nfet_05v0 W=5.65e-07 L=6e-07
X_i_0 VSS A1 ZN VPW nfet_05v0 W=5.65e-07 L=6e-07
X_i_3 net_0 A2 VDD VNW pfet_05v0 W=1.22e-06 L=5e-07
X_i_2 ZN A1 net_0 VNW pfet_05v0 W=1.22e-06 L=5e-07
.ENDS

.SUBCKT gf180mcu_fd_sc_mcu7t5v0__and2_1 A1 A2 Z VDD VNW VPW VSS
X_i_2 net_0 A1 Z_neg VPW nfet_05v0 W=3.65e-07 L=6e-07
X_i_3 VSS A2 net_0 VPW nfet_05v0 W=3.65e-07 L=6e-07
X_i_0 Z Z_neg VSS VPW nfet_05v0 W=8.15e-07 L=6e-07
X_i_4 Z_neg A1 VDD VNW pfet_05v0 W=6e-07 L=5e-07
X_i_5 VDD A2 Z_neg VNW pfet_05v0 W=6e-07 L=5e-07
X_i_1 Z Z_neg VDD VNW pfet_05v0 W=1.215e-06 L=5e-07
.ENDS

.SUBCKT gf180mcu_fd_sc_mcu7t5v0__nor4_1 A1 A2 A3 A4 ZN VDD VNW VPW VSS
X_i_3 ZN A4 VSS VPW nfet_05v0 W=3.6e-07 L=6e-07
X_i_2 VSS A3 ZN VPW nfet_05v0 W=3.6e-07 L=6e-07
X_i_1 ZN A2 VSS VPW nfet_05v0 W=3.6e-07 L=6e-07
X_i_0 VSS A1 ZN VPW nfet_05v0 W=3.6e-07 L=6e-07
X_i_7 net_2 A4 VDD VNW pfet_05v0 W=1.22e-06 L=5e-07
X_i_6 net_1 A3 net_2 VNW pfet_05v0 W=1.22e-06 L=5e-07
X_i_5 net_0 A2 net_1 VNW pfet_05v0 W=1.22e-06 L=5e-07
X_i_4 ZN A1 net_0 VNW pfet_05v0 W=1.22e-06 L=5e-07
.ENDS

.SUBCKT gf180mcu_fd_sc_mcu7t5v0__or2_1 A1 A2 Z VDD VNW VPW VSS
X_i_2 Z_neg A1 VSS VPW nfet_05v0 W=3.6e-07 L=6e-07
X_i_3 VSS A2 Z_neg VPW nfet_05v0 W=3.6e-07 L=6e-07
X_i_0 Z Z_neg VSS VPW nfet_05v0 W=8.2e-07 L=6e-07
X_i_4 net_0 A1 Z_neg VNW pfet_05v0 W=5.65e-07 L=5e-07
X_i_5 VDD A2 net_0 VNW pfet_05v0 W=5.65e-07 L=5e-07
X_i_1 Z Z_neg VDD VNW pfet_05v0 W=1.22e-06 L=5e-07
.ENDS

.SUBCKT gf180mcu_fd_sc_mcu7t5v0__nand4_1 A1 A2 A3 A4 ZN VDD VNW VPW VSS
X_i_3 net_2 A4 VSS VPW nfet_05v0 W=8.2e-07 L=6e-07
X_i_2 net_1 A3 net_2 VPW nfet_05v0 W=8.2e-07 L=6e-07
X_i_1 net_0 A2 net_1 VPW nfet_05v0 W=8.2e-07 L=6e-07
X_i_0 ZN A1 net_0 VPW nfet_05v0 W=8.2e-07 L=6e-07
X_i_7 ZN A4 VDD VNW pfet_05v0 W=8.45e-07 L=5e-07
X_i_6 VDD A3 ZN VNW pfet_05v0 W=8.45e-07 L=5e-07
X_i_5 ZN A2 VDD VNW pfet_05v0 W=8.45e-07 L=5e-07
X_i_4 VDD A1 ZN VNW pfet_05v0 W=8.45e-07 L=5e-07
.ENDS

.SUBCKT gf180mcu_fd_sc_mcu7t5v0__nor3_1 A1 A2 A3 ZN VDD VNW VPW VSS
X_i_2 ZN A3 VSS VPW nfet_05v0 W=4.65e-07 L=6e-07
X_i_1 VSS A2 ZN VPW nfet_05v0 W=4.65e-07 L=6e-07
X_i_0 ZN A1 VSS VPW nfet_05v0 W=4.65e-07 L=6e-07
X_i_5 net_1 A3 VDD VNW pfet_05v0 W=1.22e-06 L=5e-07
X_i_4 net_0 A2 net_1 VNW pfet_05v0 W=1.22e-06 L=5e-07
X_i_3 ZN A1 net_0 VNW pfet_05v0 W=1.22e-06 L=5e-07
.ENDS

.SUBCKT gf180mcu_fd_sc_mcu7t5v0__aoi21_1 A1 A2 B ZN VDD VNW VPW VSS
X_i_1 net_0 A2 VSS VPW nfet_05v0 W=8.2e-07 L=6e-07
X_i_0 ZN A1 net_0 VPW nfet_05v0 W=8.2e-07 L=6e-07
X_i_2 VSS B ZN VPW nfet_05v0 W=5.1e-07 L=6e-07
X_i_4 ZN A2 net_1 VNW pfet_05v0 W=1.215e-06 L=5e-07
X_i_3 net_1 A1 ZN VNW pfet_05v0 W=1.215e-06 L=5e-07
X_i_5 VDD B net_1 VNW pfet_05v0 W=1.215e-06 L=5e-07
.ENDS

.SUBCKT gf180mcu_fd_sc_mcu7t5v0__aoi211_1 A1 A2 B C ZN VDD VNW VPW VSS
X_i_1 net_0 A2 VSS VPW nfet_05v0 W=7.1e-07 L=6e-07
X_i_0 ZN A1 net_0 VPW nfet_05v0 W=7.1e-07 L=6e-07
X_i_2 VSS B ZN VPW nfet_05v0 W=4.65e-07 L=6e-07
X_i_3 ZN C VSS VPW nfet_05v0 W=4.65e-07 L=6e-07
X_i_5 ZN A2 net_1 VNW pfet_05v0 W=1.215e-06 L=5e-07
X_i_4 net_1 A1 ZN VNW pfet_05v0 W=1.215e-06 L=5e-07
X_i_6 net_2 B net_1 VNW pfet_05v0 W=1.215e-06 L=5e-07
X_i_7 VDD C net_2 VNW pfet_05v0 W=1.215e-06 L=5e-07
.ENDS

.SUBCKT gf180mcu_fd_sc_mcu7t5v0__oai31_1 A1 A2 A3 B ZN VDD VNW VPW VSS
X_i_3 net_0 B VSS VPW nfet_05v0 W=8.15e-07 L=6e-07
X_i_0 ZN A1 net_0 VPW nfet_05v0 W=8.15e-07 L=6e-07
X_i_1 net_0 A2 ZN VPW nfet_05v0 W=8.15e-07 L=6e-07
X_i_2 ZN A3 net_0 VPW nfet_05v0 W=8.15e-07 L=6e-07
X_i_7 ZN B VDD VNW pfet_05v0 W=1.13e-06 L=5e-07
X_i_4 net_1 A1 ZN VNW pfet_05v0 W=1.095e-06 L=5e-07
X_i_5 net_2 A2 net_1 VNW pfet_05v0 W=1.095e-06 L=5e-07
X_i_6 VDD A3 net_2 VNW pfet_05v0 W=1.095e-06 L=5e-07
.ENDS

.SUBCKT gf180mcu_fd_sc_mcu7t5v0__nand3_1 A1 A2 A3 ZN VDD VNW VPW VSS
X_i_2 net_1 A3 VSS VPW nfet_05v0 W=8.2e-07 L=6e-07
X_i_1 net_0 A2 net_1 VPW nfet_05v0 W=8.2e-07 L=6e-07
X_i_0 ZN A1 net_0 VPW nfet_05v0 W=8.2e-07 L=6e-07
X_i_5 ZN A3 VDD VNW pfet_05v0 W=9.85e-07 L=5e-07
X_i_4 VDD A2 ZN VNW pfet_05v0 W=9.85e-07 L=5e-07
X_i_3 ZN A1 VDD VNW pfet_05v0 W=9.85e-07 L=5e-07
.ENDS

.SUBCKT gf180mcu_fd_sc_mcu7t5v0__xor2_1 A1 A2 Z VDD VNW VPW VSS
X_i_6 I A2 VSS VPW nfet_05v0 W=3.6e-07 L=6e-07
X_i_7 VSS A1 I VPW nfet_05v0 W=3.6e-07 L=6e-07
X_i_2 Z I VSS VPW nfet_05v0 W=8.2e-07 L=6e-07
X_i_0 net_0 A1 Z VPW nfet_05v0 W=8.2e-07 L=6e-07
X_i_1 VSS A2 net_0 VPW nfet_05v0 W=8.2e-07 L=6e-07
X_i_8 net_2 A2 I VNW pfet_05v0 W=5.6e-07 L=5e-07
X_i_9 VDD A1 net_2 VNW pfet_05v0 W=5.6e-07 L=5e-07
X_i_5 net_1 I VDD VNW pfet_05v0 W=1.22e-06 L=5e-07
X_i_3 Z A1 net_1 VNW pfet_05v0 W=1.22e-06 L=5e-07
X_i_4 net_1 A2 Z VNW pfet_05v0 W=1.22e-06 L=5e-07
.ENDS

.SUBCKT gf180mcu_fd_sc_mcu7t5v0__oai22_1 A1 A2 B1 B2 ZN VDD VNW VPW VSS
X_i_3 VSS B2 net_0 VPW nfet_05v0 W=8.2e-07 L=6e-07
X_i_2 net_0 B1 VSS VPW nfet_05v0 W=8.2e-07 L=6e-07
X_i_0 ZN A1 net_0 VPW nfet_05v0 W=8.2e-07 L=6e-07
X_i_1 net_0 A2 ZN VPW nfet_05v0 W=8.2e-07 L=6e-07
X_i_7 net_2 B2 VDD VNW pfet_05v0 W=1.22e-06 L=5e-07
X_i_6 ZN B1 net_2 VNW pfet_05v0 W=1.22e-06 L=5e-07
X_i_4 net_1 A1 ZN VNW pfet_05v0 W=1.22e-06 L=5e-07
X_i_5 VDD A2 net_1 VNW pfet_05v0 W=1.22e-06 L=5e-07
.ENDS

.SUBCKT gf180mcu_fd_sc_mcu7t5v0__aoi22_1 A1 A2 B1 B2 ZN VDD VNW VPW VSS
X_i_3 net_1 B2 VSS VPW nfet_05v0 W=8.15e-07 L=6e-07
X_i_2 ZN B1 net_1 VPW nfet_05v0 W=8.15e-07 L=6e-07
X_i_0 net_0 A1 ZN VPW nfet_05v0 W=8.15e-07 L=6e-07
X_i_1 VSS A2 net_0 VPW nfet_05v0 W=8.15e-07 L=6e-07
X_i_7 VDD B2 net_2 VNW pfet_05v0 W=1.215e-06 L=5e-07
X_i_6 net_2 B1 VDD VNW pfet_05v0 W=1.215e-06 L=5e-07
X_i_4 ZN A1 net_2 VNW pfet_05v0 W=1.215e-06 L=5e-07
X_i_5 net_2 A2 ZN VNW pfet_05v0 W=1.215e-06 L=5e-07
.ENDS

.SUBCKT gf180mcu_fd_sc_mcu7t5v0__oai221_1 A1 A2 B1 B2 C ZN VDD VNW VPW VSS
X_i_4 VSS B2 net_1 VPW nfet_05v0 W=8.2e-07 L=6e-07
X_i_3 net_1 B1 VSS VPW nfet_05v0 W=8.2e-07 L=6e-07
X_i_2 net_0 C net_1 VPW nfet_05v0 W=8.2e-07 L=6e-07
X_i_1 ZN A2 net_0 VPW nfet_05v0 W=8.2e-07 L=6e-07
X_i_0 net_0 A1 ZN VPW nfet_05v0 W=8.2e-07 L=6e-07
X_i_9 net_3 B2 VDD VNW pfet_05v0 W=1.22e-06 L=5e-07
X_i_8 ZN B1 net_3 VNW pfet_05v0 W=1.22e-06 L=5e-07
X_i_7 VDD C ZN VNW pfet_05v0 W=9.45e-07 L=5e-07
X_i_6 net_2 A2 VDD VNW pfet_05v0 W=1.22e-06 L=5e-07
X_i_5 ZN A1 net_2 VNW pfet_05v0 W=1.22e-06 L=5e-07
.ENDS

.SUBCKT gf180mcu_fd_sc_mcu7t5v0__aoi221_1 A1 A2 B1 B2 C ZN VDD VNW VPW VSS
X_i_4 net_1 B2 VSS VPW nfet_05v0 W=7.1e-07 L=6e-07
X_i_3 ZN B1 net_1 VPW nfet_05v0 W=7.1e-07 L=6e-07
X_i_2 VSS C ZN VPW nfet_05v0 W=4.65e-07 L=6e-07
X_i_1 net_0 A2 VSS VPW nfet_05v0 W=7.1e-07 L=6e-07
X_i_0 ZN A1 net_0 VPW nfet_05v0 W=7.1e-07 L=6e-07
X_i_9 VDD B2 net_3 VNW pfet_05v0 W=1.215e-06 L=5e-07
X_i_8 net_3 B1 VDD VNW pfet_05v0 W=1.215e-06 L=5e-07
X_i_7 net_2 C net_3 VNW pfet_05v0 W=1.215e-06 L=5e-07
X_i_6 ZN A2 net_2 VNW pfet_05v0 W=1.215e-06 L=5e-07
X_i_5 net_2 A1 ZN VNW pfet_05v0 W=1.215e-06 L=5e-07
.ENDS

.SUBCKT gf180mcu_fd_sc_mcu7t5v0__xor2_2 A1 A2 Z VDD VNW VPW VSS
X_i_8 net_2 A2 I VPW nfet_05v0 W=3.6e-07 L=6e-07
X_i_9 VSS A1 net_2 VPW nfet_05v0 W=3.6e-07 L=6e-07
X_i_4 net_0 I VSS VPW nfet_05v0 W=8.2e-07 L=6e-07
X_i_2 Z_neg A1 net_0 VPW nfet_05v0 W=8.2e-07 L=6e-07
X_i_3 net_0 A2 Z_neg VPW nfet_05v0 W=8.2e-07 L=6e-07
X_i_0_0 Z Z_neg VSS VPW nfet_05v0 W=8.2e-07 L=6e-07
X_i_0_1 VSS Z_neg Z VPW nfet_05v0 W=8.2e-07 L=6e-07
X_i_10 I A2 VDD VNW pfet_05v0 W=5.6e-07 L=5e-07
X_i_11 VDD A1 I VNW pfet_05v0 W=5.6e-07 L=5e-07
X_i_7 Z_neg I VDD VNW pfet_05v0 W=1.095e-06 L=5e-07
X_i_5 net_1 A1 Z_neg VNW pfet_05v0 W=1.095e-06 L=5e-07
X_i_6 VDD A2 net_1 VNW pfet_05v0 W=1.095e-06 L=5e-07
X_i_1_0 Z Z_neg VDD VNW pfet_05v0 W=1.22e-06 L=5e-07
X_i_1_1 VDD Z_neg Z VNW pfet_05v0 W=1.22e-06 L=5e-07
.ENDS

.SUBCKT gf180mcu_fd_sc_mcu7t5v0__xnor2_2 A1 A2 ZN VDD VNW VPW VSS
X_i_8 I A2 VSS VPW nfet_05v0 W=3.6e-07 L=6e-07
X_i_9 VSS A1 I VPW nfet_05v0 W=3.6e-07 L=6e-07
X_i_4 Z_neg I VSS VPW nfet_05v0 W=8.2e-07 L=6e-07
X_i_2 net_0 A1 Z_neg VPW nfet_05v0 W=8.2e-07 L=6e-07
X_i_3 VSS A2 net_0 VPW nfet_05v0 W=8.2e-07 L=6e-07
X_i_0_0 ZN Z_neg VSS VPW nfet_05v0 W=8.2e-07 L=6e-07
X_i_0_1 VSS Z_neg ZN VPW nfet_05v0 W=8.2e-07 L=6e-07
X_i_10 net_2 A2 I VNW pfet_05v0 W=5.65e-07 L=5e-07
X_i_11 VDD A1 net_2 VNW pfet_05v0 W=5.65e-07 L=5e-07
X_i_7 net_1 I VDD VNW pfet_05v0 W=1.22e-06 L=5e-07
X_i_5 Z_neg A1 net_1 VNW pfet_05v0 W=1.22e-06 L=5e-07
X_i_6 net_1 A2 Z_neg VNW pfet_05v0 W=1.22e-06 L=5e-07
X_i_1_0 ZN Z_neg VDD VNW pfet_05v0 W=1.22e-06 L=5e-07
X_i_1_1 VDD Z_neg ZN VNW pfet_05v0 W=1.22e-06 L=5e-07
.ENDS

.SUBCKT gf180mcu_fd_sc_mcu7t5v0__nor2_4 A1 A2 ZN VDD VNW VPW VSS
X_i_1_3 ZN A2 VSS VPW nfet_05v0 W=5.65e-07 L=6e-07
X_i_0_3 VSS A1 ZN VPW nfet_05v0 W=5.65e-07 L=6e-07
X_i_0_2 ZN A1 VSS VPW nfet_05v0 W=5.65e-07 L=6e-07
X_i_1_2 VSS A2 ZN VPW nfet_05v0 W=5.65e-07 L=6e-07
X_i_1_1 ZN A2 VSS VPW nfet_05v0 W=5.65e-07 L=6e-07
X_i_0_1 VSS A1 ZN VPW nfet_05v0 W=5.65e-07 L=6e-07
X_i_0_0 ZN A1 VSS VPW nfet_05v0 W=5.65e-07 L=6e-07
X_i_1_0 VSS A2 ZN VPW nfet_05v0 W=5.65e-07 L=6e-07
X_i_3_3 net_0_0 A2 VDD VNW pfet_05v0 W=1.22e-06 L=5e-07
X_i_2_3 ZN A1 net_0_0 VNW pfet_05v0 W=1.22e-06 L=5e-07
X_i_2_2 net_0_1 A1 ZN VNW pfet_05v0 W=1.22e-06 L=5e-07
X_i_3_2 VDD A2 net_0_1 VNW pfet_05v0 W=1.22e-06 L=5e-07
X_i_3_1 net_0_2 A2 VDD VNW pfet_05v0 W=1.22e-06 L=5e-07
X_i_2_1 ZN A1 net_0_2 VNW pfet_05v0 W=1.22e-06 L=5e-07
X_i_2_0 net_0_3 A1 ZN VNW pfet_05v0 W=1.22e-06 L=5e-07
X_i_3_0 VDD A2 net_0_3 VNW pfet_05v0 W=1.22e-06 L=5e-07
.ENDS

.SUBCKT gf180mcu_fd_sc_mcu7t5v0__oai21_2 A1 A2 B ZN VDD VNW VPW VSS
X_i_2_1 VSS B net_0 VPW nfet_05v0 W=8.2e-07 L=6e-07
X_i_2_0 net_0 B VSS VPW nfet_05v0 W=8.2e-07 L=6e-07
X_i_1_1 ZN A2 net_0 VPW nfet_05v0 W=8.2e-07 L=6e-07
X_i_0_1 net_0 A1 ZN VPW nfet_05v0 W=8.2e-07 L=6e-07
X_i_0_0 ZN A1 net_0 VPW nfet_05v0 W=8.2e-07 L=6e-07
X_i_1_0 net_0 A2 ZN VPW nfet_05v0 W=8.2e-07 L=6e-07
X_i_5_1 ZN B VDD VNW pfet_05v0 W=9.55e-07 L=5e-07
X_i_5_0 VDD B ZN VNW pfet_05v0 W=9.55e-07 L=5e-07
X_i_4_1 net_1_0 A2 VDD VNW pfet_05v0 W=1.095e-06 L=5e-07
X_i_3_1 ZN A1 net_1_0 VNW pfet_05v0 W=1.095e-06 L=5e-07
X_i_3_0 net_1_1 A1 ZN VNW pfet_05v0 W=1.095e-06 L=5e-07
X_i_4_0 VDD A2 net_1_1 VNW pfet_05v0 W=1.095e-06 L=5e-07
.ENDS

.SUBCKT gf180mcu_fd_sc_mcu7t5v0__or3_2 A1 A2 A3 Z VDD VNW VPW VSS
X_i_2 VSS A1 Z_neg VPW nfet_05v0 W=6.65e-07 L=6e-07
X_i_3 Z_neg A2 VSS VPW nfet_05v0 W=6.65e-07 L=6e-07
X_i_4 VSS A3 Z_neg VPW nfet_05v0 W=6.65e-07 L=6e-07
X_i_0_0 Z Z_neg VSS VPW nfet_05v0 W=8.2e-07 L=6e-07
X_i_0_1 VSS Z_neg Z VPW nfet_05v0 W=8.2e-07 L=6e-07
X_i_5 net_0 A1 Z_neg VNW pfet_05v0 W=1.22e-06 L=5e-07
X_i_6 net_1 A2 net_0 VNW pfet_05v0 W=1.22e-06 L=5e-07
X_i_7 VDD A3 net_1 VNW pfet_05v0 W=1.22e-06 L=5e-07
X_i_1_0 Z Z_neg VDD VNW pfet_05v0 W=1.22e-06 L=5e-07
X_i_1_1 VDD Z_neg Z VNW pfet_05v0 W=1.22e-06 L=5e-07
.ENDS

.SUBCKT gf180mcu_fd_sc_mcu7t5v0__nor3_2 A1 A2 A3 ZN VDD VNW VPW VSS
X_i_2_1 VSS A3 ZN VPW nfet_05v0 W=4.65e-07 L=6e-07
X_i_1_0 ZN A2 VSS VPW nfet_05v0 W=4.65e-07 L=6e-07
X_i_0_0 VSS A1 ZN VPW nfet_05v0 W=4.65e-07 L=6e-07
X_i_0_1 ZN A1 VSS VPW nfet_05v0 W=4.65e-07 L=6e-07
X_i_1_1 VSS A2 ZN VPW nfet_05v0 W=4.65e-07 L=6e-07
X_i_2_0 ZN A3 VSS VPW nfet_05v0 W=4.65e-07 L=6e-07
X_i_5_1 net_1_0 A3 VDD VNW pfet_05v0 W=1.22e-06 L=5e-07
X_i_4_0 net_0_0 A2 net_1_0 VNW pfet_05v0 W=1.22e-06 L=5e-07
X_i_3_0 ZN A1 net_0_0 VNW pfet_05v0 W=1.22e-06 L=5e-07
X_i_3_1 net_0_1 A1 ZN VNW pfet_05v0 W=1.22e-06 L=5e-07
X_i_4_1 net_1_1 A2 net_0_1 VNW pfet_05v0 W=1.22e-06 L=5e-07
X_i_5_0 VDD A3 net_1_1 VNW pfet_05v0 W=1.22e-06 L=5e-07
.ENDS

.SUBCKT gf180mcu_fd_sc_mcu7t5v0__nand2_2 A1 A2 ZN VDD VNW VPW VSS
X_i_1_1 net_0_0 A2 VSS VPW nfet_05v0 W=8.2e-07 L=6e-07
X_i_0_1 ZN A1 net_0_0 VPW nfet_05v0 W=8.2e-07 L=6e-07
X_i_0_0 net_0_1 A1 ZN VPW nfet_05v0 W=8.2e-07 L=6e-07
X_i_1_0 VSS A2 net_0_1 VPW nfet_05v0 W=8.2e-07 L=6e-07
X_i_3_1 ZN A2 VDD VNW pfet_05v0 W=1.13e-06 L=5e-07
X_i_2_1 VDD A1 ZN VNW pfet_05v0 W=1.13e-06 L=5e-07
X_i_2_0 ZN A1 VDD VNW pfet_05v0 W=1.13e-06 L=5e-07
X_i_3_0 VDD A2 ZN VNW pfet_05v0 W=1.13e-06 L=5e-07
.ENDS

.SUBCKT gf180mcu_fd_sc_mcu7t5v0__nor4_4 A1 A2 A3 A4 ZN VDD VNW VPW VSS
X_i_2_3 ZN A3 VSS VPW nfet_05v0 W=3.6e-07 L=6e-07
X_i_3_3 VSS A4 ZN VPW nfet_05v0 W=3.6e-07 L=6e-07
X_i_3_2 ZN A4 VSS VPW nfet_05v0 W=3.6e-07 L=6e-07
X_i_2_2 VSS A3 ZN VPW nfet_05v0 W=3.6e-07 L=6e-07
X_i_2_1 ZN A3 VSS VPW nfet_05v0 W=3.6e-07 L=6e-07
X_i_3_1 VSS A4 ZN VPW nfet_05v0 W=3.6e-07 L=6e-07
X_i_3_0 ZN A4 VSS VPW nfet_05v0 W=3.6e-07 L=6e-07
X_i_2_0 VSS A3 ZN VPW nfet_05v0 W=3.6e-07 L=6e-07
X_i_1_3 ZN A2 VSS VPW nfet_05v0 W=3.6e-07 L=6e-07
X_i_0_3 VSS A1 ZN VPW nfet_05v0 W=3.6e-07 L=6e-07
X_i_0_2 ZN A1 VSS VPW nfet_05v0 W=3.6e-07 L=6e-07
X_i_1_2 VSS A2 ZN VPW nfet_05v0 W=3.6e-07 L=6e-07
X_i_1_1 ZN A2 VSS VPW nfet_05v0 W=3.6e-07 L=6e-07
X_i_0_1 VSS A1 ZN VPW nfet_05v0 W=3.6e-07 L=6e-07
X_i_0_0 ZN A1 VSS VPW nfet_05v0 W=3.6e-07 L=6e-07
X_i_1_0 VSS A2 ZN VPW nfet_05v0 W=3.6e-07 L=6e-07
X_i_6_3 net_2_3 A3 net_1 VNW pfet_05v0 W=1.215e-06 L=5e-07
X_i_7_3 VDD A4 net_2_3 VNW pfet_05v0 W=1.215e-06 L=5e-07
X_i_7_2 net_2_2 A4 VDD VNW pfet_05v0 W=1.215e-06 L=5e-07
X_i_6_2 net_1 A3 net_2_2 VNW pfet_05v0 W=1.215e-06 L=5e-07
X_i_6_1 net_2_1 A3 net_1 VNW pfet_05v0 W=1.215e-06 L=5e-07
X_i_7_1 VDD A4 net_2_1 VNW pfet_05v0 W=1.215e-06 L=5e-07
X_i_7_0 net_2_0 A4 VDD VNW pfet_05v0 W=1.215e-06 L=5e-07
X_i_6_0 net_1_0 A3 net_2_0 VNW pfet_05v0 W=1.215e-06 L=5e-07
X_i_5_3 net_0_3 A2 net_1_0 VNW pfet_05v0 W=1.215e-06 L=5e-07
X_i_4_3 ZN A1 net_0_3 VNW pfet_05v0 W=1.215e-06 L=5e-07
X_i_4_2 net_0_2 A1 ZN VNW pfet_05v0 W=1.215e-06 L=5e-07
X_i_5_2 net_1 A2 net_0_2 VNW pfet_05v0 W=1.215e-06 L=5e-07
X_i_5_1 net_0_1 A2 net_1 VNW pfet_05v0 W=1.215e-06 L=5e-07
X_i_4_1 ZN A1 net_0_1 VNW pfet_05v0 W=1.215e-06 L=5e-07
X_i_4_0 net_0_0 A1 ZN VNW pfet_05v0 W=1.215e-06 L=5e-07
X_i_5_0 net_1 A2 net_0_0 VNW pfet_05v0 W=1.215e-06 L=5e-07
.ENDS

.SUBCKT gf180mcu_fd_sc_mcu7t5v0__oai31_2 A1 A2 A3 B ZN VDD VNW VPW VSS
X_i_3_1 VSS B net_0 VPW nfet_05v0 W=8.2e-07 L=6e-07
X_i_3_0 net_0 B VSS VPW nfet_05v0 W=8.2e-07 L=6e-07
X_i_2_1 ZN A3 net_0 VPW nfet_05v0 W=8.2e-07 L=6e-07
X_i_1_1 net_0 A2 ZN VPW nfet_05v0 W=8.2e-07 L=6e-07
X_i_0_1 ZN A1 net_0 VPW nfet_05v0 W=8.2e-07 L=6e-07
X_i_0_0 net_0 A1 ZN VPW nfet_05v0 W=8.2e-07 L=6e-07
X_i_1_0 ZN A2 net_0 VPW nfet_05v0 W=8.2e-07 L=6e-07
X_i_2_0 net_0 A3 ZN VPW nfet_05v0 W=8.2e-07 L=6e-07
X_i_7_1 ZN B VDD VNW pfet_05v0 W=1.08e-06 L=5e-07
X_i_7_0 VDD B ZN VNW pfet_05v0 W=1.08e-06 L=5e-07
X_i_6_1 net_2_0 A3 VDD VNW pfet_05v0 W=1.095e-06 L=5e-07
X_i_5_1 net_1_0 A2 net_2_0 VNW pfet_05v0 W=1.095e-06 L=5e-07
X_i_4_1 ZN A1 net_1_0 VNW pfet_05v0 W=1.095e-06 L=5e-07
X_i_4_0 net_1_1 A1 ZN VNW pfet_05v0 W=1.095e-06 L=5e-07
X_i_5_0 net_2_1 A2 net_1_1 VNW pfet_05v0 W=1.095e-06 L=5e-07
X_i_6_0 VDD A3 net_2_1 VNW pfet_05v0 W=1.095e-06 L=5e-07
.ENDS

.SUBCKT gf180mcu_fd_sc_mcu7t5v0__xnor2_1 A1 A2 ZN VDD VNW VPW VSS
X_i_6 net_2 A2 I VPW nfet_05v0 W=3.6e-07 L=6e-07
X_i_7 VSS A1 net_2 VPW nfet_05v0 W=3.6e-07 L=6e-07
X_i_2 net_0 I VSS VPW nfet_05v0 W=8.2e-07 L=6e-07
X_i_0 ZN A1 net_0 VPW nfet_05v0 W=8.2e-07 L=6e-07
X_i_1 net_0 A2 ZN VPW nfet_05v0 W=8.2e-07 L=6e-07
X_i_8 I A2 VDD VNW pfet_05v0 W=5.6e-07 L=5e-07
X_i_9 VDD A1 I VNW pfet_05v0 W=5.6e-07 L=5e-07
X_i_5 ZN I VDD VNW pfet_05v0 W=1.095e-06 L=5e-07
X_i_3 net_1 A1 ZN VNW pfet_05v0 W=1.095e-06 L=5e-07
X_i_4 VDD A2 net_1 VNW pfet_05v0 W=1.095e-06 L=5e-07
.ENDS

.SUBCKT gf180mcu_fd_sc_mcu7t5v0__nand3_2 A1 A2 A3 ZN VDD VNW VPW VSS
X_i_2_1 net_1_0 A3 VSS VPW nfet_05v0 W=8.2e-07 L=6e-07
X_i_1_0 net_0_0 A2 net_1_0 VPW nfet_05v0 W=8.2e-07 L=6e-07
X_i_0_0 ZN A1 net_0_0 VPW nfet_05v0 W=8.2e-07 L=6e-07
X_i_0_1 net_0_1 A1 ZN VPW nfet_05v0 W=8.2e-07 L=6e-07
X_i_1_1 net_1_1 A2 net_0_1 VPW nfet_05v0 W=8.2e-07 L=6e-07
X_i_2_0 VSS A3 net_1_1 VPW nfet_05v0 W=8.2e-07 L=6e-07
X_i_5_1 ZN A3 VDD VNW pfet_05v0 W=9.85e-07 L=5e-07
X_i_4_0 VDD A2 ZN VNW pfet_05v0 W=9.85e-07 L=5e-07
X_i_3_0 ZN A1 VDD VNW pfet_05v0 W=9.85e-07 L=5e-07
X_i_3_1 VDD A1 ZN VNW pfet_05v0 W=9.85e-07 L=5e-07
X_i_4_1 ZN A2 VDD VNW pfet_05v0 W=9.85e-07 L=5e-07
X_i_5_0 VDD A3 ZN VNW pfet_05v0 W=9.85e-07 L=5e-07
.ENDS

.SUBCKT gf180mcu_fd_sc_mcu7t5v0__aoi21_4 A1 A2 B ZN VDD VNW VPW VSS
X_i_1_3 net_0_0 A2 VSS VPW nfet_05v0 W=8.2e-07 L=6e-07
X_i_0_3 ZN A1 net_0_0 VPW nfet_05v0 W=8.2e-07 L=6e-07
X_i_0_2 net_0_1 A1 ZN VPW nfet_05v0 W=8.2e-07 L=6e-07
X_i_1_2 VSS A2 net_0_1 VPW nfet_05v0 W=8.2e-07 L=6e-07
X_i_1_1 net_0_2 A2 VSS VPW nfet_05v0 W=8.2e-07 L=6e-07
X_i_0_1 ZN A1 net_0_2 VPW nfet_05v0 W=8.2e-07 L=6e-07
X_i_0_0 net_0_3 A1 ZN VPW nfet_05v0 W=8.2e-07 L=6e-07
X_i_1_0 VSS A2 net_0_3 VPW nfet_05v0 W=8.2e-07 L=6e-07
X_i_2_3 ZN B VSS VPW nfet_05v0 W=5.1e-07 L=6e-07
X_i_2_2 VSS B ZN VPW nfet_05v0 W=5.1e-07 L=6e-07
X_i_2_1 ZN B VSS VPW nfet_05v0 W=5.1e-07 L=6e-07
X_i_2_0 VSS B ZN VPW nfet_05v0 W=5.1e-07 L=6e-07
X_i_4_3 ZN A2 net_1 VNW pfet_05v0 W=1.2e-06 L=5e-07
X_i_3_3 net_1 A1 ZN VNW pfet_05v0 W=1.2e-06 L=5e-07
X_i_3_2 ZN A1 net_1 VNW pfet_05v0 W=1.2e-06 L=5e-07
X_i_4_2 net_1 A2 ZN VNW pfet_05v0 W=1.2e-06 L=5e-07
X_i_4_1 ZN A2 net_1 VNW pfet_05v0 W=1.2e-06 L=5e-07
X_i_3_1 net_1 A1 ZN VNW pfet_05v0 W=1.2e-06 L=5e-07
X_i_3_0 ZN A1 net_1 VNW pfet_05v0 W=1.2e-06 L=5e-07
X_i_4_0 net_1 A2 ZN VNW pfet_05v0 W=1.2e-06 L=5e-07
X_i_5_3 VDD B net_1 VNW pfet_05v0 W=1.2e-06 L=5e-07
X_i_5_2 net_1 B VDD VNW pfet_05v0 W=1.2e-06 L=5e-07
X_i_5_1 VDD B net_1 VNW pfet_05v0 W=1.2e-06 L=5e-07
X_i_5_0 net_1 B VDD VNW pfet_05v0 W=1.2e-06 L=5e-07
.ENDS

.SUBCKT gf180mcu_fd_sc_mcu7t5v0__oai21_4 A1 A2 B ZN VDD VNW VPW VSS
X_i_1_3 ZN A2 net_0 VPW nfet_05v0 W=8.2e-07 L=6e-07
X_i_0_3 net_0 A1 ZN VPW nfet_05v0 W=8.2e-07 L=6e-07
X_i_0_2 ZN A1 net_0 VPW nfet_05v0 W=8.2e-07 L=6e-07
X_i_1_2 net_0 A2 ZN VPW nfet_05v0 W=8.2e-07 L=6e-07
X_i_1_1 ZN A2 net_0 VPW nfet_05v0 W=8.2e-07 L=6e-07
X_i_0_1 net_0 A1 ZN VPW nfet_05v0 W=8.2e-07 L=6e-07
X_i_0_0 ZN A1 net_0 VPW nfet_05v0 W=8.2e-07 L=6e-07
X_i_1_0 net_0 A2 ZN VPW nfet_05v0 W=8.2e-07 L=6e-07
X_i_2_3 VSS B net_0 VPW nfet_05v0 W=8.2e-07 L=6e-07
X_i_2_2 net_0 B VSS VPW nfet_05v0 W=8.2e-07 L=6e-07
X_i_2_1 VSS B net_0 VPW nfet_05v0 W=8.2e-07 L=6e-07
X_i_2_0 net_0 B VSS VPW nfet_05v0 W=8.2e-07 L=6e-07
X_i_4_3 net_1_0 A2 VDD VNW pfet_05v0 W=1.095e-06 L=5e-07
X_i_3_3 ZN A1 net_1_0 VNW pfet_05v0 W=1.095e-06 L=5e-07
X_i_3_2 net_1_1 A1 ZN VNW pfet_05v0 W=1.095e-06 L=5e-07
X_i_4_2 VDD A2 net_1_1 VNW pfet_05v0 W=1.095e-06 L=5e-07
X_i_4_1 net_1_2 A2 VDD VNW pfet_05v0 W=1.095e-06 L=5e-07
X_i_3_1 ZN A1 net_1_2 VNW pfet_05v0 W=1.095e-06 L=5e-07
X_i_3_0 net_1_3 A1 ZN VNW pfet_05v0 W=1.095e-06 L=5e-07
X_i_4_0 VDD A2 net_1_3 VNW pfet_05v0 W=1.095e-06 L=5e-07
X_i_5_3 ZN B VDD VNW pfet_05v0 W=9.55e-07 L=5e-07
X_i_5_2 VDD B ZN VNW pfet_05v0 W=9.55e-07 L=5e-07
X_i_5_1 ZN B VDD VNW pfet_05v0 W=9.55e-07 L=5e-07
X_i_5_0 VDD B ZN VNW pfet_05v0 W=9.55e-07 L=5e-07
.ENDS

.SUBCKT gf180mcu_fd_sc_mcu7t5v0__or3_1 A1 A2 A3 Z VDD VNW VPW VSS
X_i_2 VSS A1 Z_neg VPW nfet_05v0 W=4e-07 L=6e-07
X_i_3 Z_neg A2 VSS VPW nfet_05v0 W=4e-07 L=6e-07
X_i_4 VSS A3 Z_neg VPW nfet_05v0 W=4e-07 L=6e-07
X_i_0 Z Z_neg VSS VPW nfet_05v0 W=8.2e-07 L=6e-07
X_i_5 net_0 A1 Z_neg VNW pfet_05v0 W=5.6e-07 L=5e-07
X_i_6 net_1 A2 net_0 VNW pfet_05v0 W=5.6e-07 L=5e-07
X_i_7 VDD A3 net_1 VNW pfet_05v0 W=5.6e-07 L=5e-07
X_i_1 Z Z_neg VDD VNW pfet_05v0 W=1.22e-06 L=5e-07
.ENDS

.SUBCKT gf180mcu_fd_sc_mcu7t5v0__or4_4 A1 A2 A3 A4 Z VDD VNW VPW VSS
X_i_5_1_x2_1 Z_neg A4 VSS VPW nfet_05v0 W=4.65e-07 L=6e-07
X_i_4_1_x2_1 VSS A3 Z_neg VPW nfet_05v0 W=4.65e-07 L=6e-07
X_i_3_1_x2_1 Z_neg A2 VSS VPW nfet_05v0 W=4.65e-07 L=6e-07
X_i_2_1_x2_1 VSS A1 Z_neg VPW nfet_05v0 W=4.65e-07 L=6e-07
X_i_2_1_x2_0 Z_neg A1 VSS VPW nfet_05v0 W=4.65e-07 L=6e-07
X_i_3_1_x2_0 VSS A2 Z_neg VPW nfet_05v0 W=4.65e-07 L=6e-07
X_i_4_1_x2_0 Z_neg A3 VSS VPW nfet_05v0 W=4.65e-07 L=6e-07
X_i_5_1_x2_0 VSS A4 Z_neg VPW nfet_05v0 W=4.65e-07 L=6e-07
X_i_0_3_x4_3 Z Z_neg VSS VPW nfet_05v0 W=8.2e-07 L=6e-07
X_i_0_3_x4_2 VSS Z_neg Z VPW nfet_05v0 W=8.2e-07 L=6e-07
X_i_0_3_x4_1 Z Z_neg VSS VPW nfet_05v0 W=8.2e-07 L=6e-07
X_i_0_3_x4_0 VSS Z_neg Z VPW nfet_05v0 W=8.2e-07 L=6e-07
X_i_9_0_m2_1 net_2_0_1 A4 VDD VNW pfet_05v0 W=1.22e-06 L=5e-07
X_i_8_0_m2_1 net_1_0_1 A3 net_2_0_1 VNW pfet_05v0 W=1.22e-06 L=5e-07
X_i_7_0_m2_1 net_0_0_1 A2 net_1_0_1 VNW pfet_05v0 W=1.22e-06 L=5e-07
X_i_6_0_m2_1 Z_neg A1 net_0_0_1 VNW pfet_05v0 W=1.22e-06 L=5e-07
X_i_6_0_m2_0 net_0_0_0 A1 Z_neg VNW pfet_05v0 W=1.22e-06 L=5e-07
X_i_7_0_m2_0 net_1_0_0 A2 net_0_0_0 VNW pfet_05v0 W=1.22e-06 L=5e-07
X_i_8_0_m2_0 net_2_0_0 A3 net_1_0_0 VNW pfet_05v0 W=1.22e-06 L=5e-07
X_i_9_0_m2_0 VDD A4 net_2_0_0 VNW pfet_05v0 W=1.22e-06 L=5e-07
X_i_1_3_x4_3 Z Z_neg VDD VNW pfet_05v0 W=1.22e-06 L=5e-07
X_i_1_3_x4_2 VDD Z_neg Z VNW pfet_05v0 W=1.22e-06 L=5e-07
X_i_1_3_x4_1 Z Z_neg VDD VNW pfet_05v0 W=1.22e-06 L=5e-07
X_i_1_3_x4_0 VDD Z_neg Z VNW pfet_05v0 W=1.22e-06 L=5e-07
.ENDS

.SUBCKT gf180mcu_fd_sc_mcu7t5v0__oai31_4 A1 A2 A3 B ZN VDD VNW VPW VSS
X_i_2_3 ZN A3 net_0 VPW nfet_05v0 W=8.2e-07 L=6e-07
X_i_2_2 net_0 A3 ZN VPW nfet_05v0 W=8.2e-07 L=6e-07
X_i_2_1 ZN A3 net_0 VPW nfet_05v0 W=8.2e-07 L=6e-07
X_i_2_0 net_0 A3 ZN VPW nfet_05v0 W=8.2e-07 L=6e-07
X_i_1_3 ZN A2 net_0 VPW nfet_05v0 W=8.2e-07 L=6e-07
X_i_0_3 net_0 A1 ZN VPW nfet_05v0 W=8.2e-07 L=6e-07
X_i_0_2 ZN A1 net_0 VPW nfet_05v0 W=8.2e-07 L=6e-07
X_i_1_2 net_0 A2 ZN VPW nfet_05v0 W=8.2e-07 L=6e-07
X_i_1_1 ZN A2 net_0 VPW nfet_05v0 W=8.2e-07 L=6e-07
X_i_0_1 net_0 A1 ZN VPW nfet_05v0 W=8.2e-07 L=6e-07
X_i_0_0 ZN A1 net_0 VPW nfet_05v0 W=8.2e-07 L=6e-07
X_i_1_0 net_0 A2 ZN VPW nfet_05v0 W=8.2e-07 L=6e-07
X_i_3_3 VSS B net_0 VPW nfet_05v0 W=8.2e-07 L=6e-07
X_i_3_2 net_0 B VSS VPW nfet_05v0 W=8.2e-07 L=6e-07
X_i_3_1 VSS B net_0 VPW nfet_05v0 W=8.2e-07 L=6e-07
X_i_3_0 net_0 B VSS VPW nfet_05v0 W=8.2e-07 L=6e-07
X_i_6_3 VDD A3 net_2 VNW pfet_05v0 W=1.095e-06 L=5e-07
X_i_6_2 net_2 A3 VDD VNW pfet_05v0 W=1.095e-06 L=5e-07
X_i_6_1 VDD A3 net_2 VNW pfet_05v0 W=1.095e-06 L=5e-07
X_i_6_0 net_2_0 A3 VDD VNW pfet_05v0 W=1.095e-06 L=5e-07
X_i_5_3 net_1_0 A2 net_2_0 VNW pfet_05v0 W=1.095e-06 L=5e-07
X_i_4_3 ZN A1 net_1_0 VNW pfet_05v0 W=1.095e-06 L=5e-07
X_i_4_2 net_1_1 A1 ZN VNW pfet_05v0 W=1.095e-06 L=5e-07
X_i_5_2 net_2 A2 net_1_1 VNW pfet_05v0 W=1.095e-06 L=5e-07
X_i_5_1 net_1_2 A2 net_2 VNW pfet_05v0 W=1.095e-06 L=5e-07
X_i_4_1 ZN A1 net_1_2 VNW pfet_05v0 W=1.095e-06 L=5e-07
X_i_4_0 net_1_3 A1 ZN VNW pfet_05v0 W=1.095e-06 L=5e-07
X_i_5_0 net_2 A2 net_1_3 VNW pfet_05v0 W=1.095e-06 L=5e-07
X_i_7_3 ZN B VDD VNW pfet_05v0 W=1.095e-06 L=5e-07
X_i_7_2 VDD B ZN VNW pfet_05v0 W=1.095e-06 L=5e-07
X_i_7_1 ZN B VDD VNW pfet_05v0 W=1.095e-06 L=5e-07
X_i_7_0 VDD B ZN VNW pfet_05v0 W=1.095e-06 L=5e-07
.ENDS

.SUBCKT gf180mcu_fd_sc_mcu7t5v0__aoi211_4 A1 A2 B C ZN VDD VNW VPW VSS
X_i_1_3 net_0_0 A2 VSS VPW nfet_05v0 W=7.7e-07 L=6e-07
X_i_0_3 ZN A1 net_0_0 VPW nfet_05v0 W=7.7e-07 L=6e-07
X_i_0_2 net_0_1 A1 ZN VPW nfet_05v0 W=7.7e-07 L=6e-07
X_i_1_2 VSS A2 net_0_1 VPW nfet_05v0 W=7.7e-07 L=6e-07
X_i_1_1 net_0_2 A2 VSS VPW nfet_05v0 W=7.7e-07 L=6e-07
X_i_0_1 ZN A1 net_0_2 VPW nfet_05v0 W=7.7e-07 L=6e-07
X_i_0_0 net_0_3 A1 ZN VPW nfet_05v0 W=7.7e-07 L=6e-07
X_i_1_0 VSS A2 net_0_3 VPW nfet_05v0 W=7.7e-07 L=6e-07
X_i_2_0 ZN B VSS VPW nfet_05v0 W=4.6e-07 L=6e-07
X_i_3_0 VSS C ZN VPW nfet_05v0 W=4.6e-07 L=6e-07
X_i_3_1 ZN C VSS VPW nfet_05v0 W=4.6e-07 L=6e-07
X_i_2_1 VSS B ZN VPW nfet_05v0 W=4.6e-07 L=6e-07
X_i_2_2 ZN B VSS VPW nfet_05v0 W=4.6e-07 L=6e-07
X_i_3_2 VSS C ZN VPW nfet_05v0 W=4.6e-07 L=6e-07
X_i_3_3 ZN C VSS VPW nfet_05v0 W=4.6e-07 L=6e-07
X_i_2_3 VSS B ZN VPW nfet_05v0 W=4.6e-07 L=6e-07
X_i_5_3 ZN A2 net_1 VNW pfet_05v0 W=1.22e-06 L=5e-07
X_i_4_3 net_1 A1 ZN VNW pfet_05v0 W=1.22e-06 L=5e-07
X_i_4_2 ZN A1 net_1 VNW pfet_05v0 W=1.22e-06 L=5e-07
X_i_5_2 net_1 A2 ZN VNW pfet_05v0 W=1.22e-06 L=5e-07
X_i_5_1 ZN A2 net_1 VNW pfet_05v0 W=1.22e-06 L=5e-07
X_i_4_1 net_1 A1 ZN VNW pfet_05v0 W=1.22e-06 L=5e-07
X_i_4_0 ZN A1 net_1 VNW pfet_05v0 W=1.22e-06 L=5e-07
X_i_5_0 net_1 A2 ZN VNW pfet_05v0 W=1.22e-06 L=5e-07
X_i_6_0 net_2_0 B net_1 VNW pfet_05v0 W=1.22e-06 L=5e-07
X_i_7_0 VDD C net_2_0 VNW pfet_05v0 W=1.22e-06 L=5e-07
X_i_7_1 net_2_1 C VDD VNW pfet_05v0 W=1.22e-06 L=5e-07
X_i_6_1 net_1 B net_2_1 VNW pfet_05v0 W=1.22e-06 L=5e-07
X_i_6_2 net_2_2 B net_1 VNW pfet_05v0 W=1.22e-06 L=5e-07
X_i_7_2 VDD C net_2_2 VNW pfet_05v0 W=1.22e-06 L=5e-07
X_i_7_3 net_2_3 C VDD VNW pfet_05v0 W=1.22e-06 L=5e-07
X_i_6_3 net_1 B net_2_3 VNW pfet_05v0 W=1.22e-06 L=5e-07
.ENDS

.SUBCKT gf180mcu_fd_sc_mcu7t5v0__xor3_1 A1 A2 A3 Z VDD VNW VPW VSS
X_i_12 I A2 VSS VPW nfet_05v0 W=3.6e-07 L=6e-07
X_i_13 VSS A1 I VPW nfet_05v0 W=3.6e-07 L=6e-07
X_i_2 I2 I VSS VPW nfet_05v0 W=3.6e-07 L=6e-07
X_i_0 net_0 A1 I2 VPW nfet_05v0 W=3.6e-07 L=6e-07
X_i_1 VSS A2 net_0 VPW nfet_05v0 W=3.6e-07 L=6e-07
X_i_16 I3 I2 VSS VPW nfet_05v0 W=3.6e-07 L=6e-07
X_i_17 VSS A3 I3 VPW nfet_05v0 W=3.6e-07 L=6e-07
X_i_8 Z I3 VSS VPW nfet_05v0 W=8.2e-07 L=6e-07
X_i_6 net_2 A3 Z VPW nfet_05v0 W=8.2e-07 L=6e-07
X_i_7 VSS I2 net_2 VPW nfet_05v0 W=8.2e-07 L=6e-07
X_i_14 net_4 A2 I VNW pfet_05v0 W=3.6e-07 L=5e-07
X_i_15 VDD A1 net_4 VNW pfet_05v0 W=3.6e-07 L=5e-07
X_i_5 net_1 I VDD VNW pfet_05v0 W=5.65e-07 L=5e-07
X_i_3 I2 A1 net_1 VNW pfet_05v0 W=5.65e-07 L=5e-07
X_i_4 net_1 A2 I2 VNW pfet_05v0 W=5.65e-07 L=5e-07
X_i_18 net_5 I2 I3 VNW pfet_05v0 W=5.65e-07 L=5e-07
X_i_19 VDD A3 net_5 VNW pfet_05v0 W=5.65e-07 L=5e-07
X_i_11 net_3 I3 VDD VNW pfet_05v0 W=1.22e-06 L=5e-07
X_i_9 Z A3 net_3 VNW pfet_05v0 W=1.22e-06 L=5e-07
X_i_10 net_3 I2 Z VNW pfet_05v0 W=1.22e-06 L=5e-07
.ENDS

.SUBCKT gf180mcu_fd_sc_mcu7t5v0__oai22_2 A1 A2 B1 B2 ZN VDD VNW VPW VSS
X_i_3_1 VSS B2 net_0 VPW nfet_05v0 W=8.2e-07 L=6e-07
X_i_2_1 net_0 B1 VSS VPW nfet_05v0 W=8.2e-07 L=6e-07
X_i_2_0 VSS B1 net_0 VPW nfet_05v0 W=8.2e-07 L=6e-07
X_i_3_0 net_0 B2 VSS VPW nfet_05v0 W=8.2e-07 L=6e-07
X_i_1_1 ZN A2 net_0 VPW nfet_05v0 W=8.2e-07 L=6e-07
X_i_0_1 net_0 A1 ZN VPW nfet_05v0 W=8.2e-07 L=6e-07
X_i_0_0 ZN A1 net_0 VPW nfet_05v0 W=8.2e-07 L=6e-07
X_i_1_0 net_0 A2 ZN VPW nfet_05v0 W=8.2e-07 L=6e-07
X_i_7_1 net_2_0 B2 VDD VNW pfet_05v0 W=1.095e-06 L=5e-07
X_i_6_1 ZN B1 net_2_0 VNW pfet_05v0 W=1.095e-06 L=5e-07
X_i_6_0 net_2_1 B1 ZN VNW pfet_05v0 W=1.095e-06 L=5e-07
X_i_7_0 VDD B2 net_2_1 VNW pfet_05v0 W=1.095e-06 L=5e-07
X_i_5_1 net_1_0 A2 VDD VNW pfet_05v0 W=1.095e-06 L=5e-07
X_i_4_1 ZN A1 net_1_0 VNW pfet_05v0 W=1.095e-06 L=5e-07
X_i_4_0 net_1_1 A1 ZN VNW pfet_05v0 W=1.095e-06 L=5e-07
X_i_5_0 VDD A2 net_1_1 VNW pfet_05v0 W=1.095e-06 L=5e-07
.ENDS

.SUBCKT gf180mcu_fd_sc_mcu7t5v0__and2_4 A1 A2 Z VDD VNW VPW VSS
X_i_3_1 net_0_1 A2 VSS VPW nfet_05v0 W=7.75e-07 L=6e-07
X_i_2_1 Z_neg A1 net_0_1 VPW nfet_05v0 W=7.75e-07 L=6e-07
X_i_2_0 net_0_0 A1 Z_neg VPW nfet_05v0 W=7.75e-07 L=6e-07
X_i_3_0 VSS A2 net_0_0 VPW nfet_05v0 W=7.75e-07 L=6e-07
X_i_0_3 Z Z_neg VSS VPW nfet_05v0 W=7.75e-07 L=6e-07
X_i_0_2 VSS Z_neg Z VPW nfet_05v0 W=7.75e-07 L=6e-07
X_i_0_1 Z Z_neg VSS VPW nfet_05v0 W=7.75e-07 L=6e-07
X_i_0_0 VSS Z_neg Z VPW nfet_05v0 W=7.75e-07 L=6e-07
X_i_5_1 Z_neg A2 VDD VNW pfet_05v0 W=1.125e-06 L=5e-07
X_i_4_1 VDD A1 Z_neg VNW pfet_05v0 W=1.125e-06 L=5e-07
X_i_4_0 Z_neg A1 VDD VNW pfet_05v0 W=1.125e-06 L=5e-07
X_i_5_0 VDD A2 Z_neg VNW pfet_05v0 W=1.125e-06 L=5e-07
X_i_1_3 Z Z_neg VDD VNW pfet_05v0 W=1.215e-06 L=5e-07
X_i_1_2 VDD Z_neg Z VNW pfet_05v0 W=1.215e-06 L=5e-07
X_i_1_1 Z Z_neg VDD VNW pfet_05v0 W=1.215e-06 L=5e-07
X_i_1_0 VDD Z_neg Z VNW pfet_05v0 W=1.215e-06 L=5e-07
.ENDS

.SUBCKT gf180mcu_fd_sc_mcu7t5v0__and2_2 A1 A2 Z VDD VNW VPW VSS
X_i_2 net_0 A1 Z_neg VPW nfet_05v0 W=8.15e-07 L=6e-07
X_i_3 VSS A2 net_0 VPW nfet_05v0 W=8.15e-07 L=6e-07
X_i_0_0 Z Z_neg VSS VPW nfet_05v0 W=8.15e-07 L=6e-07
X_i_0_1 VSS Z_neg Z VPW nfet_05v0 W=8.15e-07 L=6e-07
X_i_4 Z_neg A1 VDD VNW pfet_05v0 W=1.07e-06 L=5e-07
X_i_5 VDD A2 Z_neg VNW pfet_05v0 W=1.07e-06 L=5e-07
X_i_1_0 Z Z_neg VDD VNW pfet_05v0 W=1.215e-06 L=5e-07
X_i_1_1 VDD Z_neg Z VNW pfet_05v0 W=1.215e-06 L=5e-07
.ENDS

.SUBCKT gf180mcu_fd_sc_mcu7t5v0__and3_1 A1 A2 A3 Z VDD VNW VPW VSS
X_i_2 net_0 A1 Z_neg VPW nfet_05v0 W=3.8e-07 L=6e-07
X_i_3 net_1 A2 net_0 VPW nfet_05v0 W=3.8e-07 L=6e-07
X_i_4 VSS A3 net_1 VPW nfet_05v0 W=3.8e-07 L=6e-07
X_i_0 Z Z_neg VSS VPW nfet_05v0 W=7.75e-07 L=6e-07
X_i_5 VDD A1 Z_neg VNW pfet_05v0 W=5.35e-07 L=5e-07
X_i_6 Z_neg A2 VDD VNW pfet_05v0 W=5.35e-07 L=5e-07
X_i_7 VDD A3 Z_neg VNW pfet_05v0 W=5.35e-07 L=5e-07
X_i_1 Z Z_neg VDD VNW pfet_05v0 W=1.215e-06 L=5e-07
.ENDS

.SUBCKT gf180mcu_fd_sc_mcu7t5v0__oai211_1 A1 A2 B C ZN VDD VNW VPW VSS
X_i_1 ZN A2 net_0 VPW nfet_05v0 W=8.2e-07 L=6e-07
X_i_0 net_0 A1 ZN VPW nfet_05v0 W=8.2e-07 L=6e-07
X_i_2 net_1 B net_0 VPW nfet_05v0 W=8.2e-07 L=6e-07
X_i_3 VSS C net_1 VPW nfet_05v0 W=8.2e-07 L=6e-07
X_i_5 net_2 A2 VDD VNW pfet_05v0 W=1.22e-06 L=5e-07
X_i_4 ZN A1 net_2 VNW pfet_05v0 W=1.22e-06 L=5e-07
X_i_6 VDD B ZN VNW pfet_05v0 W=9.85e-07 L=5e-07
X_i_7 ZN C VDD VNW pfet_05v0 W=9.85e-07 L=5e-07
.ENDS

.SUBCKT gf180mcu_fd_sc_mcu7t5v0__nand4_2 A1 A2 A3 A4 ZN VDD VNW VPW VSS
X_i_3_0 net_2_0 A4 VSS VPW nfet_05v0 W=8.2e-07 L=6e-07
X_i_2_0 net_1_0 A3 net_2_0 VPW nfet_05v0 W=8.2e-07 L=6e-07
X_i_1_0 net_0_0 A2 net_1_0 VPW nfet_05v0 W=8.2e-07 L=6e-07
X_i_0_0 ZN A1 net_0_0 VPW nfet_05v0 W=8.2e-07 L=6e-07
X_i_0_1 net_0_1 A1 ZN VPW nfet_05v0 W=8.2e-07 L=6e-07
X_i_1_1 net_1_1 A2 net_0_1 VPW nfet_05v0 W=8.2e-07 L=6e-07
X_i_2_1 net_2_1 A3 net_1_1 VPW nfet_05v0 W=8.2e-07 L=6e-07
X_i_3_1 VSS A4 net_2_1 VPW nfet_05v0 W=8.2e-07 L=6e-07
X_i_7_0 VDD A4 ZN VNW pfet_05v0 W=8.45e-07 L=5e-07
X_i_6_0 ZN A3 VDD VNW pfet_05v0 W=8.45e-07 L=5e-07
X_i_5_0 VDD A2 ZN VNW pfet_05v0 W=8.45e-07 L=5e-07
X_i_4_0 ZN A1 VDD VNW pfet_05v0 W=8.45e-07 L=5e-07
X_i_4_1 VDD A1 ZN VNW pfet_05v0 W=8.45e-07 L=5e-07
X_i_5_1 ZN A2 VDD VNW pfet_05v0 W=8.45e-07 L=5e-07
X_i_6_1 VDD A3 ZN VNW pfet_05v0 W=8.45e-07 L=5e-07
X_i_7_1 ZN A4 VDD VNW pfet_05v0 W=8.45e-07 L=5e-07
.ENDS

.SUBCKT gf180mcu_fd_sc_mcu7t5v0__or4_1 A1 A2 A3 A4 Z VDD VNW VPW VSS
X_i_2 Z_neg A1 VSS VPW nfet_05v0 W=3.6e-07 L=6e-07
X_i_3 VSS A2 Z_neg VPW nfet_05v0 W=3.6e-07 L=6e-07
X_i_4 Z_neg A3 VSS VPW nfet_05v0 W=3.6e-07 L=6e-07
X_i_5 VSS A4 Z_neg VPW nfet_05v0 W=3.6e-07 L=6e-07
X_i_0 Z Z_neg VSS VPW nfet_05v0 W=8.2e-07 L=6e-07
X_i_6 net_0 A1 Z_neg VNW pfet_05v0 W=5.6e-07 L=5e-07
X_i_7 net_1 A2 net_0 VNW pfet_05v0 W=5.6e-07 L=5e-07
X_i_8 net_2 A3 net_1 VNW pfet_05v0 W=5.6e-07 L=5e-07
X_i_9 VDD A4 net_2 VNW pfet_05v0 W=5.6e-07 L=5e-07
X_i_1 Z Z_neg VDD VNW pfet_05v0 W=1.22e-06 L=5e-07
.ENDS

.SUBCKT gf180mcu_fd_sc_mcu7t5v0__mux2_2 I0 I1 S Z VDD VNW VPW VSS
X_MN2_12 VSS int04 Z VPW nfet_05v0 W=8.2e-07 L=6e-07
X_MN2 VSS int04 Z VPW nfet_05v0 W=8.2e-07 L=6e-07
X_MN4 net_1 I1 VSS VPW nfet_05v0 W=8.2e-07 L=6e-07
X_MN8 int04 S net_1 VPW nfet_05v0 W=8.2e-07 L=6e-07
X_MN7 net_3 sel1_n int04 VPW nfet_05v0 W=8.2e-07 L=6e-07
X_MN3 VSS I0 net_3 VPW nfet_05v0 W=8.2e-07 L=6e-07
X_MN1 sel1_n S VSS VPW nfet_05v0 W=8.2e-07 L=6e-07
X_MP5_6 VDD int04 Z VNW pfet_05v0 W=1.22e-06 L=5e-07
X_MP5 VDD int04 Z VNW pfet_05v0 W=1.22e-06 L=5e-07
X_MP4 net_0 I1 VDD VNW pfet_05v0 W=1.22e-06 L=5e-07
X_MP8 int04 sel1_n net_0 VNW pfet_05v0 W=1.22e-06 L=5e-07
X_MP7 net_2 S int04 VNW pfet_05v0 W=1.22e-06 L=5e-07
X_MP3 VDD I0 net_2 VNW pfet_05v0 W=1.22e-06 L=5e-07
X_MP1 sel1_n S VDD VNW pfet_05v0 W=1.22e-06 L=5e-07
.ENDS

.SUBCKT gf180mcu_fd_sc_mcu7t5v0__aoi222_1 A1 A2 B1 B2 C1 C2 ZN VDD VNW VPW VSS
X_i_5 net_2 C2 VSS VPW nfet_05v0 W=8.2e-07 L=6e-07
X_i_4 ZN C1 net_2 VPW nfet_05v0 W=8.2e-07 L=6e-07
X_i_2 net_1 B1 ZN VPW nfet_05v0 W=8.2e-07 L=6e-07
X_i_3 VSS B2 net_1 VPW nfet_05v0 W=8.2e-07 L=6e-07
X_i_1 net_0 A2 VSS VPW nfet_05v0 W=8.2e-07 L=6e-07
X_i_0 ZN A1 net_0 VPW nfet_05v0 W=8.2e-07 L=6e-07
X_i_11 net_4 C2 VDD VNW pfet_05v0 W=1.16e-06 L=5e-07
X_i_10 VDD C1 net_4 VNW pfet_05v0 W=1.16e-06 L=5e-07
X_i_8 net_4 B1 net_3 VNW pfet_05v0 W=1.16e-06 L=5e-07
X_i_9 net_3 B2 net_4 VNW pfet_05v0 W=1.16e-06 L=5e-07
X_i_7 ZN A2 net_3 VNW pfet_05v0 W=1.16e-06 L=5e-07
X_i_6 net_3 A1 ZN VNW pfet_05v0 W=1.16e-06 L=5e-07
.ENDS

.SUBCKT gf180mcu_fd_sc_mcu7t5v0__dffrnq_1 D RN CLK Q VDD VNW VPW VSS
X_tn10 ncki CLK VSS VPW nfet_05v0 W=4.05e-07 L=6e-07
X_tn13 cki ncki VSS VPW nfet_05v0 W=4.05e-07 L=6e-07
X_tn11 net10 D VSS VPW nfet_05v0 W=3.6e-07 L=6e-07
X_tn15 net10 ncki net1 VPW nfet_05v0 W=3.6e-07 L=6e-07
X_tn14 net1 cki net15 VPW nfet_05v0 W=3.6e-07 L=6e-07
X_tn8 net12 net2 net15 VPW nfet_05v0 W=3.6e-07 L=6e-07
X_tn9 VSS RN net12 VPW nfet_05v0 W=3.6e-07 L=6e-07
X_tn18 VSS net1 net2 VPW nfet_05v0 W=3.6e-07 L=6e-07
X_tn0 net8 cki net2 VPW nfet_05v0 W=3.6e-07 L=6e-07
X_tn1 net11 ncki net8 VPW nfet_05v0 W=3.6e-07 L=6e-07
X_tn12 net11 net4 VSS VPW nfet_05v0 W=3.6e-07 L=6e-07
X_tn5 net0 RN VSS VPW nfet_05v0 W=3.6e-07 L=6e-07
X_tn4 net4 net8 net0 VPW nfet_05v0 W=4e-07 L=6e-07
X_tn3 Q net4 VSS VPW nfet_05v0 W=8.15e-07 L=6e-07
X_tp8 ncki CLK VDD VNW pfet_05v0 W=8.65e-07 L=5e-07
X_tp11 cki ncki VDD VNW pfet_05v0 W=8.65e-07 L=5e-07
X_tp9 VDD D net10 VNW pfet_05v0 W=7.8e-07 L=5e-07
X_tp15 net1 cki net10 VNW pfet_05v0 W=7.8e-07 L=5e-07
X_tp7 net9 ncki net1 VNW pfet_05v0 W=7.8e-07 L=5e-07
X_tp6 VDD net2 net9 VNW pfet_05v0 W=7.8e-07 L=5e-07
X_tp12 net9 RN VDD VNW pfet_05v0 W=7.8e-07 L=5e-07
X_tp18 VDD net1 net2 VNW pfet_05v0 W=5.05e-07 L=5e-07
X_tp2 net2 ncki net8 VNW pfet_05v0 W=5.05e-07 L=5e-07
X_tp3 net8 cki net11 VNW pfet_05v0 W=5.05e-07 L=5e-07
X_tp10 net11 net4 VDD VNW pfet_05v0 W=5.05e-07 L=5e-07
X_tp5 net4 RN VDD VNW pfet_05v0 W=1e-06 L=5e-07
X_tp4 VDD net8 net4 VNW pfet_05v0 W=1e-06 L=5e-07
X_tp1 Q net4 VDD VNW pfet_05v0 W=1.215e-06 L=5e-07
.ENDS

.SUBCKT gf180mcu_fd_sc_mcu7t5v0__dffsnq_1 D SETN CLK Q VDD VNW VPW VSS
X_tn3 ncki CLK VSS VPW nfet_05v0 W=4.05e-07 L=6e-07
X_tn0 cki ncki VSS VPW nfet_05v0 W=4.05e-07 L=6e-07
X_tn10 net13 D VSS VPW nfet_05v0 W=3.6e-07 L=6e-07
X_tn6 net13 ncki net3 VPW nfet_05v0 W=3.6e-07 L=6e-07
X_tn4 net3 cki net14 VPW nfet_05v0 W=3.6e-07 L=6e-07
X_tn5 VSS net4 net14 VPW nfet_05v0 W=3.6e-07 L=6e-07
X_tn2 net0 net3 VSS VPW nfet_05v0 W=3.6e-07 L=6e-07
X_tn1 net4 SETN net0 VPW nfet_05v0 W=3.6e-07 L=6e-07
X_tn13 net5 cki net4 VPW nfet_05v0 W=3.6e-07 L=6e-07
X_tn12 net7 ncki net5 VPW nfet_05v0 W=3.6e-07 L=6e-07
X_tn14 net1 SETN net7 VPW nfet_05v0 W=4.05e-07 L=6e-07
X_tn15 VSS net6 net1 VPW nfet_05v0 W=4.05e-07 L=6e-07
X_tn18 net6 net5 VSS VPW nfet_05v0 W=4.05e-07 L=6e-07
X_tn16 VSS net6 Q VPW nfet_05v0 W=8.15e-07 L=6e-07
X_tp4 ncki CLK VDD VNW pfet_05v0 W=8.65e-07 L=5e-07
X_tp0 cki ncki VDD VNW pfet_05v0 W=8.65e-07 L=5e-07
X_tp8 VDD D net13 VNW pfet_05v0 W=5.05e-07 L=5e-07
X_tp9 net3 cki net13 VNW pfet_05v0 W=5.05e-07 L=5e-07
X_tp6 net10 ncki net3 VNW pfet_05v0 W=5.05e-07 L=5e-07
X_tp5 VDD net4 net10 VNW pfet_05v0 W=5.05e-07 L=5e-07
X_tp3 net4 net3 VDD VNW pfet_05v0 W=5.85e-07 L=5e-07
X_tp2 VDD SETN net4 VNW pfet_05v0 W=5.85e-07 L=5e-07
X_tp18 net5 ncki net4 VNW pfet_05v0 W=4.15e-07 L=5e-07
X_tp17 net7 cki net5 VNW pfet_05v0 W=4.15e-07 L=5e-07
X_tp12 net7 SETN VDD VNW pfet_05v0 W=7.8e-07 L=5e-07
X_tp13 VDD net6 net7 VNW pfet_05v0 W=7.8e-07 L=5e-07
X_tp16 net6 net5 VDD VNW pfet_05v0 W=7.8e-07 L=5e-07
X_tp14 VDD net6 Q VNW pfet_05v0 W=1.215e-06 L=5e-07
.ENDS

.SUBCKT gf180mcu_fd_sc_mcu7t5v0__dffrnq_2 D RN CLK Q VDD VNW VPW VSS
X_tn10 ncki CLK VSS VPW nfet_05v0 W=4.05e-07 L=6e-07
X_tn13 cki ncki VSS VPW nfet_05v0 W=4.05e-07 L=6e-07
X_tn11 net10 D VSS VPW nfet_05v0 W=3.6e-07 L=6e-07
X_tn15 net10 ncki net1 VPW nfet_05v0 W=3.6e-07 L=6e-07
X_tn14 net1 cki net15 VPW nfet_05v0 W=3.6e-07 L=6e-07
X_tn8 net12 net2 net15 VPW nfet_05v0 W=3.6e-07 L=6e-07
X_tn9 VSS RN net12 VPW nfet_05v0 W=3.6e-07 L=6e-07
X_tn18 VSS net1 net2 VPW nfet_05v0 W=3.6e-07 L=6e-07
X_tn0 net8 cki net2 VPW nfet_05v0 W=3.6e-07 L=6e-07
X_tn1 net11 ncki net8 VPW nfet_05v0 W=3.6e-07 L=6e-07
X_tn12 net11 net4 VSS VPW nfet_05v0 W=3.6e-07 L=6e-07
X_tn5 net0 RN VSS VPW nfet_05v0 W=3.6e-07 L=6e-07
X_tn4 net4 net8 net0 VPW nfet_05v0 W=8.15e-07 L=6e-07
X_tn3_15 Q net4 VSS VPW nfet_05v0 W=8.15e-07 L=6e-07
X_tn3 Q net4 VSS VPW nfet_05v0 W=8.15e-07 L=6e-07
X_tp8 ncki CLK VDD VNW pfet_05v0 W=8.65e-07 L=5e-07
X_tp11 cki ncki VDD VNW pfet_05v0 W=8.65e-07 L=5e-07
X_tp9 VDD D net10 VNW pfet_05v0 W=7.8e-07 L=5e-07
X_tp15 net1 cki net10 VNW pfet_05v0 W=7.8e-07 L=5e-07
X_tp7 net9 ncki net1 VNW pfet_05v0 W=7.8e-07 L=5e-07
X_tp6 VDD net2 net9 VNW pfet_05v0 W=7.8e-07 L=5e-07
X_tp12 net9 RN VDD VNW pfet_05v0 W=7.8e-07 L=5e-07
X_tp18 VDD net1 net2 VNW pfet_05v0 W=5.05e-07 L=5e-07
X_tp2 net2 ncki net8 VNW pfet_05v0 W=5.05e-07 L=5e-07
X_tp3 net8 cki net11 VNW pfet_05v0 W=5.05e-07 L=5e-07
X_tp10 net11 net4 VDD VNW pfet_05v0 W=5.05e-07 L=5e-07
X_tp5 net4 RN VDD VNW pfet_05v0 W=1.215e-06 L=5e-07
X_tp4 VDD net8 net4 VNW pfet_05v0 W=1.215e-06 L=5e-07
X_tp1_13 Q net4 VDD VNW pfet_05v0 W=1.215e-06 L=5e-07
X_tp1 Q net4 VDD VNW pfet_05v0 W=1.215e-06 L=5e-07
.ENDS

.SUBCKT gf180mcu_fd_sc_mcu7t5v0__dffnrnq_1 D RN CLKN Q VDD VNW VPW VSS
X_tn13 ncki CLKN VSS VPW nfet_05v0 W=4.05e-07 L=6e-07
X_tn10 cki ncki VSS VPW nfet_05v0 W=4.05e-07 L=6e-07
X_tn11 net6 D VSS VPW nfet_05v0 W=3.9e-07 L=6e-07
X_tn15 net6 cki net1 VPW nfet_05v0 W=3.9e-07 L=6e-07
X_tn14 net1 ncki net15 VPW nfet_05v0 W=3.9e-07 L=6e-07
X_tn8 net12 net2 net15 VPW nfet_05v0 W=3.9e-07 L=6e-07
X_tn9 VSS RN net12 VPW nfet_05v0 W=3.9e-07 L=6e-07
X_tn18 VSS net1 net2 VPW nfet_05v0 W=3.9e-07 L=6e-07
X_tn0 net8 ncki net2 VPW nfet_05v0 W=3.9e-07 L=6e-07
X_tn1 net11 cki net8 VPW nfet_05v0 W=3.9e-07 L=6e-07
X_tn12 net11 net4 VSS VPW nfet_05v0 W=3.9e-07 L=6e-07
X_tn5 net0 RN VSS VPW nfet_05v0 W=3.9e-07 L=6e-07
X_tn4 net4 net8 net0 VPW nfet_05v0 W=4e-07 L=6e-07
X_tn3 Q net4 VSS VPW nfet_05v0 W=7.95e-07 L=6e-07
X_tp11 ncki CLKN VDD VNW pfet_05v0 W=8.65e-07 L=5e-07
X_tp8 cki ncki VDD VNW pfet_05v0 W=8.65e-07 L=5e-07
X_tp9 VDD D net6 VNW pfet_05v0 W=7.6e-07 L=5e-07
X_tp15 net1 ncki net6 VNW pfet_05v0 W=7.6e-07 L=5e-07
X_tp7 net9 cki net1 VNW pfet_05v0 W=7.6e-07 L=5e-07
X_tp6 VDD net2 net9 VNW pfet_05v0 W=7.6e-07 L=5e-07
X_tp12 net9 RN VDD VNW pfet_05v0 W=7.6e-07 L=5e-07
X_tp18 VDD net1 net2 VNW pfet_05v0 W=5.05e-07 L=5e-07
X_tp2 net2 cki net8 VNW pfet_05v0 W=5.05e-07 L=5e-07
X_tp3 net8 ncki net11 VNW pfet_05v0 W=5.05e-07 L=5e-07
X_tp10 net11 net4 VDD VNW pfet_05v0 W=5.05e-07 L=5e-07
X_tp5 net4 RN VDD VNW pfet_05v0 W=0.94e-06 L=5e-07
X_tp4 VDD net8 net4 VNW pfet_05v0 W=0.94e-06 L=5e-07
X_tp1 Q net4 VDD VNW pfet_05v0 W=1.175e-06 L=5e-07
.ENDS

.SUBCKT gf180mcu_fd_sc_mcu7t5v0__dffrnq_4 D RN CLK Q VDD VNW VPW VSS
X_tn10 ncki CLK VSS VPW nfet_05v0 W=4.05e-07 L=6e-07
X_tn13 cki ncki VSS VPW nfet_05v0 W=4.05e-07 L=6e-07
X_tn11 net10 D VSS VPW nfet_05v0 W=3.6e-07 L=6e-07
X_tn15 net10 ncki net1 VPW nfet_05v0 W=3.6e-07 L=6e-07
X_tn14 net1 cki net15 VPW nfet_05v0 W=3.6e-07 L=6e-07
X_tn8 net12 net2 net15 VPW nfet_05v0 W=3.6e-07 L=6e-07
X_tn9 VSS RN net12 VPW nfet_05v0 W=3.6e-07 L=6e-07
X_tn18 VSS net1 net2 VPW nfet_05v0 W=3.6e-07 L=6e-07
X_tn0 net8 cki net2 VPW nfet_05v0 W=3.6e-07 L=6e-07
X_tn1 net11 ncki net8 VPW nfet_05v0 W=3.6e-07 L=6e-07
X_tn12 net11 net4 VSS VPW nfet_05v0 W=3.6e-07 L=6e-07
X_tn5 net0 RN VSS VPW nfet_05v0 W=3.6e-07 L=6e-07
X_tn4 net4 net8 net0 VPW nfet_05v0 W=8.15e-07 L=6e-07
X_tn3_15 Q net4 VSS VPW nfet_05v0 W=8.15e-07 L=6e-07
X_tn3 Q net4 VSS VPW nfet_05v0 W=8.15e-07 L=6e-07
X_tn3_15_13 Q net4 VSS VPW nfet_05v0 W=8.15e-07 L=6e-07
X_tn3_10 Q net4 VSS VPW nfet_05v0 W=8.15e-07 L=6e-07
X_tp8 ncki CLK VDD VNW pfet_05v0 W=8.65e-07 L=5e-07
X_tp11 cki ncki VDD VNW pfet_05v0 W=8.65e-07 L=5e-07
X_tp9 VDD D net10 VNW pfet_05v0 W=7.8e-07 L=5e-07
X_tp15 net1 cki net10 VNW pfet_05v0 W=7.8e-07 L=5e-07
X_tp7 net9 ncki net1 VNW pfet_05v0 W=7.8e-07 L=5e-07
X_tp6 VDD net2 net9 VNW pfet_05v0 W=7.8e-07 L=5e-07
X_tp12 net9 RN VDD VNW pfet_05v0 W=7.8e-07 L=5e-07
X_tp18 VDD net1 net2 VNW pfet_05v0 W=5.05e-07 L=5e-07
X_tp2 net2 ncki net8 VNW pfet_05v0 W=5.05e-07 L=5e-07
X_tp3 net8 cki net11 VNW pfet_05v0 W=5.05e-07 L=5e-07
X_tp10 net11 net4 VDD VNW pfet_05v0 W=5.05e-07 L=5e-07
X_tp5 net4 RN VDD VNW pfet_05v0 W=1.215e-06 L=5e-07
X_tp4 VDD net8 net4 VNW pfet_05v0 W=1.215e-06 L=5e-07
X_tp1_13 Q net4 VDD VNW pfet_05v0 W=1.215e-06 L=5e-07
X_tp1 Q net4 VDD VNW pfet_05v0 W=1.215e-06 L=5e-07
X_tp1_13_25 Q net4 VDD VNW pfet_05v0 W=1.215e-06 L=5e-07
X_tp1_30 Q net4 VDD VNW pfet_05v0 W=1.215e-06 L=5e-07
.ENDS

.SUBCKT gf180mcu_fd_sc_mcu7t5v0__clkbuf_4 I Z VDD VNW VPW VSS
X_i_2_1 VSS I Z_neg VPW nfet_05v0 W=6.05e-07 L=6e-07
X_i_0_0 Z Z_neg VSS VPW nfet_05v0 W=4.55e-07 L=6e-07
X_i_0_1 VSS Z_neg Z VPW nfet_05v0 W=4.55e-07 L=6e-07
X_i_0_2 Z Z_neg VSS VPW nfet_05v0 W=4.55e-07 L=6e-07
X_i_0_3 VSS Z_neg Z VPW nfet_05v0 W=4.55e-07 L=6e-07
X_i_3_0 Z_neg I VDD VNW pfet_05v0 W=0.82e-06 L=5e-07
X_i_3_1 VDD I Z_neg VNW pfet_05v0 W=0.82e-06 L=5e-07
X_i_1_0 Z Z_neg VDD VNW pfet_05v0 W=1.22e-06 L=5e-07
X_i_1_1 VDD Z_neg Z VNW pfet_05v0 W=1.22e-06 L=5e-07
X_i_1_2 Z Z_neg VDD VNW pfet_05v0 W=1.22e-06 L=5e-07
X_i_1_3 VDD Z_neg Z VNW pfet_05v0 W=1.22e-06 L=5e-07
.ENDS

.SUBCKT gf180mcu_fd_sc_mcu7t5v0__clkbuf_2 I Z VDD VNW VPW VSS
X_i_2 VSS I Z_neg VPW nfet_05v0 W=3.6e-07 L=6e-07
X_i_0_0 Z Z_neg VSS VPW nfet_05v0 W=4.85e-07 L=6e-07
X_i_0_1 VSS Z_neg Z VPW nfet_05v0 W=4.85e-07 L=6e-07
X_i_3 VDD I Z_neg VNW pfet_05v0 W=1.02e-06 L=5e-07
X_i_1_0 Z Z_neg VDD VNW pfet_05v0 W=1.22e-06 L=5e-07
X_i_1_1 VDD Z_neg Z VNW pfet_05v0 W=1.22e-06 L=5e-07
.ENDS

.SUBCKT gf180mcu_fd_sc_mcu7t5v0__inv_2 I ZN VDD VNW VPW VSS
X_i_0_0 ZN I VSS VPW nfet_05v0 W=8.2e-07 L=6e-07
X_i_0_1 VSS I ZN VPW nfet_05v0 W=8.2e-07 L=6e-07
X_i_1_0 ZN I VDD VNW pfet_05v0 W=1.22e-06 L=5e-07
X_i_1_1 VDD I ZN VNW pfet_05v0 W=1.22e-06 L=5e-07
.ENDS

.SUBCKT gf180mcu_fd_sc_mcu7t5v0__inv_4 I ZN VDD VNW VPW VSS
X_i_0_0 ZN I VSS VPW nfet_05v0 W=8.2e-07 L=6e-07
X_i_0_1 VSS I ZN VPW nfet_05v0 W=8.2e-07 L=6e-07
X_i_0_2 ZN I VSS VPW nfet_05v0 W=8.2e-07 L=6e-07
X_i_0_3 VSS I ZN VPW nfet_05v0 W=8.2e-07 L=6e-07
X_i_1_0 ZN I VDD VNW pfet_05v0 W=1.22e-06 L=5e-07
X_i_1_1 VDD I ZN VNW pfet_05v0 W=1.22e-06 L=5e-07
X_i_1_2 ZN I VDD VNW pfet_05v0 W=1.22e-06 L=5e-07
X_i_1_3 VDD I ZN VNW pfet_05v0 W=1.22e-06 L=5e-07
.ENDS

.SUBCKT gf180mcu_fd_sc_mcu7t5v0__clkinv_8 I ZN VDD VNW VPW VSS
X_i_0_0_x8_0 ZN I VSS VPW nfet_05v0 W=4.8e-07 L=6e-07
X_i_0_0_x8_1 VSS I ZN VPW nfet_05v0 W=4.8e-07 L=6e-07
X_i_0_0_x8_2 ZN I VSS VPW nfet_05v0 W=4.8e-07 L=6e-07
X_i_0_0_x8_3 VSS I ZN VPW nfet_05v0 W=4.8e-07 L=6e-07
X_i_0_0_x8_4 ZN I VSS VPW nfet_05v0 W=4.8e-07 L=6e-07
X_i_0_0_x8_5 VSS I ZN VPW nfet_05v0 W=4.8e-07 L=6e-07
X_i_0_0_x8_6 ZN I VSS VPW nfet_05v0 W=4.8e-07 L=6e-07
X_i_0_0_x8_7 VSS I ZN VPW nfet_05v0 W=4.8e-07 L=6e-07
X_i_1_0_x8_0 ZN I VDD VNW pfet_05v0 W=1.22e-06 L=5e-07
X_i_1_0_x8_1 VDD I ZN VNW pfet_05v0 W=1.22e-06 L=5e-07
X_i_1_0_x8_2 ZN I VDD VNW pfet_05v0 W=1.22e-06 L=5e-07
X_i_1_0_x8_3 VDD I ZN VNW pfet_05v0 W=1.22e-06 L=5e-07
X_i_1_0_x8_4 ZN I VDD VNW pfet_05v0 W=1.22e-06 L=5e-07
X_i_1_0_x8_5 VDD I ZN VNW pfet_05v0 W=1.22e-06 L=5e-07
X_i_1_0_x8_6 ZN I VDD VNW pfet_05v0 W=1.22e-06 L=5e-07
X_i_1_0_x8_7 VDD I ZN VNW pfet_05v0 W=1.22e-06 L=5e-07
.ENDS

.SUBCKT gf180mcu_fd_sc_mcu7t5v0__inv_3 I ZN VDD VNW VPW VSS
X_i_0_0 ZN I VSS VPW nfet_05v0 W=8.2e-07 L=6e-07
X_i_0_1 VSS I ZN VPW nfet_05v0 W=8.2e-07 L=6e-07
X_i_0_2 ZN I VSS VPW nfet_05v0 W=8.2e-07 L=6e-07
X_i_1_0 ZN I VDD VNW pfet_05v0 W=1.22e-06 L=5e-07
X_i_1_1 VDD I ZN VNW pfet_05v0 W=1.22e-06 L=5e-07
X_i_1_2 ZN I VDD VNW pfet_05v0 W=1.22e-06 L=5e-07
.ENDS

.SUBCKT gf180mcu_fd_sc_mcu7t5v0__icgtp_1 CLK E TE Q VDD VNW VPW VSS
X_MU19 net50 TE VSS VPW nfet_05v0 W=3.95e-07 L=6e-07
X_MU20 VSS E net50 VPW nfet_05v0 W=3.95e-07 L=6e-07
X_MU81_M_u2 NCK CLK VSS VPW nfet_05v0 W=3.9e-07 L=6e-07
X_MU75_M_u2 Q d3 VSS VPW nfet_05v0 W=6.3e-07 L=6e-07
X_MI81 VDD TE net58 VNW pfet_05v0 W=9.25e-07 L=5e-07
X_MU17 net58 E net61 VNW pfet_05v0 W=9.25e-07 L=5e-07
X_MU82_M_u3 CK NCK VDD VNW pfet_05v0 W=9.2e-07 L=5e-07
X_MU81_M_u3 VDD CLK NCK VNW pfet_05v0 W=9.2e-07 L=5e-07
X_MI85_M_u1 d3 CLK VDD VNW pfet_05v0 W=9.2e-07 L=5e-07
X_MU75_M_u3 Q d3 VDD VNW pfet_05v0 W=1.22e-06 L=5e-07
X_MI82 net50 NCK net53 VPW nfet_05v0 W=3.95e-07 L=6e-07
X_MI91 net53 CK net033 VPW nfet_05v0 W=3.95e-07 L=6e-07
X_MI92 net033 QD VSS VPW nfet_05v0 W=3.95e-07 L=6e-07
X_MI80_M_u2 VSS net53 QD VPW nfet_05v0 W=3.95e-07 L=6e-07
X_MU82_M_u2 VSS NCK CK VPW nfet_05v0 W=3.9e-07 L=6e-07
X_MI85_M_u3 XI85-net6 CLK d3 VPW nfet_05v0 W=3.9e-07 L=6e-07
X_MI85_M_u4 VSS QD XI85-net6 VPW nfet_05v0 W=3.9e-07 L=6e-07
X_MU16 net61 CK net53 VNW pfet_05v0 W=7.65e-07 L=5e-07
X_MI90 net53 NCK net062 VNW pfet_05v0 W=7.65e-07 L=5e-07
X_MI88 net062 QD VDD VNW pfet_05v0 W=7.65e-07 L=5e-07
X_MI80_M_u3 VDD net53 QD VNW pfet_05v0 W=7.65e-07 L=5e-07
X_MI85_M_u2 VDD QD d3 VNW pfet_05v0 W=9.2e-07 L=5e-07
.ENDS

.SUBCKT gf180mcu_fd_sc_mcu7t5v0__dlyc_1 I Z VDD VNW VPW VSS
X_i_2_0 Z_neg I VSS VPW nfet_05v0 W=3.6e-07 L=6e-07
X_i_2 net_7 Z_neg net_1 VPW nfet_05v0 W=3.6e-07 L=6e-07
X_i_3 net_1 Z_neg VSS VPW nfet_05v0 W=3.6e-07 L=6e-07
X_i_2_26 net_9 net_7 net_13 VPW nfet_05v0 W=3.6e-07 L=6e-07
X_i_3_30 net_13 net_7 VSS VPW nfet_05v0 W=3.6e-07 L=6e-07
X_i_2_0_1 net_8 net_9 net_11 VPW nfet_05v0 W=3.6e-07 L=6e-07
X_i_3_4 net_11 net_9 VSS VPW nfet_05v0 W=3.6e-07 L=6e-07
X_i_2_21 net_3 net_8 net_6 VPW nfet_05v0 W=3.65e-07 L=6e-07
X_i_3_6 net_6 net_8 VSS VPW nfet_05v0 W=3.65e-07 L=6e-07
X_i_2_0_18 Z net_3 VSS VPW nfet_05v0 W=8.2e-07 L=6e-07
X_i_3_0 Z_neg I VDD VNW pfet_05v0 W=3.6e-07 L=5e-07
X_i_0 net_0 Z_neg VDD VNW pfet_05v0 W=3.6e-07 L=5e-07
X_i_1 net_7 Z_neg net_0 VNW pfet_05v0 W=3.6e-07 L=5e-07
X_i_0_35 net_12 net_7 VDD VNW pfet_05v0 W=3.6e-07 L=5e-07
X_i_1_47 net_9 net_7 net_12 VNW pfet_05v0 W=3.6e-07 L=5e-07
X_i_0_9 net_10 net_9 VDD VNW pfet_05v0 W=3.6e-07 L=5e-07
X_i_1_22 net_8 net_9 net_10 VNW pfet_05v0 W=3.6e-07 L=5e-07
X_i_0_29 net_5 net_8 VDD VNW pfet_05v0 W=3.6e-07 L=5e-07
X_i_1_39 net_3 net_8 net_5 VNW pfet_05v0 W=3.6e-07 L=5e-07
X_i_3_0_0 Z net_3 VDD VNW pfet_05v0 W=1.22e-06 L=5e-07
.ENDS

.SUBCKT gf180mcu_fd_sc_mcu7t5v0__buf_1 I Z VDD VNW VPW VSS
X_i_2 VSS I Z_neg VPW nfet_05v0 W=3.6e-07 L=6e-07
X_i_0 Z Z_neg VSS VPW nfet_05v0 W=8.2e-07 L=6e-07
X_i_3 VDD I Z_neg VNW pfet_05v0 W=5.65e-07 L=5e-07
X_i_1 Z Z_neg VDD VNW pfet_05v0 W=1.22e-06 L=5e-07
.ENDS

.SUBCKT gf180mcu_fd_sc_mcu7t5v0__buf_2 I Z VDD VNW VPW VSS
X_i_2 VSS I Z_neg VPW nfet_05v0 W=8.2e-07 L=6e-07
X_i_0_0 Z Z_neg VSS VPW nfet_05v0 W=8.2e-07 L=6e-07
X_i_0_1 VSS Z_neg Z VPW nfet_05v0 W=8.2e-07 L=6e-07
X_i_3 VDD I Z_neg VNW pfet_05v0 W=1.22e-06 L=5e-07
X_i_1_0 Z Z_neg VDD VNW pfet_05v0 W=1.22e-06 L=5e-07
X_i_1_1 VDD Z_neg Z VNW pfet_05v0 W=1.22e-06 L=5e-07
.ENDS

.SUBCKT gf180mcu_fd_sc_mcu7t5v0__buf_12 I Z VDD VNW VPW VSS
X_i_2_0 Z_neg I VSS VPW nfet_05v0 W=8.2e-07 L=6e-07
X_i_2_1 VSS I Z_neg VPW nfet_05v0 W=8.2e-07 L=6e-07
X_i_2_2 Z_neg I VSS VPW nfet_05v0 W=8.2e-07 L=6e-07
X_i_2_3 VSS I Z_neg VPW nfet_05v0 W=8.2e-07 L=6e-07
X_i_2_4 Z_neg I VSS VPW nfet_05v0 W=8.2e-07 L=6e-07
X_i_2_5 VSS I Z_neg VPW nfet_05v0 W=8.2e-07 L=6e-07
X_i_0_0 Z Z_neg VSS VPW nfet_05v0 W=8.2e-07 L=6e-07
X_i_0_1 VSS Z_neg Z VPW nfet_05v0 W=8.2e-07 L=6e-07
X_i_0_2 Z Z_neg VSS VPW nfet_05v0 W=8.2e-07 L=6e-07
X_i_0_3 VSS Z_neg Z VPW nfet_05v0 W=8.2e-07 L=6e-07
X_i_0_4 Z Z_neg VSS VPW nfet_05v0 W=8.2e-07 L=6e-07
X_i_0_5 VSS Z_neg Z VPW nfet_05v0 W=8.2e-07 L=6e-07
X_i_0_6 Z Z_neg VSS VPW nfet_05v0 W=8.2e-07 L=6e-07
X_i_0_7 VSS Z_neg Z VPW nfet_05v0 W=8.2e-07 L=6e-07
X_i_0_8 Z Z_neg VSS VPW nfet_05v0 W=8.2e-07 L=6e-07
X_i_0_9 VSS Z_neg Z VPW nfet_05v0 W=8.2e-07 L=6e-07
X_i_0_10 Z Z_neg VSS VPW nfet_05v0 W=8.2e-07 L=6e-07
X_i_0_11 VSS Z_neg Z VPW nfet_05v0 W=8.2e-07 L=6e-07
X_i_3_0 Z_neg I VDD VNW pfet_05v0 W=1.22e-06 L=5e-07
X_i_3_1 VDD I Z_neg VNW pfet_05v0 W=1.22e-06 L=5e-07
X_i_3_2 Z_neg I VDD VNW pfet_05v0 W=1.22e-06 L=5e-07
X_i_3_3 VDD I Z_neg VNW pfet_05v0 W=1.22e-06 L=5e-07
X_i_3_4 Z_neg I VDD VNW pfet_05v0 W=1.22e-06 L=5e-07
X_i_3_5 VDD I Z_neg VNW pfet_05v0 W=1.22e-06 L=5e-07
X_i_1_0 Z Z_neg VDD VNW pfet_05v0 W=1.22e-06 L=5e-07
X_i_1_1 VDD Z_neg Z VNW pfet_05v0 W=1.22e-06 L=5e-07
X_i_1_2 Z Z_neg VDD VNW pfet_05v0 W=1.22e-06 L=5e-07
X_i_1_3 VDD Z_neg Z VNW pfet_05v0 W=1.22e-06 L=5e-07
X_i_1_4 Z Z_neg VDD VNW pfet_05v0 W=1.22e-06 L=5e-07
X_i_1_5 VDD Z_neg Z VNW pfet_05v0 W=1.22e-06 L=5e-07
X_i_1_6 Z Z_neg VDD VNW pfet_05v0 W=1.22e-06 L=5e-07
X_i_1_7 VDD Z_neg Z VNW pfet_05v0 W=1.22e-06 L=5e-07
X_i_1_8 Z Z_neg VDD VNW pfet_05v0 W=1.22e-06 L=5e-07
X_i_1_9 VDD Z_neg Z VNW pfet_05v0 W=1.22e-06 L=5e-07
X_i_1_10 Z Z_neg VDD VNW pfet_05v0 W=1.22e-06 L=5e-07
X_i_1_11 VDD Z_neg Z VNW pfet_05v0 W=1.22e-06 L=5e-07
.ENDS

.SUBCKT gf180mcu_fd_sc_mcu7t5v0__buf_16 I Z VDD VNW VPW VSS
X_i_2_0 Z_neg I VSS VPW nfet_05v0 W=8.2e-07 L=6e-07
X_i_2_1 VSS I Z_neg VPW nfet_05v0 W=8.2e-07 L=6e-07
X_i_2_2 Z_neg I VSS VPW nfet_05v0 W=8.2e-07 L=6e-07
X_i_2_3 VSS I Z_neg VPW nfet_05v0 W=8.2e-07 L=6e-07
X_i_2_4 Z_neg I VSS VPW nfet_05v0 W=8.2e-07 L=6e-07
X_i_2_5 VSS I Z_neg VPW nfet_05v0 W=8.2e-07 L=6e-07
X_i_2_6 Z_neg I VSS VPW nfet_05v0 W=8.2e-07 L=6e-07
X_i_2_7 VSS I Z_neg VPW nfet_05v0 W=8.2e-07 L=6e-07
X_i_0_0 Z Z_neg VSS VPW nfet_05v0 W=8.2e-07 L=6e-07
X_i_0_1 VSS Z_neg Z VPW nfet_05v0 W=8.2e-07 L=6e-07
X_i_0_2 Z Z_neg VSS VPW nfet_05v0 W=8.2e-07 L=6e-07
X_i_0_3 VSS Z_neg Z VPW nfet_05v0 W=8.2e-07 L=6e-07
X_i_0_4 Z Z_neg VSS VPW nfet_05v0 W=8.2e-07 L=6e-07
X_i_0_5 VSS Z_neg Z VPW nfet_05v0 W=8.2e-07 L=6e-07
X_i_0_6 Z Z_neg VSS VPW nfet_05v0 W=8.2e-07 L=6e-07
X_i_0_7 VSS Z_neg Z VPW nfet_05v0 W=8.2e-07 L=6e-07
X_i_0_8 Z Z_neg VSS VPW nfet_05v0 W=8.2e-07 L=6e-07
X_i_0_9 VSS Z_neg Z VPW nfet_05v0 W=8.2e-07 L=6e-07
X_i_0_10 Z Z_neg VSS VPW nfet_05v0 W=8.2e-07 L=6e-07
X_i_0_11 VSS Z_neg Z VPW nfet_05v0 W=8.2e-07 L=6e-07
X_i_0_12 Z Z_neg VSS VPW nfet_05v0 W=8.2e-07 L=6e-07
X_i_0_13 VSS Z_neg Z VPW nfet_05v0 W=8.2e-07 L=6e-07
X_i_0_14 Z Z_neg VSS VPW nfet_05v0 W=8.2e-07 L=6e-07
X_i_0_15 VSS Z_neg Z VPW nfet_05v0 W=8.2e-07 L=6e-07
X_i_3_0 Z_neg I VDD VNW pfet_05v0 W=1.22e-06 L=5e-07
X_i_3_1 VDD I Z_neg VNW pfet_05v0 W=1.22e-06 L=5e-07
X_i_3_2 Z_neg I VDD VNW pfet_05v0 W=1.22e-06 L=5e-07
X_i_3_3 VDD I Z_neg VNW pfet_05v0 W=1.22e-06 L=5e-07
X_i_3_4 Z_neg I VDD VNW pfet_05v0 W=1.22e-06 L=5e-07
X_i_3_5 VDD I Z_neg VNW pfet_05v0 W=1.22e-06 L=5e-07
X_i_3_6 Z_neg I VDD VNW pfet_05v0 W=1.22e-06 L=5e-07
X_i_3_7 VDD I Z_neg VNW pfet_05v0 W=1.22e-06 L=5e-07
X_i_1_0 Z Z_neg VDD VNW pfet_05v0 W=1.22e-06 L=5e-07
X_i_1_1 VDD Z_neg Z VNW pfet_05v0 W=1.22e-06 L=5e-07
X_i_1_2 Z Z_neg VDD VNW pfet_05v0 W=1.22e-06 L=5e-07
X_i_1_3 VDD Z_neg Z VNW pfet_05v0 W=1.22e-06 L=5e-07
X_i_1_4 Z Z_neg VDD VNW pfet_05v0 W=1.22e-06 L=5e-07
X_i_1_5 VDD Z_neg Z VNW pfet_05v0 W=1.22e-06 L=5e-07
X_i_1_6 Z Z_neg VDD VNW pfet_05v0 W=1.22e-06 L=5e-07
X_i_1_7 VDD Z_neg Z VNW pfet_05v0 W=1.22e-06 L=5e-07
X_i_1_8 Z Z_neg VDD VNW pfet_05v0 W=1.22e-06 L=5e-07
X_i_1_9 VDD Z_neg Z VNW pfet_05v0 W=1.22e-06 L=5e-07
X_i_1_10 Z Z_neg VDD VNW pfet_05v0 W=1.22e-06 L=5e-07
X_i_1_11 VDD Z_neg Z VNW pfet_05v0 W=1.22e-06 L=5e-07
X_i_1_12 Z Z_neg VDD VNW pfet_05v0 W=1.22e-06 L=5e-07
X_i_1_13 VDD Z_neg Z VNW pfet_05v0 W=1.22e-06 L=5e-07
X_i_1_14 Z Z_neg VDD VNW pfet_05v0 W=1.22e-06 L=5e-07
X_i_1_15 VDD Z_neg Z VNW pfet_05v0 W=1.22e-06 L=5e-07
.ENDS

.SUBCKT gf180mcu_fd_sc_mcu7t5v0__clkbuf_3 I Z VDD VNW VPW VSS
X_i_2_1 VSS I Z_neg VPW nfet_05v0 W=6.05e-07 L=6e-07
X_i_0_0 Z Z_neg VSS VPW nfet_05v0 W=4.55e-07 L=6e-07
X_i_0_1 VSS Z_neg Z VPW nfet_05v0 W=4.55e-07 L=6e-07
X_i_0_2 Z Z_neg VSS VPW nfet_05v0 W=4.55e-07 L=6e-07
X_i_0_3 VSS Z_neg Z VPW nfet_05v0 W=4.55e-07 L=6e-07
X_i_3_0 Z_neg I VDD VNW pfet_05v0 W=0.82e-06 L=5e-07
X_i_3_1 VDD I Z_neg VNW pfet_05v0 W=0.82e-06 L=5e-07
X_i_1_0 Z Z_neg VDD VNW pfet_05v0 W=12.2e-07 L=5e-07
X_i_1_1 VDD Z_neg Z VNW pfet_05v0 W=12.2e-07 L=5e-07
X_i_1_2 Z Z_neg VDD VNW pfet_05v0 W=12.2e-07 L=5e-07
X_i_1_3 VDD Z_neg Z VNW pfet_05v0 W=12.2e-07 L=5e-07
.ENDS

.SUBCKT gf180mcu_fd_sc_mcu7t5v0__buf_8 I Z VDD VNW VPW VSS
X_i_2_0 Z_neg I VSS VPW nfet_05v0 W=8.2e-07 L=6e-07
X_i_2_1 VSS I Z_neg VPW nfet_05v0 W=8.2e-07 L=6e-07
X_i_2_2 Z_neg I VSS VPW nfet_05v0 W=8.2e-07 L=6e-07
X_i_2_3 VSS I Z_neg VPW nfet_05v0 W=8.2e-07 L=6e-07
X_i_0_0 Z Z_neg VSS VPW nfet_05v0 W=8.2e-07 L=6e-07
X_i_0_1 VSS Z_neg Z VPW nfet_05v0 W=8.2e-07 L=6e-07
X_i_0_2 Z Z_neg VSS VPW nfet_05v0 W=8.2e-07 L=6e-07
X_i_0_3 VSS Z_neg Z VPW nfet_05v0 W=8.2e-07 L=6e-07
X_i_0_4 Z Z_neg VSS VPW nfet_05v0 W=8.2e-07 L=6e-07
X_i_0_5 VSS Z_neg Z VPW nfet_05v0 W=8.2e-07 L=6e-07
X_i_0_6 Z Z_neg VSS VPW nfet_05v0 W=8.2e-07 L=6e-07
X_i_0_7 VSS Z_neg Z VPW nfet_05v0 W=8.2e-07 L=6e-07
X_i_3_0 Z_neg I VDD VNW pfet_05v0 W=1.22e-06 L=5e-07
X_i_3_1 VDD I Z_neg VNW pfet_05v0 W=1.22e-06 L=5e-07
X_i_3_2 Z_neg I VDD VNW pfet_05v0 W=1.22e-06 L=5e-07
X_i_3_3 VDD I Z_neg VNW pfet_05v0 W=1.22e-06 L=5e-07
X_i_1_0 Z Z_neg VDD VNW pfet_05v0 W=1.22e-06 L=5e-07
X_i_1_1 VDD Z_neg Z VNW pfet_05v0 W=1.22e-06 L=5e-07
X_i_1_2 Z Z_neg VDD VNW pfet_05v0 W=1.22e-06 L=5e-07
X_i_1_3 VDD Z_neg Z VNW pfet_05v0 W=1.22e-06 L=5e-07
X_i_1_4 Z Z_neg VDD VNW pfet_05v0 W=1.22e-06 L=5e-07
X_i_1_5 VDD Z_neg Z VNW pfet_05v0 W=1.22e-06 L=5e-07
X_i_1_6 Z Z_neg VDD VNW pfet_05v0 W=1.22e-06 L=5e-07
X_i_1_7 VDD Z_neg Z VNW pfet_05v0 W=1.22e-06 L=5e-07
.ENDS

.end
